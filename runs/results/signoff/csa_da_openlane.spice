* NGSPICE file created from csa_da_openlane.ext - technology: sky130A

* Black-box entry subcircuit for sky130_fd_sc_hd__nand2_1 abstract view
.subckt sky130_fd_sc_hd__nand2_1 A B VGND VNB VPB VPWR Y
.ends

* Black-box entry subcircuit for sky130_fd_sc_hd__a21o_1 abstract view
.subckt sky130_fd_sc_hd__a21o_1 A1 A2 B1 VGND VNB VPB VPWR X
.ends

* Black-box entry subcircuit for sky130_fd_sc_hd__decap_6 abstract view
.subckt sky130_fd_sc_hd__decap_6 VGND VNB VPB VPWR
.ends

* Black-box entry subcircuit for sky130_fd_sc_hd__o21ai_1 abstract view
.subckt sky130_fd_sc_hd__o21ai_1 A1 A2 B1 VGND VNB VPB VPWR Y
.ends

* Black-box entry subcircuit for sky130_fd_sc_hd__decap_8 abstract view
.subckt sky130_fd_sc_hd__decap_8 VGND VNB VPB VPWR
.ends

* Black-box entry subcircuit for sky130_fd_sc_hd__nor2_1 abstract view
.subckt sky130_fd_sc_hd__nor2_1 A B VGND VNB VPB VPWR Y
.ends

* Black-box entry subcircuit for sky130_ef_sc_hd__decap_12 abstract view
.subckt sky130_ef_sc_hd__decap_12 VPWR VGND VPB VNB
.ends

* Black-box entry subcircuit for sky130_fd_sc_hd__fill_1 abstract view
.subckt sky130_fd_sc_hd__fill_1 VGND VNB VPB VPWR
.ends

* Black-box entry subcircuit for sky130_fd_sc_hd__o21ai_2 abstract view
.subckt sky130_fd_sc_hd__o21ai_2 A1 A2 B1 VGND VNB VPB VPWR Y
.ends

* Black-box entry subcircuit for sky130_fd_sc_hd__decap_4 abstract view
.subckt sky130_fd_sc_hd__decap_4 VGND VNB VPB VPWR
.ends

* Black-box entry subcircuit for sky130_fd_sc_hd__dfrtp_1 abstract view
.subckt sky130_fd_sc_hd__dfrtp_1 CLK D RESET_B VGND VNB VPB VPWR Q
.ends

* Black-box entry subcircuit for sky130_fd_sc_hd__nand3b_2 abstract view
.subckt sky130_fd_sc_hd__nand3b_2 A_N B C VGND VNB VPB VPWR Y
.ends

* Black-box entry subcircuit for sky130_fd_sc_hd__and3b_1 abstract view
.subckt sky130_fd_sc_hd__and3b_1 A_N B C VGND VNB VPB VPWR X
.ends

* Black-box entry subcircuit for sky130_fd_sc_hd__o21bai_2 abstract view
.subckt sky130_fd_sc_hd__o21bai_2 A1 A2 B1_N VGND VNB VPB VPWR Y
.ends

* Black-box entry subcircuit for sky130_fd_sc_hd__nand2_2 abstract view
.subckt sky130_fd_sc_hd__nand2_2 A B VGND VNB VPB VPWR Y
.ends

* Black-box entry subcircuit for sky130_fd_sc_hd__dlygate4sd3_1 abstract view
.subckt sky130_fd_sc_hd__dlygate4sd3_1 A VGND VNB VPB VPWR X
.ends

* Black-box entry subcircuit for sky130_fd_sc_hd__inv_2 abstract view
.subckt sky130_fd_sc_hd__inv_2 A VGND VNB VPB VPWR Y
.ends

* Black-box entry subcircuit for sky130_fd_sc_hd__tapvpwrvgnd_1 abstract view
.subckt sky130_fd_sc_hd__tapvpwrvgnd_1 VGND VPWR
.ends

* Black-box entry subcircuit for sky130_fd_sc_hd__fill_2 abstract view
.subckt sky130_fd_sc_hd__fill_2 VGND VNB VPB VPWR
.ends

* Black-box entry subcircuit for sky130_fd_sc_hd__nand3_1 abstract view
.subckt sky130_fd_sc_hd__nand3_1 A B C VGND VNB VPB VPWR Y
.ends

* Black-box entry subcircuit for sky130_fd_sc_hd__a31oi_1 abstract view
.subckt sky130_fd_sc_hd__a31oi_1 A1 A2 A3 B1 VGND VNB VPB VPWR Y
.ends

* Black-box entry subcircuit for sky130_fd_sc_hd__nand3_2 abstract view
.subckt sky130_fd_sc_hd__nand3_2 A B C VGND VNB VPB VPWR Y
.ends

* Black-box entry subcircuit for sky130_fd_sc_hd__o211a_1 abstract view
.subckt sky130_fd_sc_hd__o211a_1 A1 A2 B1 C1 VGND VNB VPB VPWR X
.ends

* Black-box entry subcircuit for sky130_fd_sc_hd__or2_1 abstract view
.subckt sky130_fd_sc_hd__or2_1 A B VGND VNB VPB VPWR X
.ends

* Black-box entry subcircuit for sky130_fd_sc_hd__o21ai_4 abstract view
.subckt sky130_fd_sc_hd__o21ai_4 A1 A2 B1 VGND VNB VPB VPWR Y
.ends

* Black-box entry subcircuit for sky130_fd_sc_hd__a211o_1 abstract view
.subckt sky130_fd_sc_hd__a211o_1 A1 A2 B1 C1 VGND VNB VPB VPWR X
.ends

* Black-box entry subcircuit for sky130_fd_sc_hd__o21bai_4 abstract view
.subckt sky130_fd_sc_hd__o21bai_4 A1 A2 B1_N VGND VNB VPB VPWR Y
.ends

* Black-box entry subcircuit for sky130_fd_sc_hd__a31o_1 abstract view
.subckt sky130_fd_sc_hd__a31o_1 A1 A2 A3 B1 VGND VNB VPB VPWR X
.ends

* Black-box entry subcircuit for sky130_fd_sc_hd__clkdlybuf4s25_1 abstract view
.subckt sky130_fd_sc_hd__clkdlybuf4s25_1 A VGND VNB VPB VPWR X
.ends

* Black-box entry subcircuit for sky130_fd_sc_hd__decap_3 abstract view
.subckt sky130_fd_sc_hd__decap_3 VGND VNB VPB VPWR
.ends

* Black-box entry subcircuit for sky130_fd_sc_hd__clkbuf_4 abstract view
.subckt sky130_fd_sc_hd__clkbuf_4 A VGND VNB VPB VPWR X
.ends

* Black-box entry subcircuit for sky130_fd_sc_hd__dfrtp_4 abstract view
.subckt sky130_fd_sc_hd__dfrtp_4 CLK D RESET_B VGND VNB VPB VPWR Q
.ends

* Black-box entry subcircuit for sky130_fd_sc_hd__o21a_1 abstract view
.subckt sky130_fd_sc_hd__o21a_1 A1 A2 B1 VGND VNB VPB VPWR X
.ends

* Black-box entry subcircuit for sky130_fd_sc_hd__and3_1 abstract view
.subckt sky130_fd_sc_hd__and3_1 A B C VGND VNB VPB VPWR X
.ends

* Black-box entry subcircuit for sky130_fd_sc_hd__or3_1 abstract view
.subckt sky130_fd_sc_hd__or3_1 A B C VGND VNB VPB VPWR X
.ends

* Black-box entry subcircuit for sky130_fd_sc_hd__a21oi_2 abstract view
.subckt sky130_fd_sc_hd__a21oi_2 A1 A2 B1 VGND VNB VPB VPWR Y
.ends

* Black-box entry subcircuit for sky130_fd_sc_hd__a21oi_1 abstract view
.subckt sky130_fd_sc_hd__a21oi_1 A1 A2 B1 VGND VNB VPB VPWR Y
.ends

* Black-box entry subcircuit for sky130_fd_sc_hd__o221ai_4 abstract view
.subckt sky130_fd_sc_hd__o221ai_4 A1 A2 B1 B2 C1 VGND VNB VPB VPWR Y
.ends

* Black-box entry subcircuit for sky130_fd_sc_hd__and2_2 abstract view
.subckt sky130_fd_sc_hd__and2_2 A B VGND VNB VPB VPWR X
.ends

* Black-box entry subcircuit for sky130_fd_sc_hd__xor2_1 abstract view
.subckt sky130_fd_sc_hd__xor2_1 A B VGND VNB VPB VPWR X
.ends

* Black-box entry subcircuit for sky130_fd_sc_hd__o211ai_4 abstract view
.subckt sky130_fd_sc_hd__o211ai_4 A1 A2 B1 C1 VGND VNB VPB VPWR Y
.ends

* Black-box entry subcircuit for sky130_fd_sc_hd__dfrtp_2 abstract view
.subckt sky130_fd_sc_hd__dfrtp_2 CLK D RESET_B VGND VNB VPB VPWR Q
.ends

* Black-box entry subcircuit for sky130_fd_sc_hd__xnor2_1 abstract view
.subckt sky130_fd_sc_hd__xnor2_1 A B VGND VNB VPB VPWR Y
.ends

* Black-box entry subcircuit for sky130_fd_sc_hd__buf_8 abstract view
.subckt sky130_fd_sc_hd__buf_8 A VGND VNB VPB VPWR X
.ends

* Black-box entry subcircuit for sky130_fd_sc_hd__o22ai_2 abstract view
.subckt sky130_fd_sc_hd__o22ai_2 A1 A2 B1 B2 VGND VNB VPB VPWR Y
.ends

* Black-box entry subcircuit for sky130_fd_sc_hd__nor2_2 abstract view
.subckt sky130_fd_sc_hd__nor2_2 A B VGND VNB VPB VPWR Y
.ends

* Black-box entry subcircuit for sky130_fd_sc_hd__o2bb2ai_2 abstract view
.subckt sky130_fd_sc_hd__o2bb2ai_2 A1_N A2_N B1 B2 VGND VNB VPB VPWR Y
.ends

* Black-box entry subcircuit for sky130_fd_sc_hd__o22a_2 abstract view
.subckt sky130_fd_sc_hd__o22a_2 A1 A2 B1 B2 VGND VNB VPB VPWR X
.ends

* Black-box entry subcircuit for sky130_fd_sc_hd__a21bo_1 abstract view
.subckt sky130_fd_sc_hd__a21bo_1 A1 A2 B1_N VGND VNB VPB VPWR X
.ends

* Black-box entry subcircuit for sky130_fd_sc_hd__o211ai_2 abstract view
.subckt sky130_fd_sc_hd__o211ai_2 A1 A2 B1 C1 VGND VNB VPB VPWR Y
.ends

* Black-box entry subcircuit for sky130_fd_sc_hd__o211a_2 abstract view
.subckt sky130_fd_sc_hd__o211a_2 A1 A2 B1 C1 VGND VNB VPB VPWR X
.ends

* Black-box entry subcircuit for sky130_fd_sc_hd__buf_1 abstract view
.subckt sky130_fd_sc_hd__buf_1 A VGND VNB VPB VPWR X
.ends

* Black-box entry subcircuit for sky130_fd_sc_hd__nand3_4 abstract view
.subckt sky130_fd_sc_hd__nand3_4 A B C VGND VNB VPB VPWR Y
.ends

* Black-box entry subcircuit for sky130_fd_sc_hd__o22ai_4 abstract view
.subckt sky130_fd_sc_hd__o22ai_4 A1 A2 B1 B2 VGND VNB VPB VPWR Y
.ends

* Black-box entry subcircuit for sky130_fd_sc_hd__nand3b_1 abstract view
.subckt sky130_fd_sc_hd__nand3b_1 A_N B C VGND VNB VPB VPWR Y
.ends

* Black-box entry subcircuit for sky130_fd_sc_hd__buf_4 abstract view
.subckt sky130_fd_sc_hd__buf_4 A VGND VNB VPB VPWR X
.ends

* Black-box entry subcircuit for sky130_fd_sc_hd__a21oi_4 abstract view
.subckt sky130_fd_sc_hd__a21oi_4 A1 A2 B1 VGND VNB VPB VPWR Y
.ends

* Black-box entry subcircuit for sky130_fd_sc_hd__a22oi_4 abstract view
.subckt sky130_fd_sc_hd__a22oi_4 A1 A2 B1 B2 VGND VNB VPB VPWR Y
.ends

* Black-box entry subcircuit for sky130_fd_sc_hd__o31a_1 abstract view
.subckt sky130_fd_sc_hd__o31a_1 A1 A2 A3 B1 VGND VNB VPB VPWR X
.ends

* Black-box entry subcircuit for sky130_fd_sc_hd__and2_1 abstract view
.subckt sky130_fd_sc_hd__and2_1 A B VGND VNB VPB VPWR X
.ends

* Black-box entry subcircuit for sky130_fd_sc_hd__a21boi_2 abstract view
.subckt sky130_fd_sc_hd__a21boi_2 A1 A2 B1_N VGND VNB VPB VPWR Y
.ends

* Black-box entry subcircuit for sky130_fd_sc_hd__or3b_2 abstract view
.subckt sky130_fd_sc_hd__or3b_2 A B C_N VGND VNB VPB VPWR X
.ends

* Black-box entry subcircuit for sky130_fd_sc_hd__or2_2 abstract view
.subckt sky130_fd_sc_hd__or2_2 A B VGND VNB VPB VPWR X
.ends

* Black-box entry subcircuit for sky130_fd_sc_hd__clkbuf_16 abstract view
.subckt sky130_fd_sc_hd__clkbuf_16 A VGND VNB VPB VPWR X
.ends

* Black-box entry subcircuit for sky130_fd_sc_hd__o211ai_1 abstract view
.subckt sky130_fd_sc_hd__o211ai_1 A1 A2 B1 C1 VGND VNB VPB VPWR Y
.ends

* Black-box entry subcircuit for sky130_fd_sc_hd__o21ba_1 abstract view
.subckt sky130_fd_sc_hd__o21ba_1 A1 A2 B1_N VGND VNB VPB VPWR X
.ends

* Black-box entry subcircuit for sky130_fd_sc_hd__or2b_1 abstract view
.subckt sky130_fd_sc_hd__or2b_1 A B_N VGND VNB VPB VPWR X
.ends

* Black-box entry subcircuit for sky130_fd_sc_hd__a32oi_4 abstract view
.subckt sky130_fd_sc_hd__a32oi_4 A1 A2 A3 B1 B2 VGND VNB VPB VPWR Y
.ends

* Black-box entry subcircuit for sky130_fd_sc_hd__a221oi_2 abstract view
.subckt sky130_fd_sc_hd__a221oi_2 A1 A2 B1 B2 C1 VGND VNB VPB VPWR Y
.ends

* Black-box entry subcircuit for sky130_fd_sc_hd__and2b_1 abstract view
.subckt sky130_fd_sc_hd__and2b_1 A_N B VGND VNB VPB VPWR X
.ends

* Black-box entry subcircuit for sky130_fd_sc_hd__o221a_2 abstract view
.subckt sky130_fd_sc_hd__o221a_2 A1 A2 B1 B2 C1 VGND VNB VPB VPWR X
.ends

* Black-box entry subcircuit for sky130_fd_sc_hd__a22o_1 abstract view
.subckt sky130_fd_sc_hd__a22o_1 A1 A2 B1 B2 VGND VNB VPB VPWR X
.ends

* Black-box entry subcircuit for sky130_fd_sc_hd__nand2_4 abstract view
.subckt sky130_fd_sc_hd__nand2_4 A B VGND VNB VPB VPWR Y
.ends

* Black-box entry subcircuit for sky130_fd_sc_hd__o21bai_1 abstract view
.subckt sky130_fd_sc_hd__o21bai_1 A1 A2 B1_N VGND VNB VPB VPWR Y
.ends

* Black-box entry subcircuit for sky130_fd_sc_hd__clkbuf_2 abstract view
.subckt sky130_fd_sc_hd__clkbuf_2 A VGND VNB VPB VPWR X
.ends

* Black-box entry subcircuit for sky130_fd_sc_hd__a21bo_2 abstract view
.subckt sky130_fd_sc_hd__a21bo_2 A1 A2 B1_N VGND VNB VPB VPWR X
.ends

* Black-box entry subcircuit for sky130_fd_sc_hd__o2111ai_2 abstract view
.subckt sky130_fd_sc_hd__o2111ai_2 A1 A2 B1 C1 D1 VGND VNB VPB VPWR Y
.ends

* Black-box entry subcircuit for sky130_fd_sc_hd__a221oi_1 abstract view
.subckt sky130_fd_sc_hd__a221oi_1 A1 A2 B1 B2 C1 VGND VNB VPB VPWR Y
.ends

* Black-box entry subcircuit for sky130_fd_sc_hd__o2bb2ai_1 abstract view
.subckt sky130_fd_sc_hd__o2bb2ai_1 A1_N A2_N B1 B2 VGND VNB VPB VPWR Y
.ends

* Black-box entry subcircuit for sky130_fd_sc_hd__a21boi_1 abstract view
.subckt sky130_fd_sc_hd__a21boi_1 A1 A2 B1_N VGND VNB VPB VPWR Y
.ends

* Black-box entry subcircuit for sky130_fd_sc_hd__nor3_1 abstract view
.subckt sky130_fd_sc_hd__nor3_1 A B C VGND VNB VPB VPWR Y
.ends

* Black-box entry subcircuit for sky130_fd_sc_hd__o2111ai_4 abstract view
.subckt sky130_fd_sc_hd__o2111ai_4 A1 A2 B1 C1 D1 VGND VNB VPB VPWR Y
.ends

* Black-box entry subcircuit for sky130_fd_sc_hd__a221o_1 abstract view
.subckt sky130_fd_sc_hd__a221o_1 A1 A2 B1 B2 C1 VGND VNB VPB VPWR X
.ends

* Black-box entry subcircuit for sky130_fd_sc_hd__xor2_2 abstract view
.subckt sky130_fd_sc_hd__xor2_2 A B VGND VNB VPB VPWR X
.ends

* Black-box entry subcircuit for sky130_fd_sc_hd__o2111a_1 abstract view
.subckt sky130_fd_sc_hd__o2111a_1 A1 A2 B1 C1 D1 VGND VNB VPB VPWR X
.ends

* Black-box entry subcircuit for sky130_fd_sc_hd__a2bb2o_1 abstract view
.subckt sky130_fd_sc_hd__a2bb2o_1 A1_N A2_N B1 B2 VGND VNB VPB VPWR X
.ends

* Black-box entry subcircuit for sky130_fd_sc_hd__a32o_1 abstract view
.subckt sky130_fd_sc_hd__a32o_1 A1 A2 A3 B1 B2 VGND VNB VPB VPWR X
.ends

* Black-box entry subcircuit for sky130_fd_sc_hd__clkbuf_1 abstract view
.subckt sky130_fd_sc_hd__clkbuf_1 A VGND VNB VPB VPWR X
.ends

* Black-box entry subcircuit for sky130_fd_sc_hd__o22a_1 abstract view
.subckt sky130_fd_sc_hd__o22a_1 A1 A2 B1 B2 VGND VNB VPB VPWR X
.ends

* Black-box entry subcircuit for sky130_fd_sc_hd__or4_2 abstract view
.subckt sky130_fd_sc_hd__or4_2 A B C D VGND VNB VPB VPWR X
.ends

* Black-box entry subcircuit for sky130_fd_sc_hd__o31ai_4 abstract view
.subckt sky130_fd_sc_hd__o31ai_4 A1 A2 A3 B1 VGND VNB VPB VPWR Y
.ends

* Black-box entry subcircuit for sky130_fd_sc_hd__and3_2 abstract view
.subckt sky130_fd_sc_hd__and3_2 A B C VGND VNB VPB VPWR X
.ends

* Black-box entry subcircuit for sky130_fd_sc_hd__a21o_2 abstract view
.subckt sky130_fd_sc_hd__a21o_2 A1 A2 B1 VGND VNB VPB VPWR X
.ends

* Black-box entry subcircuit for sky130_fd_sc_hd__a41oi_4 abstract view
.subckt sky130_fd_sc_hd__a41oi_4 A1 A2 A3 A4 B1 VGND VNB VPB VPWR Y
.ends

* Black-box entry subcircuit for sky130_fd_sc_hd__o221a_1 abstract view
.subckt sky130_fd_sc_hd__o221a_1 A1 A2 B1 B2 C1 VGND VNB VPB VPWR X
.ends

* Black-box entry subcircuit for sky130_fd_sc_hd__nand3b_4 abstract view
.subckt sky130_fd_sc_hd__nand3b_4 A_N B C VGND VNB VPB VPWR Y
.ends

* Black-box entry subcircuit for sky130_fd_sc_hd__a211oi_1 abstract view
.subckt sky130_fd_sc_hd__a211oi_1 A1 A2 B1 C1 VGND VNB VPB VPWR Y
.ends

* Black-box entry subcircuit for sky130_fd_sc_hd__o21a_2 abstract view
.subckt sky130_fd_sc_hd__o21a_2 A1 A2 B1 VGND VNB VPB VPWR X
.ends

* Black-box entry subcircuit for sky130_fd_sc_hd__and4bb_1 abstract view
.subckt sky130_fd_sc_hd__and4bb_1 A_N B_N C D VGND VNB VPB VPWR X
.ends

* Black-box entry subcircuit for sky130_fd_sc_hd__or3b_1 abstract view
.subckt sky130_fd_sc_hd__or3b_1 A B C_N VGND VNB VPB VPWR X
.ends

* Black-box entry subcircuit for sky130_fd_sc_hd__buf_2 abstract view
.subckt sky130_fd_sc_hd__buf_2 A VGND VNB VPB VPWR X
.ends

* Black-box entry subcircuit for sky130_fd_sc_hd__nand4_1 abstract view
.subckt sky130_fd_sc_hd__nand4_1 A B C D VGND VNB VPB VPWR Y
.ends

* Black-box entry subcircuit for sky130_fd_sc_hd__and4_1 abstract view
.subckt sky130_fd_sc_hd__and4_1 A B C D VGND VNB VPB VPWR X
.ends

* Black-box entry subcircuit for sky130_fd_sc_hd__a31o_2 abstract view
.subckt sky130_fd_sc_hd__a31o_2 A1 A2 A3 B1 VGND VNB VPB VPWR X
.ends

* Black-box entry subcircuit for sky130_fd_sc_hd__a31oi_4 abstract view
.subckt sky130_fd_sc_hd__a31oi_4 A1 A2 A3 B1 VGND VNB VPB VPWR Y
.ends

* Black-box entry subcircuit for sky130_fd_sc_hd__a21boi_4 abstract view
.subckt sky130_fd_sc_hd__a21boi_4 A1 A2 B1_N VGND VNB VPB VPWR Y
.ends

* Black-box entry subcircuit for sky130_fd_sc_hd__a32oi_2 abstract view
.subckt sky130_fd_sc_hd__a32oi_2 A1 A2 A3 B1 B2 VGND VNB VPB VPWR Y
.ends

* Black-box entry subcircuit for sky130_fd_sc_hd__a22oi_2 abstract view
.subckt sky130_fd_sc_hd__a22oi_2 A1 A2 B1 B2 VGND VNB VPB VPWR Y
.ends

* Black-box entry subcircuit for sky130_fd_sc_hd__nor3b_1 abstract view
.subckt sky130_fd_sc_hd__nor3b_1 A B C_N VGND VNB VPB VPWR Y
.ends

* Black-box entry subcircuit for sky130_fd_sc_hd__o2bb2ai_4 abstract view
.subckt sky130_fd_sc_hd__o2bb2ai_4 A1_N A2_N B1 B2 VGND VNB VPB VPWR Y
.ends

* Black-box entry subcircuit for sky130_fd_sc_hd__clkbuf_8 abstract view
.subckt sky130_fd_sc_hd__clkbuf_8 A VGND VNB VPB VPWR X
.ends

* Black-box entry subcircuit for sky130_fd_sc_hd__o32a_2 abstract view
.subckt sky130_fd_sc_hd__o32a_2 A1 A2 A3 B1 B2 VGND VNB VPB VPWR X
.ends

* Black-box entry subcircuit for sky130_fd_sc_hd__o311a_1 abstract view
.subckt sky130_fd_sc_hd__o311a_1 A1 A2 A3 B1 C1 VGND VNB VPB VPWR X
.ends

* Black-box entry subcircuit for sky130_fd_sc_hd__nand4_4 abstract view
.subckt sky130_fd_sc_hd__nand4_4 A B C D VGND VNB VPB VPWR Y
.ends

* Black-box entry subcircuit for sky130_fd_sc_hd__and3b_2 abstract view
.subckt sky130_fd_sc_hd__and3b_2 A_N B C VGND VNB VPB VPWR X
.ends

* Black-box entry subcircuit for sky130_fd_sc_hd__o211a_4 abstract view
.subckt sky130_fd_sc_hd__o211a_4 A1 A2 B1 C1 VGND VNB VPB VPWR X
.ends

* Black-box entry subcircuit for sky130_fd_sc_hd__and2_4 abstract view
.subckt sky130_fd_sc_hd__and2_4 A B VGND VNB VPB VPWR X
.ends

* Black-box entry subcircuit for sky130_fd_sc_hd__a211oi_2 abstract view
.subckt sky130_fd_sc_hd__a211oi_2 A1 A2 B1 C1 VGND VNB VPB VPWR Y
.ends

* Black-box entry subcircuit for sky130_fd_sc_hd__nand4_2 abstract view
.subckt sky130_fd_sc_hd__nand4_2 A B C D VGND VNB VPB VPWR Y
.ends

* Black-box entry subcircuit for sky130_fd_sc_hd__a22o_2 abstract view
.subckt sky130_fd_sc_hd__a22o_2 A1 A2 B1 B2 VGND VNB VPB VPWR X
.ends

* Black-box entry subcircuit for sky130_fd_sc_hd__o221a_4 abstract view
.subckt sky130_fd_sc_hd__o221a_4 A1 A2 B1 B2 C1 VGND VNB VPB VPWR X
.ends

* Black-box entry subcircuit for sky130_fd_sc_hd__o31ai_1 abstract view
.subckt sky130_fd_sc_hd__o31ai_1 A1 A2 A3 B1 VGND VNB VPB VPWR Y
.ends

* Black-box entry subcircuit for sky130_fd_sc_hd__a2bb2oi_1 abstract view
.subckt sky130_fd_sc_hd__a2bb2oi_1 A1_N A2_N B1 B2 VGND VNB VPB VPWR Y
.ends

* Black-box entry subcircuit for sky130_fd_sc_hd__a2bb2oi_4 abstract view
.subckt sky130_fd_sc_hd__a2bb2oi_4 A1_N A2_N B1 B2 VGND VNB VPB VPWR Y
.ends

* Black-box entry subcircuit for sky130_fd_sc_hd__o2111ai_1 abstract view
.subckt sky130_fd_sc_hd__o2111ai_1 A1 A2 B1 C1 D1 VGND VNB VPB VPWR Y
.ends

* Black-box entry subcircuit for sky130_fd_sc_hd__o22ai_1 abstract view
.subckt sky130_fd_sc_hd__o22ai_1 A1 A2 B1 B2 VGND VNB VPB VPWR Y
.ends

* Black-box entry subcircuit for sky130_fd_sc_hd__a211oi_4 abstract view
.subckt sky130_fd_sc_hd__a211oi_4 A1 A2 B1 C1 VGND VNB VPB VPWR Y
.ends

* Black-box entry subcircuit for sky130_fd_sc_hd__a2bb2oi_2 abstract view
.subckt sky130_fd_sc_hd__a2bb2oi_2 A1_N A2_N B1 B2 VGND VNB VPB VPWR Y
.ends

* Black-box entry subcircuit for sky130_fd_sc_hd__a31oi_2 abstract view
.subckt sky130_fd_sc_hd__a31oi_2 A1 A2 A3 B1 VGND VNB VPB VPWR Y
.ends

* Black-box entry subcircuit for sky130_fd_sc_hd__o221ai_1 abstract view
.subckt sky130_fd_sc_hd__o221ai_1 A1 A2 B1 B2 C1 VGND VNB VPB VPWR Y
.ends

* Black-box entry subcircuit for sky130_fd_sc_hd__o2bb2a_1 abstract view
.subckt sky130_fd_sc_hd__o2bb2a_1 A1_N A2_N B1 B2 VGND VNB VPB VPWR X
.ends

* Black-box entry subcircuit for sky130_fd_sc_hd__a22oi_1 abstract view
.subckt sky130_fd_sc_hd__a22oi_1 A1 A2 B1 B2 VGND VNB VPB VPWR Y
.ends

* Black-box entry subcircuit for sky130_fd_sc_hd__o31ai_2 abstract view
.subckt sky130_fd_sc_hd__o31ai_2 A1 A2 A3 B1 VGND VNB VPB VPWR Y
.ends

* Black-box entry subcircuit for sky130_fd_sc_hd__a32o_2 abstract view
.subckt sky130_fd_sc_hd__a32o_2 A1 A2 A3 B1 B2 VGND VNB VPB VPWR X
.ends

* Black-box entry subcircuit for sky130_fd_sc_hd__a311oi_1 abstract view
.subckt sky130_fd_sc_hd__a311oi_1 A1 A2 A3 B1 C1 VGND VNB VPB VPWR Y
.ends

* Black-box entry subcircuit for sky130_fd_sc_hd__o41a_1 abstract view
.subckt sky130_fd_sc_hd__o41a_1 A1 A2 A3 A4 B1 VGND VNB VPB VPWR X
.ends

* Black-box entry subcircuit for sky130_fd_sc_hd__nor3_2 abstract view
.subckt sky130_fd_sc_hd__nor3_2 A B C VGND VNB VPB VPWR Y
.ends

* Black-box entry subcircuit for sky130_fd_sc_hd__o311a_2 abstract view
.subckt sky130_fd_sc_hd__o311a_2 A1 A2 A3 B1 C1 VGND VNB VPB VPWR X
.ends

* Black-box entry subcircuit for sky130_fd_sc_hd__nor2_4 abstract view
.subckt sky130_fd_sc_hd__nor2_4 A B VGND VNB VPB VPWR Y
.ends

* Black-box entry subcircuit for sky130_fd_sc_hd__xnor2_2 abstract view
.subckt sky130_fd_sc_hd__xnor2_2 A B VGND VNB VPB VPWR Y
.ends

* Black-box entry subcircuit for sky130_fd_sc_hd__a221o_2 abstract view
.subckt sky130_fd_sc_hd__a221o_2 A1 A2 B1 B2 C1 VGND VNB VPB VPWR X
.ends

* Black-box entry subcircuit for sky130_fd_sc_hd__or2_4 abstract view
.subckt sky130_fd_sc_hd__or2_4 A B VGND VNB VPB VPWR X
.ends

* Black-box entry subcircuit for sky130_fd_sc_hd__clkinv_4 abstract view
.subckt sky130_fd_sc_hd__clkinv_4 A VGND VNB VPB VPWR Y
.ends

* Black-box entry subcircuit for sky130_fd_sc_hd__nor2b_2 abstract view
.subckt sky130_fd_sc_hd__nor2b_2 A B_N VGND VNB VPB VPWR Y
.ends

* Black-box entry subcircuit for sky130_fd_sc_hd__o221ai_2 abstract view
.subckt sky130_fd_sc_hd__o221ai_2 A1 A2 B1 B2 C1 VGND VNB VPB VPWR Y
.ends

* Black-box entry subcircuit for sky130_fd_sc_hd__nor3b_2 abstract view
.subckt sky130_fd_sc_hd__nor3b_2 A B C_N VGND VNB VPB VPWR Y
.ends

* Black-box entry subcircuit for sky130_fd_sc_hd__o311a_4 abstract view
.subckt sky130_fd_sc_hd__o311a_4 A1 A2 A3 B1 C1 VGND VNB VPB VPWR X
.ends

* Black-box entry subcircuit for sky130_fd_sc_hd__buf_6 abstract view
.subckt sky130_fd_sc_hd__buf_6 A VGND VNB VPB VPWR X
.ends

* Black-box entry subcircuit for sky130_fd_sc_hd__o2111a_2 abstract view
.subckt sky130_fd_sc_hd__o2111a_2 A1 A2 B1 C1 D1 VGND VNB VPB VPWR X
.ends

* Black-box entry subcircuit for sky130_fd_sc_hd__or4bb_1 abstract view
.subckt sky130_fd_sc_hd__or4bb_1 A B C_N D_N VGND VNB VPB VPWR X
.ends

* Black-box entry subcircuit for sky130_fd_sc_hd__nor4_1 abstract view
.subckt sky130_fd_sc_hd__nor4_1 A B C D VGND VNB VPB VPWR Y
.ends

* Black-box entry subcircuit for sky130_fd_sc_hd__diode_2 abstract view
.subckt sky130_fd_sc_hd__diode_2 DIODE VGND VNB VPB VPWR
.ends

* Black-box entry subcircuit for sky130_fd_sc_hd__a221oi_4 abstract view
.subckt sky130_fd_sc_hd__a221oi_4 A1 A2 B1 B2 C1 VGND VNB VPB VPWR Y
.ends

* Black-box entry subcircuit for sky130_fd_sc_hd__xnor2_4 abstract view
.subckt sky130_fd_sc_hd__xnor2_4 A B VGND VNB VPB VPWR Y
.ends

.subckt csa_da_openlane VGND VPWR clk led[0] led[10] led[11] led[12] led[13] led[14]
+ led[15] led[1] led[2] led[3] led[4] led[5] led[6] led[7] led[8] led[9] rst x[0]
+ x[1] x[2] x[3] x[4] x[5] x[6] x[7]
X_7963_ net42 _0734_ VGND VGND VPWR VPWR _0812_ sky130_fd_sc_hd__nand2_1
X_6914_ _3897_ _3901_ _3828_ VGND VGND VPWR VPWR _3902_ sky130_fd_sc_hd__a21o_1
XFILLER_0_76_133 VGND VGND VPWR VPWR sky130_fd_sc_hd__decap_6
X_7894_ _0731_ _0733_ _0734_ VGND VGND VPWR VPWR _0744_ sky130_fd_sc_hd__o21ai_1
XFILLER_0_77_678 VGND VGND VPWR VPWR sky130_fd_sc_hd__decap_8
X_6845_ sh4\[1\] _3750_ VGND VGND VPWR VPWR _3833_ sky130_fd_sc_hd__nor2_1
XFILLER_0_18_701 VPWR VGND VPWR VGND sky130_ef_sc_hd__decap_12
XFILLER_0_92_648 VPWR VGND VPWR VGND sky130_ef_sc_hd__decap_12
XFILLER_0_57_391 VGND VGND VPWR VPWR sky130_fd_sc_hd__fill_1
XFILLER_0_9_466 VPWR VGND VPWR VGND sky130_ef_sc_hd__decap_12
X_6776_ _3763_ _3764_ sh13\[1\] VGND VGND VPWR VPWR _3765_ sky130_fd_sc_hd__o21ai_2
XFILLER_0_119_279 VGND VGND VPWR VPWR sky130_fd_sc_hd__fill_1
XFILLER_0_91_169 VGND VGND VPWR VPWR sky130_fd_sc_hd__decap_4
XFILLER_0_72_350 VGND VGND VPWR VPWR sky130_fd_sc_hd__decap_8
X_8515_ clknet_leaf_39_clk _0095_ _0266_ VGND VGND VPWR VPWR sum5\[5\] sky130_fd_sc_hd__dfrtp_1
X_5727_ _2729_ _2741_ _2742_ VGND VGND VPWR VPWR _2743_ sky130_fd_sc_hd__nand3b_2
XFILLER_0_45_542 VGND VGND VPWR VPWR sky130_fd_sc_hd__decap_4
X_8446_ clknet_leaf_28_clk net423 _0197_ VGND VGND VPWR VPWR carry4\[12\] sky130_fd_sc_hd__dfrtp_1
X_5658_ _2673_ _2669_ _2671_ VGND VGND VPWR VPWR _2675_ sky130_fd_sc_hd__and3b_1
XFILLER_0_32_236 VPWR VGND VPWR VGND sky130_ef_sc_hd__decap_12
X_4609_ _1644_ _1646_ _1647_ VGND VGND VPWR VPWR _1648_ sky130_fd_sc_hd__o21ai_2
XFILLER_0_102_113 VPWR VGND VPWR VGND sky130_ef_sc_hd__decap_12
X_8377_ _1207_ _1208_ carry5\[13\] VGND VGND VPWR VPWR _1210_ sky130_fd_sc_hd__o21bai_2
X_5589_ _2606_ _2560_ VGND VGND VPWR VPWR _2607_ sky130_fd_sc_hd__nand2_2
XFILLER_0_102_146 VPWR VGND VPWR VGND sky130_ef_sc_hd__decap_12
Xhold351 sh4\[3\] VGND VGND VPWR VPWR net393 sky130_fd_sc_hd__dlygate4sd3_1
Xhold340 _0035_ VGND VGND VPWR VPWR net382 sky130_fd_sc_hd__dlygate4sd3_1
XFILLER_0_7_81 VPWR VGND VPWR VGND sky130_ef_sc_hd__decap_12
XFILLER_0_13_472 VGND VGND VPWR VPWR sky130_fd_sc_hd__decap_6
Xhold362 sh0\[2\] VGND VGND VPWR VPWR net404 sky130_fd_sc_hd__dlygate4sd3_1
X_7328_ _4140_ VGND VGND VPWR VPWR _0345_ sky130_fd_sc_hd__inv_2
Xhold384 sh15\[6\] VGND VGND VPWR VPWR net426 sky130_fd_sc_hd__dlygate4sd3_1
Xhold373 carry3\[8\] VGND VGND VPWR VPWR net415 sky130_fd_sc_hd__dlygate4sd3_1
X_7259_ _4133_ VGND VGND VPWR VPWR _0283_ sky130_fd_sc_hd__inv_2
XFILLER_0_2_7 VPWR VGND VPWR VGND sky130_ef_sc_hd__decap_12
Xhold395 sh15\[0\] VGND VGND VPWR VPWR net437 sky130_fd_sc_hd__dlygate4sd3_1
XFILLER_0_99_225 VGND VGND VPWR VPWR sky130_fd_sc_hd__decap_8
XTAP_1800 VGND VPWR sky130_fd_sc_hd__tapvpwrvgnd_1
XTAP_1833 VGND VPWR sky130_fd_sc_hd__tapvpwrvgnd_1
XTAP_1822 VGND VPWR sky130_fd_sc_hd__tapvpwrvgnd_1
XTAP_1811 VGND VPWR sky130_fd_sc_hd__tapvpwrvgnd_1
XFILLER_0_68_645 VGND VGND VPWR VPWR sky130_fd_sc_hd__decap_8
XFILLER_0_67_133 VGND VGND VPWR VPWR sky130_fd_sc_hd__fill_2
XTAP_1866 VGND VPWR sky130_fd_sc_hd__tapvpwrvgnd_1
XTAP_1855 VGND VPWR sky130_fd_sc_hd__tapvpwrvgnd_1
XTAP_1844 VGND VPWR sky130_fd_sc_hd__tapvpwrvgnd_1
XFILLER_0_95_464 VPWR VGND VPWR VGND sky130_ef_sc_hd__decap_12
XFILLER_0_83_615 VGND VGND VPWR VPWR sky130_fd_sc_hd__fill_1
XFILLER_0_68_678 VGND VGND VPWR VPWR sky130_fd_sc_hd__fill_2
XTAP_1877 VGND VPWR sky130_fd_sc_hd__tapvpwrvgnd_1
XFILLER_0_67_188 VPWR VGND VPWR VGND sky130_ef_sc_hd__decap_12
XFILLER_0_48_380 VGND VGND VPWR VPWR sky130_fd_sc_hd__decap_8
XFILLER_0_70_309 VGND VGND VPWR VPWR sky130_fd_sc_hd__decap_6
XFILLER_0_63_372 VGND VGND VPWR VPWR sky130_fd_sc_hd__fill_1
XFILLER_0_3_609 VGND VGND VPWR VPWR sky130_fd_sc_hd__decap_6
XFILLER_0_36_586 VGND VGND VPWR VPWR sky130_fd_sc_hd__fill_2
XFILLER_0_48_15 VPWR VGND VPWR VGND sky130_ef_sc_hd__decap_12
XFILLER_0_121_499 VGND VGND VPWR VPWR sky130_fd_sc_hd__decap_4
XFILLER_0_3_39 VPWR VGND VPWR VGND sky130_ef_sc_hd__decap_12
X_4960_ _1991_ _1946_ _1993_ VGND VGND VPWR VPWR _1994_ sky130_fd_sc_hd__nand3b_2
XFILLER_0_58_133 VGND VGND VPWR VPWR sky130_fd_sc_hd__decap_6
X_4891_ _1924_ _1925_ _1911_ VGND VGND VPWR VPWR _1926_ sky130_fd_sc_hd__o21ai_1
XFILLER_0_86_475 VGND VGND VPWR VPWR sky130_fd_sc_hd__fill_1
X_6630_ _3618_ _3614_ _3617_ VGND VGND VPWR VPWR _3625_ sky130_fd_sc_hd__nand3_1
XFILLER_0_74_648 VGND VGND VPWR VPWR sky130_fd_sc_hd__decap_6
XFILLER_0_13_51 VGND VGND VPWR VPWR sky130_fd_sc_hd__fill_2
X_6561_ _3295_ _3306_ VGND VGND VPWR VPWR _3557_ sky130_fd_sc_hd__nor2_1
XFILLER_0_6_403 VGND VGND VPWR VPWR sky130_fd_sc_hd__fill_1
XFILLER_0_27_531 VGND VGND VPWR VPWR sky130_fd_sc_hd__decap_8
XFILLER_0_116_238 VGND VGND VPWR VPWR sky130_fd_sc_hd__fill_1
X_8300_ sum5\[8\] s7\[8\] carry5\[7\] VGND VGND VPWR VPWR _1139_ sky130_fd_sc_hd__o21ai_2
X_5512_ _2527_ _2528_ _2530_ VGND VGND VPWR VPWR _2531_ sky130_fd_sc_hd__a21o_1
XFILLER_0_42_501 VGND VGND VPWR VPWR sky130_fd_sc_hd__decap_8
XFILLER_0_120_41 VPWR VGND VPWR VGND sky130_ef_sc_hd__decap_12
XFILLER_0_89_55 VGND VGND VPWR VPWR sky130_fd_sc_hd__fill_1
X_6492_ _3429_ _3432_ VGND VGND VPWR VPWR _3489_ sky130_fd_sc_hd__nand2_1
XFILLER_0_89_77 VGND VGND VPWR VPWR sky130_fd_sc_hd__fill_2
X_8231_ _1005_ _1008_ _1009_ _1010_ VGND VGND VPWR VPWR _1076_ sky130_fd_sc_hd__a31oi_1
XFILLER_0_42_578 VGND VGND VPWR VPWR sky130_fd_sc_hd__decap_6
XFILLER_0_42_589 VPWR VGND VPWR VGND sky130_ef_sc_hd__decap_12
X_5443_ _2463_ _2464_ VGND VGND VPWR VPWR _0162_ sky130_fd_sc_hd__nand2_1
XFILLER_0_120_85 VPWR VGND VPWR VGND sky130_ef_sc_hd__decap_12
XFILLER_0_112_477 VGND VGND VPWR VPWR sky130_fd_sc_hd__fill_2
XFILLER_0_112_466 VGND VGND VPWR VPWR sky130_fd_sc_hd__decap_8
X_8162_ _1006_ _1007_ _1002_ VGND VGND VPWR VPWR _1008_ sky130_fd_sc_hd__nand3_2
X_5374_ _2397_ _2398_ _2386_ _2390_ VGND VGND VPWR VPWR _2399_ sky130_fd_sc_hd__o211a_1
X_4325_ _1239_ _1235_ VGND VGND VPWR VPWR _1372_ sky130_fd_sc_hd__or2_1
XFILLER_0_112_499 VGND VGND VPWR VPWR sky130_fd_sc_hd__fill_2
X_7113_ _4091_ _4096_ VGND VGND VPWR VPWR _0151_ sky130_fd_sc_hd__nand2_1
X_8093_ _0731_ _0733_ _0870_ VGND VGND VPWR VPWR _0940_ sky130_fd_sc_hd__o21ai_4
XFILLER_0_10_475 VGND VGND VPWR VPWR sky130_fd_sc_hd__fill_1
X_4256_ _1292_ _1296_ _1302_ VGND VGND VPWR VPWR _1304_ sky130_fd_sc_hd__a21o_1
XFILLER_0_10_497 VPWR VGND VPWR VGND sky130_ef_sc_hd__decap_12
X_7044_ _4026_ _4028_ VGND VGND VPWR VPWR _4029_ sky130_fd_sc_hd__nor2_1
XFILLER_0_89_291 VGND VGND VPWR VPWR sky130_fd_sc_hd__fill_1
XTAP_1129 VGND VPWR sky130_fd_sc_hd__tapvpwrvgnd_1
XTAP_1118 VGND VPWR sky130_fd_sc_hd__tapvpwrvgnd_1
XTAP_1107 VGND VPWR sky130_fd_sc_hd__tapvpwrvgnd_1
X_7946_ _0746_ _0747_ sh14\[3\] _0794_ VGND VGND VPWR VPWR _0795_ sky130_fd_sc_hd__a211o_1
XFILLER_0_49_133 VPWR VGND VPWR VGND sky130_ef_sc_hd__decap_12
XFILLER_0_77_453 VGND VGND VPWR VPWR sky130_fd_sc_hd__fill_1
X_7877_ _0724_ _0725_ _0726_ VGND VGND VPWR VPWR _0727_ sky130_fd_sc_hd__o21bai_4
X_6828_ _3816_ _3805_ _3802_ VGND VGND VPWR VPWR _3817_ sky130_fd_sc_hd__o21ai_2
XFILLER_0_52_309 VGND VGND VPWR VPWR sky130_fd_sc_hd__decap_4
XFILLER_0_9_285 VPWR VGND VPWR VGND sky130_ef_sc_hd__decap_12
XFILLER_0_9_274 VGND VGND VPWR VPWR sky130_fd_sc_hd__decap_6
XFILLER_0_18_531 VGND VGND VPWR VPWR sky130_fd_sc_hd__fill_1
XFILLER_0_64_169 VGND VGND VPWR VPWR sky130_fd_sc_hd__fill_1
X_6759_ _3734_ _3747_ _3715_ VGND VGND VPWR VPWR _3748_ sky130_fd_sc_hd__o21bai_2
XFILLER_0_103_400 VGND VGND VPWR VPWR sky130_fd_sc_hd__fill_1
X_8429_ _1223_ _1226_ _1229_ _1258_ VGND VGND VPWR VPWR _1259_ sky130_fd_sc_hd__a31o_1
XFILLER_0_21_729 VGND VGND VPWR VPWR sky130_fd_sc_hd__decap_6
Xhold170 s2\[6\] VGND VGND VPWR VPWR net212 sky130_fd_sc_hd__clkdlybuf4s25_1
Xhold181 sh2\[3\] VGND VGND VPWR VPWR net223 sky130_fd_sc_hd__dlygate4sd3_1
Xhold192 sum2\[9\] VGND VGND VPWR VPWR net234 sky130_fd_sc_hd__dlygate4sd3_1
XFILLER_0_88_707 VPWR VGND VPWR VGND sky130_ef_sc_hd__decap_12
XTAP_1630 VGND VPWR sky130_fd_sc_hd__tapvpwrvgnd_1
XTAP_1641 VGND VPWR sky130_fd_sc_hd__tapvpwrvgnd_1
XTAP_1685 VGND VPWR sky130_fd_sc_hd__tapvpwrvgnd_1
XTAP_1674 VGND VPWR sky130_fd_sc_hd__tapvpwrvgnd_1
XTAP_1663 VGND VPWR sky130_fd_sc_hd__tapvpwrvgnd_1
XTAP_1652 VGND VPWR sky130_fd_sc_hd__tapvpwrvgnd_1
XFILLER_0_55_125 VPWR VGND VPWR VGND sky130_ef_sc_hd__decap_12
XTAP_1696 VGND VPWR sky130_fd_sc_hd__tapvpwrvgnd_1
XFILLER_0_50_27 VGND VGND VPWR VPWR sky130_fd_sc_hd__fill_1
XFILLER_0_55_169 VGND VGND VPWR VPWR sky130_fd_sc_hd__decap_4
XFILLER_0_70_128 VGND VGND VPWR VPWR sky130_fd_sc_hd__decap_3
XFILLER_0_24_545 VPWR VGND VPWR VGND sky130_ef_sc_hd__decap_12
XFILLER_0_24_589 VPWR VGND VPWR VGND sky130_ef_sc_hd__decap_12
X_5090_ _2059_ _2078_ VGND VGND VPWR VPWR _2119_ sky130_fd_sc_hd__nand2_1
XFILLER_0_75_57 VPWR VGND VPWR VGND sky130_ef_sc_hd__decap_12
X_5992_ _2999_ VGND VGND VPWR VPWR _3000_ sky130_fd_sc_hd__clkbuf_4
X_8780_ clknet_leaf_47_clk net164 _0531_ VGND VGND VPWR VPWR sh4\[0\] sky130_fd_sc_hd__dfrtp_4
X_7800_ s0\[5\] net389 _0685_ VGND VGND VPWR VPWR _0005_ sky130_fd_sc_hd__o21a_1
X_4943_ sh15\[7\] _1662_ _1722_ VGND VGND VPWR VPWR _1977_ sky130_fd_sc_hd__and3_1
X_7731_ net319 _0636_ _0637_ VGND VGND VPWR VPWR _0639_ sky130_fd_sc_hd__or3_1
XFILLER_0_47_615 VGND VGND VPWR VPWR sky130_fd_sc_hd__fill_1
X_7662_ net333 _4186_ _4187_ VGND VGND VPWR VPWR _4189_ sky130_fd_sc_hd__or3_1
XFILLER_0_59_497 VGND VGND VPWR VPWR sky130_fd_sc_hd__fill_1
X_4874_ _1862_ _1863_ _1864_ VGND VGND VPWR VPWR _1909_ sky130_fd_sc_hd__o21a_1
X_6613_ _3607_ _3605_ _3561_ VGND VGND VPWR VPWR _3608_ sky130_fd_sc_hd__a21oi_2
XFILLER_0_74_445 VGND VGND VPWR VPWR sky130_fd_sc_hd__fill_1
XFILLER_0_117_547 VGND VGND VPWR VPWR sky130_fd_sc_hd__decap_3
X_7593_ _4166_ VGND VGND VPWR VPWR _0584_ sky130_fd_sc_hd__inv_2
XFILLER_0_6_233 VGND VGND VPWR VPWR sky130_fd_sc_hd__decap_8
X_6544_ _3471_ _3472_ _3474_ VGND VGND VPWR VPWR _3541_ sky130_fd_sc_hd__a21oi_1
X_6475_ _3393_ _3395_ _3400_ VGND VGND VPWR VPWR _3473_ sky130_fd_sc_hd__a21oi_1
XFILLER_0_15_556 VGND VGND VPWR VPWR sky130_fd_sc_hd__decap_4
XFILLER_0_15_567 VPWR VGND VPWR VGND sky130_ef_sc_hd__decap_12
XFILLER_0_112_230 VPWR VGND VPWR VGND sky130_ef_sc_hd__decap_12
XFILLER_0_71_3 VPWR VGND VPWR VGND sky130_ef_sc_hd__decap_12
X_8214_ _0740_ _0723_ VGND VGND VPWR VPWR _1059_ sky130_fd_sc_hd__nor2_1
X_5426_ _2419_ _2425_ _2448_ VGND VGND VPWR VPWR _2450_ sky130_fd_sc_hd__nand3_1
XFILLER_0_112_285 VPWR VGND VPWR VGND sky130_ef_sc_hd__decap_12
XFILLER_0_10_261 VGND VGND VPWR VPWR sky130_fd_sc_hd__fill_1
X_5357_ _2321_ _2377_ _2378_ _2379_ _2381_ VGND VGND VPWR VPWR _2382_ sky130_fd_sc_hd__o221ai_4
X_8145_ _0767_ _0915_ _0922_ VGND VGND VPWR VPWR _0992_ sky130_fd_sc_hd__o21ai_2
X_4308_ sh4\[5\] sh5\[5\] VGND VGND VPWR VPWR _1355_ sky130_fd_sc_hd__and2_2
XFILLER_0_10_283 VGND VGND VPWR VPWR sky130_fd_sc_hd__decap_3
X_5288_ _2246_ _2314_ VGND VGND VPWR VPWR _0157_ sky130_fd_sc_hd__xor2_1
X_8076_ _0921_ _0923_ _0858_ VGND VGND VPWR VPWR _0924_ sky130_fd_sc_hd__a21o_1
X_4239_ sh0\[5\] sh2\[5\] sh6\[5\] VGND VGND VPWR VPWR _1287_ sky130_fd_sc_hd__o21a_1
X_7027_ _3903_ _3964_ VGND VGND VPWR VPWR _4013_ sky130_fd_sc_hd__nor2_1
XFILLER_0_69_239 VGND VGND VPWR VPWR sky130_fd_sc_hd__fill_1
X_7929_ _0733_ _0771_ _0773_ _0774_ _0777_ VGND VGND VPWR VPWR _0778_ sky130_fd_sc_hd__o221ai_4
XFILLER_0_38_648 VPWR VGND VPWR VGND sky130_ef_sc_hd__decap_12
XFILLER_0_108_514 VPWR VGND VPWR VGND sky130_ef_sc_hd__decap_12
XFILLER_0_37_125 VGND VGND VPWR VPWR sky130_fd_sc_hd__decap_8
XFILLER_0_37_169 VPWR VGND VPWR VGND sky130_ef_sc_hd__decap_12
XFILLER_0_52_139 VGND VGND VPWR VPWR sky130_fd_sc_hd__fill_1
XFILLER_0_45_180 VPWR VGND VPWR VGND sky130_ef_sc_hd__decap_12
XFILLER_0_46_681 VPWR VGND VPWR VGND sky130_ef_sc_hd__decap_12
XFILLER_0_61_673 VPWR VGND VPWR VGND sky130_ef_sc_hd__decap_12
XFILLER_0_21_559 VGND VGND VPWR VPWR sky130_fd_sc_hd__fill_1
XFILLER_0_29_39 VGND VGND VPWR VPWR sky130_fd_sc_hd__decap_6
XFILLER_0_45_27 VPWR VGND VPWR VGND sky130_ef_sc_hd__decap_12
XFILLER_0_0_29 VPWR VGND VPWR VGND sky130_ef_sc_hd__decap_12
XFILLER_0_96_581 VGND VGND VPWR VPWR sky130_fd_sc_hd__decap_3
XFILLER_0_96_570 VGND VGND VPWR VPWR sky130_fd_sc_hd__fill_2
XTAP_1460 VGND VPWR sky130_fd_sc_hd__tapvpwrvgnd_1
XFILLER_0_84_721 VPWR VGND VPWR VGND sky130_ef_sc_hd__decap_12
XTAP_1493 VGND VPWR sky130_fd_sc_hd__tapvpwrvgnd_1
XTAP_1482 VGND VPWR sky130_fd_sc_hd__tapvpwrvgnd_1
XTAP_1471 VGND VPWR sky130_fd_sc_hd__tapvpwrvgnd_1
XFILLER_0_68_294 VPWR VGND VPWR VGND sky130_ef_sc_hd__decap_12
XFILLER_0_56_467 VGND VGND VPWR VPWR sky130_fd_sc_hd__decap_8
XFILLER_0_28_158 VGND VGND VPWR VPWR sky130_fd_sc_hd__fill_2
X_4590_ _1623_ _1624_ _1615_ VGND VGND VPWR VPWR _1631_ sky130_fd_sc_hd__o21a_1
XFILLER_0_9_27 VPWR VGND VPWR VGND sky130_ef_sc_hd__decap_12
XFILLER_0_3_225 VPWR VGND VPWR VGND sky130_ef_sc_hd__decap_12
XFILLER_0_101_76 VGND VGND VPWR VPWR sky130_fd_sc_hd__fill_2
XFILLER_0_10_41 VPWR VGND VPWR VGND sky130_ef_sc_hd__decap_12
X_6260_ _3262_ _3260_ _3261_ VGND VGND VPWR VPWR _3264_ sky130_fd_sc_hd__nand3_2
XFILLER_0_110_701 VPWR VGND VPWR VGND sky130_ef_sc_hd__decap_12
XFILLER_0_10_85 VPWR VGND VPWR VGND sky130_ef_sc_hd__decap_12
X_6191_ _3193_ _3195_ sh14\[6\] VGND VGND VPWR VPWR _3196_ sky130_fd_sc_hd__o21bai_2
X_5211_ _2179_ _2236_ _2177_ VGND VGND VPWR VPWR _2239_ sky130_fd_sc_hd__o21ai_1
X_5142_ _2169_ _2170_ _2152_ _2145_ VGND VGND VPWR VPWR _2171_ sky130_fd_sc_hd__o211ai_4
X_5073_ sh8\[2\] VGND VGND VPWR VPWR _2102_ sky130_fd_sc_hd__clkbuf_4
XFILLER_0_79_559 VGND VGND VPWR VPWR sky130_fd_sc_hd__fill_1
X_8832_ clknet_leaf_1_clk net182 _0583_ VGND VGND VPWR VPWR sh10\[4\] sky130_fd_sc_hd__dfrtp_2
XFILLER_0_35_82 VGND VGND VPWR VPWR sky130_fd_sc_hd__decap_3
X_8763_ clknet_leaf_18_clk net267 _0514_ VGND VGND VPWR VPWR sh1\[7\] sky130_fd_sc_hd__dfrtp_1
X_5975_ _2981_ _2982_ _2983_ VGND VGND VPWR VPWR _2984_ sky130_fd_sc_hd__a21oi_1
XFILLER_0_47_412 VPWR VGND VPWR VGND sky130_ef_sc_hd__decap_12
X_4926_ _1652_ _1637_ _1959_ VGND VGND VPWR VPWR _1960_ sky130_fd_sc_hd__a21o_1
X_7714_ carry1\[5\] sum1\[6\] VGND VGND VPWR VPWR _0629_ sky130_fd_sc_hd__xnor2_1
X_8694_ clknet_leaf_58_clk _0158_ _0445_ VGND VGND VPWR VPWR bit_sum2\[5\] sky130_fd_sc_hd__dfrtp_1
X_4857_ _1798_ _1813_ _1869_ _1879_ _1888_ VGND VGND VPWR VPWR _1893_ sky130_fd_sc_hd__o221ai_4
XFILLER_0_90_713 VPWR VGND VPWR VGND sky130_ef_sc_hd__decap_12
XFILLER_0_74_253 VPWR VGND VPWR VGND sky130_ef_sc_hd__decap_12
X_7645_ sum3\[6\] carry3\[5\] VGND VGND VPWR VPWR _4175_ sky130_fd_sc_hd__nor2_1
XFILLER_0_19_169 VPWR VGND VPWR VGND sky130_ef_sc_hd__decap_12
X_7576_ _4158_ VGND VGND VPWR VPWR _4165_ sky130_fd_sc_hd__buf_8
XFILLER_0_28_692 VGND VGND VPWR VPWR sky130_fd_sc_hd__decap_8
X_4788_ _1756_ _1755_ _1767_ VGND VGND VPWR VPWR _1825_ sky130_fd_sc_hd__a21oi_1
X_6527_ _3516_ _3459_ _3443_ VGND VGND VPWR VPWR _3524_ sky130_fd_sc_hd__o21ai_2
XFILLER_0_42_161 VGND VGND VPWR VPWR sky130_fd_sc_hd__fill_2
XFILLER_0_43_673 VPWR VGND VPWR VGND sky130_ef_sc_hd__decap_12
XFILLER_0_113_561 VGND VGND VPWR VPWR sky130_fd_sc_hd__decap_6
X_6458_ _3441_ _3443_ _3455_ VGND VGND VPWR VPWR _3456_ sky130_fd_sc_hd__nand3_1
XFILLER_0_30_356 VGND VGND VPWR VPWR sky130_fd_sc_hd__decap_8
XFILLER_0_100_233 VPWR VGND VPWR VGND sky130_ef_sc_hd__decap_12
X_6389_ _3286_ sh12\[4\] VGND VGND VPWR VPWR _3388_ sky130_fd_sc_hd__nor2_1
XFILLER_0_30_389 VGND VGND VPWR VPWR sky130_fd_sc_hd__decap_8
X_5409_ _2373_ _2427_ _2430_ _2432_ VGND VGND VPWR VPWR _2433_ sky130_fd_sc_hd__o22ai_2
X_8128_ _0797_ _0726_ _0901_ VGND VGND VPWR VPWR _0975_ sky130_fd_sc_hd__a21oi_1
X_8059_ _0899_ _0900_ _0897_ VGND VGND VPWR VPWR _0907_ sky130_fd_sc_hd__o21ai_1
XFILLER_0_78_570 VGND VGND VPWR VPWR sky130_fd_sc_hd__fill_1
XFILLER_0_65_231 VGND VGND VPWR VPWR sky130_fd_sc_hd__fill_2
XFILLER_0_65_275 VGND VGND VPWR VPWR sky130_fd_sc_hd__fill_1
XFILLER_0_38_489 VPWR VGND VPWR VGND sky130_ef_sc_hd__decap_12
XFILLER_0_18_180 VGND VGND VPWR VPWR sky130_fd_sc_hd__decap_3
XFILLER_0_25_139 VGND VGND VPWR VPWR sky130_fd_sc_hd__fill_1
XFILLER_0_123_369 VGND VGND VPWR VPWR sky130_fd_sc_hd__fill_1
XFILLER_0_111_509 VGND VGND VPWR VPWR sky130_fd_sc_hd__decap_4
XFILLER_0_1_729 VGND VGND VPWR VPWR sky130_fd_sc_hd__decap_6
XTAP_507 VGND VPWR sky130_fd_sc_hd__tapvpwrvgnd_1
XTAP_529 VGND VPWR sky130_fd_sc_hd__tapvpwrvgnd_1
XTAP_518 VGND VPWR sky130_fd_sc_hd__tapvpwrvgnd_1
XFILLER_0_56_37 VPWR VGND VPWR VGND sky130_ef_sc_hd__decap_12
XFILLER_0_56_26 VGND VGND VPWR VPWR sky130_fd_sc_hd__fill_2
XFILLER_0_88_389 VPWR VGND VPWR VGND sky130_ef_sc_hd__decap_12
XFILLER_0_56_220 VPWR VGND VPWR VGND sky130_ef_sc_hd__decap_12
X_5760_ _2487_ _2473_ VGND VGND VPWR VPWR _2775_ sky130_fd_sc_hd__nor2_1
XFILLER_0_29_445 VGND VGND VPWR VPWR sky130_fd_sc_hd__decap_3
X_4711_ _1747_ _1748_ VGND VGND VPWR VPWR _1749_ sky130_fd_sc_hd__nor2_2
XTAP_1290 VGND VPWR sky130_fd_sc_hd__tapvpwrvgnd_1
XFILLER_0_17_629 VGND VGND VPWR VPWR sky130_fd_sc_hd__decap_4
X_5691_ _2702_ _2706_ _2707_ _2613_ VGND VGND VPWR VPWR _2708_ sky130_fd_sc_hd__o2bb2ai_2
XFILLER_0_112_53 VPWR VGND VPWR VGND sky130_ef_sc_hd__decap_12
X_4642_ _1675_ _1677_ _1674_ _1679_ VGND VGND VPWR VPWR _1680_ sky130_fd_sc_hd__o22a_2
XFILLER_0_56_286 VGND VGND VPWR VPWR sky130_fd_sc_hd__fill_1
XFILLER_0_16_128 VPWR VGND VPWR VGND sky130_ef_sc_hd__decap_12
X_7430_ _4150_ VGND VGND VPWR VPWR _0437_ sky130_fd_sc_hd__inv_2
X_4573_ _1611_ _1615_ _1584_ VGND VGND VPWR VPWR _1616_ sky130_fd_sc_hd__a21oi_1
XFILLER_0_71_278 VGND VGND VPWR VPWR sky130_fd_sc_hd__fill_2
XFILLER_0_52_470 VGND VGND VPWR VPWR sky130_fd_sc_hd__decap_6
XFILLER_0_25_673 VPWR VGND VPWR VGND sky130_ef_sc_hd__decap_12
X_7361_ _4143_ VGND VGND VPWR VPWR _0375_ sky130_fd_sc_hd__inv_2
XFILLER_0_97_55 VGND VGND VPWR VPWR sky130_fd_sc_hd__fill_1
X_7292_ _4137_ VGND VGND VPWR VPWR _0312_ sky130_fd_sc_hd__inv_2
X_6312_ _3310_ _3311_ VGND VGND VPWR VPWR _3312_ sky130_fd_sc_hd__nand2_1
XFILLER_0_12_345 VGND VGND VPWR VPWR sky130_fd_sc_hd__decap_8
X_6243_ _2886_ _2875_ _3199_ VGND VGND VPWR VPWR _3247_ sky130_fd_sc_hd__a21bo_1
XFILLER_0_40_665 VPWR VGND VPWR VGND sky130_ef_sc_hd__decap_12
X_6174_ _3169_ _3174_ _3175_ _3179_ VGND VGND VPWR VPWR _3180_ sky130_fd_sc_hd__o211ai_2
X_5125_ _2146_ _2150_ _2151_ _2153_ VGND VGND VPWR VPWR _2154_ sky130_fd_sc_hd__o211a_2
XFILLER_0_34_3 VPWR VGND VPWR VGND sky130_ef_sc_hd__decap_12
X_5056_ _2085_ VGND VGND VPWR VPWR _0105_ sky130_fd_sc_hd__buf_1
XFILLER_0_46_81 VGND VGND VPWR VPWR sky130_fd_sc_hd__decap_3
X_8815_ clknet_leaf_4_clk net35 _0566_ VGND VGND VPWR VPWR sh8\[3\] sky130_fd_sc_hd__dfrtp_2
XFILLER_0_48_721 VPWR VGND VPWR VGND sky130_ef_sc_hd__decap_12
X_5958_ _2963_ _2965_ _2966_ VGND VGND VPWR VPWR _2967_ sky130_fd_sc_hd__nand3_4
XFILLER_0_94_359 VGND VGND VPWR VPWR sky130_fd_sc_hd__decap_4
X_8746_ clknet_leaf_24_clk _0187_ _0497_ VGND VGND VPWR VPWR bit_sum7\[7\] sky130_fd_sc_hd__dfrtp_1
X_4909_ _1888_ _1896_ VGND VGND VPWR VPWR _1944_ sky130_fd_sc_hd__nand2_1
XFILLER_0_47_253 VGND VGND VPWR VPWR sky130_fd_sc_hd__decap_6
X_5889_ _2897_ _2898_ VGND VGND VPWR VPWR _2899_ sky130_fd_sc_hd__nor2_1
X_8677_ clknet_leaf_43_clk _0179_ _0428_ VGND VGND VPWR VPWR bit_sum0\[8\] sky130_fd_sc_hd__dfrtp_1
XFILLER_0_118_697 VGND VGND VPWR VPWR sky130_fd_sc_hd__decap_3
X_7628_ _4169_ VGND VGND VPWR VPWR _0616_ sky130_fd_sc_hd__inv_2
XFILLER_0_105_303 VPWR VGND VPWR VGND sky130_ef_sc_hd__decap_12
XFILLER_0_62_245 VGND VGND VPWR VPWR sky130_fd_sc_hd__decap_6
XFILLER_0_7_361 VGND VGND VPWR VPWR sky130_fd_sc_hd__decap_6
XFILLER_0_90_598 VPWR VGND VPWR VGND sky130_ef_sc_hd__decap_12
X_7559_ _4163_ VGND VGND VPWR VPWR _0553_ sky130_fd_sc_hd__inv_2
XFILLER_0_15_161 VGND VGND VPWR VPWR sky130_fd_sc_hd__fill_2
XFILLER_0_22_109 VPWR VGND VPWR VGND sky130_ef_sc_hd__decap_12
XFILLER_0_31_610 VGND VGND VPWR VPWR sky130_fd_sc_hd__decap_6
XFILLER_0_50_429 VGND VGND VPWR VPWR sky130_fd_sc_hd__fill_1
XFILLER_0_31_643 VGND VGND VPWR VPWR sky130_fd_sc_hd__fill_1
XFILLER_0_31_654 VPWR VGND VPWR VGND sky130_ef_sc_hd__decap_12
XFILLER_0_113_391 VGND VGND VPWR VPWR sky130_fd_sc_hd__fill_1
XFILLER_0_30_197 VGND VGND VPWR VPWR sky130_fd_sc_hd__decap_4
XFILLER_0_101_597 VGND VGND VPWR VPWR sky130_fd_sc_hd__fill_1
Xhold41 bit_sum1\[7\] VGND VGND VPWR VPWR net83 sky130_fd_sc_hd__dlygate4sd3_1
Xhold30 bit_sum1\[9\] VGND VGND VPWR VPWR net72 sky130_fd_sc_hd__dlygate4sd3_1
XFILLER_0_89_109 VGND VGND VPWR VPWR sky130_fd_sc_hd__decap_3
Xhold74 bit_sum3\[9\] VGND VGND VPWR VPWR net116 sky130_fd_sc_hd__dlygate4sd3_1
XFILLER_0_26_29 VPWR VGND VPWR VGND sky130_ef_sc_hd__decap_12
Xhold52 sum3\[0\] VGND VGND VPWR VPWR net94 sky130_fd_sc_hd__dlygate4sd3_1
Xhold63 sum2\[1\] VGND VGND VPWR VPWR net105 sky130_fd_sc_hd__dlygate4sd3_1
XFILLER_0_98_621 VGND VGND VPWR VPWR sky130_fd_sc_hd__decap_6
Xhold96 bit_sum6\[4\] VGND VGND VPWR VPWR net138 sky130_fd_sc_hd__dlygate4sd3_1
Xhold85 bit_sum2\[3\] VGND VGND VPWR VPWR net127 sky130_fd_sc_hd__dlygate4sd3_1
XFILLER_0_97_120 VGND VGND VPWR VPWR sky130_fd_sc_hd__decap_8
XFILLER_0_58_507 VPWR VGND VPWR VGND sky130_ef_sc_hd__decap_12
XFILLER_0_109_620 VPWR VGND VPWR VGND sky130_ef_sc_hd__decap_12
XFILLER_0_38_253 VPWR VGND VPWR VGND sky130_ef_sc_hd__decap_12
XFILLER_0_108_141 VGND VGND VPWR VPWR sky130_fd_sc_hd__fill_2
XFILLER_0_66_595 VGND VGND VPWR VPWR sky130_fd_sc_hd__fill_1
XFILLER_0_53_223 VGND VGND VPWR VPWR sky130_fd_sc_hd__fill_1
XFILLER_0_109_697 VPWR VGND VPWR VGND sky130_ef_sc_hd__decap_12
XFILLER_0_53_245 VGND VGND VPWR VPWR sky130_fd_sc_hd__decap_4
XFILLER_0_13_109 VGND VGND VPWR VPWR sky130_fd_sc_hd__decap_3
XFILLER_0_22_621 VGND VGND VPWR VPWR sky130_fd_sc_hd__decap_8
XFILLER_0_22_643 VGND VGND VPWR VPWR sky130_fd_sc_hd__fill_1
XFILLER_0_111_328 VGND VGND VPWR VPWR sky130_fd_sc_hd__fill_1
XFILLER_0_1_559 VGND VGND VPWR VPWR sky130_fd_sc_hd__fill_1
XFILLER_0_22_687 VPWR VGND VPWR VGND sky130_ef_sc_hd__decap_12
XTAP_315 VGND VPWR sky130_fd_sc_hd__tapvpwrvgnd_1
XTAP_304 VGND VPWR sky130_fd_sc_hd__tapvpwrvgnd_1
XTAP_348 VGND VPWR sky130_fd_sc_hd__tapvpwrvgnd_1
XTAP_337 VGND VPWR sky130_fd_sc_hd__tapvpwrvgnd_1
XTAP_326 VGND VPWR sky130_fd_sc_hd__tapvpwrvgnd_1
XTAP_359 VGND VPWR sky130_fd_sc_hd__tapvpwrvgnd_1
XFILLER_0_83_57 VPWR VGND VPWR VGND sky130_ef_sc_hd__decap_12
X_6930_ _3916_ _3713_ VGND VGND VPWR VPWR _3917_ sky130_fd_sc_hd__nand2_1
XFILLER_0_107_97 VGND VGND VPWR VPWR sky130_fd_sc_hd__decap_8
XFILLER_0_76_315 VGND VGND VPWR VPWR sky130_fd_sc_hd__decap_6
X_6861_ _3845_ _3838_ _3843_ _3839_ VGND VGND VPWR VPWR _3849_ sky130_fd_sc_hd__o211ai_4
XFILLER_0_88_197 VPWR VGND VPWR VGND sky130_ef_sc_hd__decap_12
X_5812_ _2487_ _2473_ VGND VGND VPWR VPWR _2826_ sky130_fd_sc_hd__nand2_2
X_6792_ _3741_ _3745_ _3760_ _3708_ VGND VGND VPWR VPWR _3781_ sky130_fd_sc_hd__o22ai_4
X_8600_ clknet_leaf_53_clk net136 _0351_ VGND VGND VPWR VPWR s1\[1\] sky130_fd_sc_hd__dfrtp_1
XFILLER_0_123_41 VPWR VGND VPWR VGND sky130_ef_sc_hd__decap_12
XFILLER_0_91_318 VGND VGND VPWR VPWR sky130_fd_sc_hd__fill_1
X_8531_ clknet_leaf_38_clk net228 _0282_ VGND VGND VPWR VPWR sum3\[5\] sky130_fd_sc_hd__dfrtp_1
XFILLER_0_17_404 VPWR VGND VPWR VGND sky130_ef_sc_hd__decap_12
X_5743_ _2607_ _2612_ _2609_ _2709_ VGND VGND VPWR VPWR _2759_ sky130_fd_sc_hd__a31o_1
XFILLER_0_123_85 VPWR VGND VPWR VGND sky130_ef_sc_hd__decap_12
XFILLER_0_84_392 VPWR VGND VPWR VGND sky130_ef_sc_hd__decap_12
XFILLER_0_32_83 VGND VGND VPWR VPWR sky130_fd_sc_hd__fill_1
XFILLER_0_115_634 VGND VGND VPWR VPWR sky130_fd_sc_hd__fill_1
X_8462_ clknet_leaf_27_clk net278 _0213_ VGND VGND VPWR VPWR carry5\[9\] sky130_fd_sc_hd__dfrtp_1
X_5674_ _2672_ _2523_ _2524_ VGND VGND VPWR VPWR _2691_ sky130_fd_sc_hd__nand3b_1
XFILLER_0_44_245 VGND VGND VPWR VPWR sky130_fd_sc_hd__fill_1
X_8393_ sh2\[5\] VGND VGND VPWR VPWR _1223_ sky130_fd_sc_hd__buf_4
X_4625_ sh10\[7\] _1662_ _1663_ VGND VGND VPWR VPWR _1664_ sky130_fd_sc_hd__a21o_1
X_7413_ _4149_ VGND VGND VPWR VPWR _0421_ sky130_fd_sc_hd__inv_2
X_4556_ _1550_ _1596_ _1598_ VGND VGND VPWR VPWR _1599_ sky130_fd_sc_hd__o21ai_2
XFILLER_0_102_306 VGND VGND VPWR VPWR sky130_fd_sc_hd__fill_2
X_7344_ _4142_ VGND VGND VPWR VPWR _0359_ sky130_fd_sc_hd__inv_2
XFILLER_0_102_339 VPWR VGND VPWR VGND sky130_ef_sc_hd__decap_12
XFILLER_0_12_153 VPWR VGND VPWR VGND sky130_ef_sc_hd__decap_12
XFILLER_0_4_397 VPWR VGND VPWR VGND sky130_ef_sc_hd__decap_12
XFILLER_0_40_473 VGND VGND VPWR VPWR sky130_fd_sc_hd__decap_3
X_4487_ _1484_ _1519_ _1521_ VGND VGND VPWR VPWR _1532_ sky130_fd_sc_hd__o21ai_1
X_7275_ _4134_ VGND VGND VPWR VPWR _0298_ sky130_fd_sc_hd__inv_2
XFILLER_0_12_175 VPWR VGND VPWR VGND sky130_ef_sc_hd__decap_12
XFILLER_0_40_484 VGND VGND VPWR VPWR sky130_fd_sc_hd__decap_3
X_6226_ _3228_ _3230_ _3180_ VGND VGND VPWR VPWR _3231_ sky130_fd_sc_hd__o21ai_1
X_6157_ _3157_ _3158_ _3162_ VGND VGND VPWR VPWR _3163_ sky130_fd_sc_hd__a21oi_4
XTAP_860 VGND VPWR sky130_fd_sc_hd__tapvpwrvgnd_1
XTAP_871 VGND VPWR sky130_fd_sc_hd__tapvpwrvgnd_1
XFILLER_0_57_91 VGND VGND VPWR VPWR sky130_fd_sc_hd__decap_3
X_5108_ _2068_ _2135_ _2136_ VGND VGND VPWR VPWR _2137_ sky130_fd_sc_hd__o21a_1
XTAP_882 VGND VPWR sky130_fd_sc_hd__tapvpwrvgnd_1
XTAP_893 VGND VPWR sky130_fd_sc_hd__tapvpwrvgnd_1
X_6088_ net39 _2894_ VGND VGND VPWR VPWR _3095_ sky130_fd_sc_hd__nand2_1
X_5039_ sh6\[2\] VGND VGND VPWR VPWR _2069_ sky130_fd_sc_hd__clkbuf_4
XFILLER_0_67_304 VGND VGND VPWR VPWR sky130_fd_sc_hd__decap_6
XFILLER_0_94_112 VGND VGND VPWR VPWR sky130_fd_sc_hd__decap_8
XFILLER_0_67_348 VGND VGND VPWR VPWR sky130_fd_sc_hd__fill_1
XFILLER_0_67_337 VGND VGND VPWR VPWR sky130_fd_sc_hd__decap_3
XFILLER_0_94_145 VGND VGND VPWR VPWR sky130_fd_sc_hd__fill_1
XFILLER_0_36_713 VPWR VGND VPWR VGND sky130_ef_sc_hd__decap_12
XFILLER_0_48_540 VPWR VGND VPWR VGND sky130_ef_sc_hd__decap_12
XFILLER_0_48_573 VGND VGND VPWR VPWR sky130_fd_sc_hd__decap_6
X_8729_ clknet_leaf_15_clk _0103_ _0480_ VGND VGND VPWR VPWR bit_sum6\[0\] sky130_fd_sc_hd__dfrtp_1
XFILLER_0_118_461 VGND VGND VPWR VPWR sky130_fd_sc_hd__decap_8
XFILLER_0_90_351 VPWR VGND VPWR VGND sky130_ef_sc_hd__decap_12
XFILLER_0_8_681 VPWR VGND VPWR VGND sky130_ef_sc_hd__decap_12
XFILLER_0_106_645 VPWR VGND VPWR VGND sky130_ef_sc_hd__decap_12
XFILLER_0_35_289 VGND VGND VPWR VPWR sky130_fd_sc_hd__fill_1
XFILLER_0_106_678 VPWR VGND VPWR VGND sky130_ef_sc_hd__decap_12
XFILLER_0_105_144 VGND VGND VPWR VPWR sky130_fd_sc_hd__decap_6
XFILLER_0_31_440 VGND VGND VPWR VPWR sky130_fd_sc_hd__decap_4
XFILLER_0_120_158 VGND VGND VPWR VPWR sky130_fd_sc_hd__fill_1
XFILLER_0_120_147 VGND VGND VPWR VPWR sky130_fd_sc_hd__fill_1
Xoutput20 net20 VGND VGND VPWR VPWR led[4] sky130_fd_sc_hd__clkbuf_4
XFILLER_0_37_39 VPWR VGND VPWR VGND sky130_ef_sc_hd__decap_12
XFILLER_0_53_49 VGND VGND VPWR VPWR sky130_fd_sc_hd__decap_6
XFILLER_0_85_134 VPWR VGND VPWR VGND sky130_ef_sc_hd__decap_12
XFILLER_0_116_409 VGND VGND VPWR VPWR sky130_fd_sc_hd__decap_8
XPHY_170 VGND VGND VPWR VPWR sky130_fd_sc_hd__decap_3
XFILLER_0_54_510 VGND VGND VPWR VPWR sky130_fd_sc_hd__fill_1
XFILLER_0_39_573 VGND VGND VPWR VPWR sky130_fd_sc_hd__decap_4
XPHY_192 VGND VGND VPWR VPWR sky130_fd_sc_hd__decap_3
XPHY_181 VGND VGND VPWR VPWR sky130_fd_sc_hd__decap_3
X_4410_ _1441_ _1443_ _1445_ VGND VGND VPWR VPWR _1456_ sky130_fd_sc_hd__o21a_1
XFILLER_0_41_237 VGND VGND VPWR VPWR sky130_fd_sc_hd__fill_2
X_5390_ _2403_ _2413_ _2414_ VGND VGND VPWR VPWR _2415_ sky130_fd_sc_hd__nand3_1
X_4341_ net32 sh9\[5\] VGND VGND VPWR VPWR _1388_ sky130_fd_sc_hd__nand2_1
XFILLER_0_10_613 VGND VGND VPWR VPWR sky130_fd_sc_hd__decap_6
XFILLER_0_22_484 VPWR VGND VPWR VGND sky130_ef_sc_hd__decap_12
X_4272_ _1315_ _1317_ _1305_ _1311_ VGND VGND VPWR VPWR _1320_ sky130_fd_sc_hd__o211ai_4
XFILLER_0_10_657 VPWR VGND VPWR VGND sky130_ef_sc_hd__decap_12
X_7060_ _4035_ _4042_ _4043_ _4044_ VGND VGND VPWR VPWR _4045_ sky130_fd_sc_hd__o2bb2ai_2
X_6011_ _3015_ _2954_ _3003_ _3018_ VGND VGND VPWR VPWR _3019_ sky130_fd_sc_hd__a22oi_4
XFILLER_0_118_41 VPWR VGND VPWR VGND sky130_ef_sc_hd__decap_12
XFILLER_0_118_85 VGND VGND VPWR VPWR sky130_fd_sc_hd__fill_1
XFILLER_0_27_72 VGND VGND VPWR VPWR sky130_fd_sc_hd__decap_4
X_7962_ _0737_ _0734_ VGND VGND VPWR VPWR _0811_ sky130_fd_sc_hd__nor2_1
X_6913_ _3895_ _3900_ sh13\[1\] VGND VGND VPWR VPWR _3901_ sky130_fd_sc_hd__nand3b_1
X_7893_ _0734_ _0731_ _0733_ _0742_ VGND VGND VPWR VPWR _0743_ sky130_fd_sc_hd__o31a_1
XFILLER_0_119_225 VGND VGND VPWR VPWR sky130_fd_sc_hd__decap_8
XFILLER_0_64_307 VGND VGND VPWR VPWR sky130_fd_sc_hd__fill_1
XFILLER_0_9_434 VPWR VGND VPWR VGND sky130_ef_sc_hd__decap_12
X_6844_ sh4\[1\] sh5\[1\] VGND VGND VPWR VPWR _3832_ sky130_fd_sc_hd__and2_1
XFILLER_0_17_201 VPWR VGND VPWR VGND sky130_ef_sc_hd__decap_12
XFILLER_0_18_713 VPWR VGND VPWR VGND sky130_ef_sc_hd__decap_12
X_6775_ sh7\[1\] sh8\[1\] VGND VGND VPWR VPWR _3764_ sky130_fd_sc_hd__and2_1
XFILLER_0_72_340 VGND VGND VPWR VPWR sky130_fd_sc_hd__decap_6
X_8514_ clknet_leaf_39_clk net129 _0265_ VGND VGND VPWR VPWR sum5\[4\] sky130_fd_sc_hd__dfrtp_1
XFILLER_0_9_478 VPWR VGND VPWR VGND sky130_ef_sc_hd__decap_12
X_5726_ _2734_ _2739_ _2740_ VGND VGND VPWR VPWR _2742_ sky130_fd_sc_hd__a21o_1
X_8445_ clknet_leaf_30_clk net425 _0196_ VGND VGND VPWR VPWR carry4\[11\] sky130_fd_sc_hd__dfrtp_1
XFILLER_0_17_278 VGND VGND VPWR VPWR sky130_fd_sc_hd__fill_2
XFILLER_0_32_215 VGND VGND VPWR VPWR sky130_fd_sc_hd__fill_1
XFILLER_0_33_727 VGND VGND VPWR VPWR sky130_fd_sc_hd__fill_1
XFILLER_0_5_673 VPWR VGND VPWR VGND sky130_ef_sc_hd__decap_12
X_5657_ _2669_ _2671_ _2673_ VGND VGND VPWR VPWR _2674_ sky130_fd_sc_hd__a21boi_2
XFILLER_0_32_248 VGND VGND VPWR VPWR sky130_fd_sc_hd__fill_1
X_4608_ net40 VGND VGND VPWR VPWR _1647_ sky130_fd_sc_hd__inv_2
XFILLER_0_102_125 VGND VGND VPWR VPWR sky130_fd_sc_hd__fill_2
X_8376_ _1207_ _1208_ carry5\[13\] VGND VGND VPWR VPWR _1209_ sky130_fd_sc_hd__or3b_2
X_5588_ _2490_ sh7\[0\] VGND VGND VPWR VPWR _2606_ sky130_fd_sc_hd__nand2_1
X_4539_ _1571_ _1573_ _1575_ VGND VGND VPWR VPWR _1583_ sky130_fd_sc_hd__o21ai_1
XFILLER_0_102_158 VPWR VGND VPWR VGND sky130_ef_sc_hd__decap_12
Xhold330 _0003_ VGND VGND VPWR VPWR net372 sky130_fd_sc_hd__dlygate4sd3_1
Xhold341 s1\[8\] VGND VGND VPWR VPWR net383 sky130_fd_sc_hd__dlygate4sd3_1
X_7327_ _4140_ VGND VGND VPWR VPWR _0344_ sky130_fd_sc_hd__inv_2
Xhold352 sum1\[6\] VGND VGND VPWR VPWR net394 sky130_fd_sc_hd__dlygate4sd3_1
Xhold374 _0039_ VGND VGND VPWR VPWR net416 sky130_fd_sc_hd__dlygate4sd3_1
Xhold396 carry5\[6\] VGND VGND VPWR VPWR net438 sky130_fd_sc_hd__dlygate4sd3_1
X_7258_ _4133_ VGND VGND VPWR VPWR _0282_ sky130_fd_sc_hd__inv_2
Xhold385 sh0\[1\] VGND VGND VPWR VPWR net427 sky130_fd_sc_hd__dlygate4sd3_1
XFILLER_0_7_93 VPWR VGND VPWR VGND sky130_ef_sc_hd__decap_12
Xhold363 sum1\[5\] VGND VGND VPWR VPWR net405 sky130_fd_sc_hd__dlygate4sd3_1
X_6209_ _3212_ _3213_ VGND VGND VPWR VPWR _3214_ sky130_fd_sc_hd__or2_2
X_7189_ _4127_ VGND VGND VPWR VPWR _0219_ sky130_fd_sc_hd__inv_2
XTAP_690 VGND VPWR sky130_fd_sc_hd__tapvpwrvgnd_1
XTAP_1834 VGND VPWR sky130_fd_sc_hd__tapvpwrvgnd_1
XTAP_1823 VGND VPWR sky130_fd_sc_hd__tapvpwrvgnd_1
XTAP_1801 VGND VPWR sky130_fd_sc_hd__tapvpwrvgnd_1
XTAP_1812 VGND VPWR sky130_fd_sc_hd__tapvpwrvgnd_1
Xclkbuf_3_6__f_clk clknet_0_clk VGND VGND VPWR VPWR clknet_3_6__leaf_clk sky130_fd_sc_hd__clkbuf_16
XTAP_1867 VGND VPWR sky130_fd_sc_hd__tapvpwrvgnd_1
XTAP_1856 VGND VPWR sky130_fd_sc_hd__tapvpwrvgnd_1
XTAP_1845 VGND VPWR sky130_fd_sc_hd__tapvpwrvgnd_1
XFILLER_0_95_476 VGND VGND VPWR VPWR sky130_fd_sc_hd__decap_8
XTAP_1878 VGND VPWR sky130_fd_sc_hd__tapvpwrvgnd_1
XFILLER_0_36_521 VGND VGND VPWR VPWR sky130_fd_sc_hd__decap_8
XFILLER_0_91_660 VPWR VGND VPWR VGND sky130_ef_sc_hd__decap_12
XFILLER_0_106_475 VGND VGND VPWR VPWR sky130_fd_sc_hd__fill_1
XFILLER_0_2_109 VPWR VGND VPWR VGND sky130_ef_sc_hd__decap_12
XFILLER_0_51_557 VGND VGND VPWR VPWR sky130_fd_sc_hd__decap_3
XFILLER_0_106_497 VGND VGND VPWR VPWR sky130_fd_sc_hd__fill_2
XFILLER_0_121_445 VGND VGND VPWR VPWR sky130_fd_sc_hd__decap_3
XFILLER_0_31_270 VGND VGND VPWR VPWR sky130_fd_sc_hd__fill_2
XFILLER_0_102_681 VPWR VGND VPWR VGND sky130_ef_sc_hd__decap_12
XFILLER_0_31_281 VPWR VGND VPWR VGND sky130_ef_sc_hd__decap_12
XFILLER_0_48_27 VGND VGND VPWR VPWR sky130_fd_sc_hd__fill_1
XFILLER_0_64_15 VGND VGND VPWR VPWR sky130_fd_sc_hd__fill_1
XFILLER_0_59_613 VGND VGND VPWR VPWR sky130_fd_sc_hd__decap_3
X_4890_ _1919_ _1920_ _1921_ VGND VGND VPWR VPWR _1925_ sky130_fd_sc_hd__a21oi_2
XFILLER_0_74_605 VGND VGND VPWR VPWR sky130_fd_sc_hd__fill_1
XFILLER_0_117_707 VPWR VGND VPWR VGND sky130_ef_sc_hd__decap_12
XFILLER_0_27_521 VGND VGND VPWR VPWR sky130_fd_sc_hd__decap_3
XFILLER_0_117_729 VGND VGND VPWR VPWR sky130_fd_sc_hd__decap_6
X_6560_ _3294_ sh5\[4\] sh6\[4\] VGND VGND VPWR VPWR _3556_ sky130_fd_sc_hd__o21ai_4
X_5511_ _2529_ _2499_ _2488_ VGND VGND VPWR VPWR _2530_ sky130_fd_sc_hd__o21ai_2
XFILLER_0_15_727 VGND VGND VPWR VPWR sky130_fd_sc_hd__fill_1
X_6491_ _3295_ _3297_ _3289_ VGND VGND VPWR VPWR _3488_ sky130_fd_sc_hd__o21ai_1
XFILLER_0_14_215 VPWR VGND VPWR VGND sky130_ef_sc_hd__decap_12
XFILLER_0_120_53 VPWR VGND VPWR VGND sky130_ef_sc_hd__decap_12
X_8230_ _1051_ _1070_ _1074_ VGND VGND VPWR VPWR _1075_ sky130_fd_sc_hd__o21ai_2
X_5442_ _2455_ _2458_ _2457_ VGND VGND VPWR VPWR _2464_ sky130_fd_sc_hd__a21bo_1
XFILLER_0_120_97 VPWR VGND VPWR VGND sky130_ef_sc_hd__decap_12
X_8161_ _0730_ _0750_ VGND VGND VPWR VPWR _1007_ sky130_fd_sc_hd__or2_1
XFILLER_0_2_643 VGND VGND VPWR VPWR sky130_fd_sc_hd__fill_1
X_5373_ _2333_ _2329_ VGND VGND VPWR VPWR _2398_ sky130_fd_sc_hd__and2_1
X_4324_ _1243_ _1247_ _1354_ VGND VGND VPWR VPWR _1371_ sky130_fd_sc_hd__a21oi_1
X_8092_ _0869_ _0870_ _0874_ VGND VGND VPWR VPWR _0939_ sky130_fd_sc_hd__o21ai_4
XFILLER_0_10_421 VGND VGND VPWR VPWR sky130_fd_sc_hd__decap_6
XFILLER_0_22_292 VPWR VGND VPWR VGND sky130_ef_sc_hd__decap_12
X_7112_ _4055_ _4059_ _4095_ _4066_ VGND VGND VPWR VPWR _4096_ sky130_fd_sc_hd__o211ai_1
X_7043_ _4024_ _4027_ sh14\[1\] VGND VGND VPWR VPWR _4028_ sky130_fd_sc_hd__o21ba_1
X_4255_ _1292_ _1296_ _1302_ VGND VGND VPWR VPWR _1303_ sky130_fd_sc_hd__nand3_1
XFILLER_0_89_281 VGND VGND VPWR VPWR sky130_fd_sc_hd__fill_1
XFILLER_0_77_432 VPWR VGND VPWR VGND sky130_ef_sc_hd__decap_12
XTAP_1119 VGND VPWR sky130_fd_sc_hd__tapvpwrvgnd_1
XTAP_1108 VGND VPWR sky130_fd_sc_hd__tapvpwrvgnd_1
X_7945_ _0746_ _0747_ net35 VGND VGND VPWR VPWR _0794_ sky130_fd_sc_hd__o21a_1
X_7876_ sh12\[3\] VGND VGND VPWR VPWR _0726_ sky130_fd_sc_hd__clkbuf_4
XFILLER_0_49_145 VGND VGND VPWR VPWR sky130_fd_sc_hd__decap_4
XFILLER_0_65_627 VPWR VGND VPWR VGND sky130_ef_sc_hd__decap_12
X_6827_ _3750_ _3768_ sh14\[1\] _3803_ VGND VGND VPWR VPWR _3816_ sky130_fd_sc_hd__o211a_1
XFILLER_0_49_167 VGND VGND VPWR VPWR sky130_fd_sc_hd__fill_1
X_6758_ sh0\[1\] sh3\[1\] VGND VGND VPWR VPWR _3747_ sky130_fd_sc_hd__nor2_2
XFILLER_0_9_297 VGND VGND VPWR VPWR sky130_fd_sc_hd__decap_4
XFILLER_0_33_502 VGND VGND VPWR VPWR sky130_fd_sc_hd__fill_2
XFILLER_0_122_209 VPWR VGND VPWR VGND sky130_ef_sc_hd__decap_12
X_6689_ _3676_ _3679_ _3682_ VGND VGND VPWR VPWR _3683_ sky130_fd_sc_hd__o21ai_2
XFILLER_0_73_693 VGND VGND VPWR VPWR sky130_fd_sc_hd__fill_1
XFILLER_0_72_192 VGND VGND VPWR VPWR sky130_fd_sc_hd__decap_4
XFILLER_0_60_321 VPWR VGND VPWR VGND sky130_ef_sc_hd__decap_12
X_5709_ _2689_ _2693_ _2677_ VGND VGND VPWR VPWR _2725_ sky130_fd_sc_hd__a21oi_1
X_8428_ _1230_ _1257_ VGND VGND VPWR VPWR _1258_ sky130_fd_sc_hd__or2_1
XFILLER_0_33_579 VGND VGND VPWR VPWR sky130_fd_sc_hd__fill_1
X_8359_ _1192_ _1193_ VGND VGND VPWR VPWR _1194_ sky130_fd_sc_hd__nor2_1
Xhold160 sh2\[6\] VGND VGND VPWR VPWR net202 sky130_fd_sc_hd__dlygate4sd3_1
Xhold171 sh3\[4\] VGND VGND VPWR VPWR net213 sky130_fd_sc_hd__dlygate4sd3_1
XFILLER_0_13_281 VGND VGND VPWR VPWR sky130_fd_sc_hd__decap_6
Xhold182 sh5\[7\] VGND VGND VPWR VPWR net224 sky130_fd_sc_hd__dlygate4sd3_1
Xhold193 _0029_ VGND VGND VPWR VPWR net235 sky130_fd_sc_hd__dlygate4sd3_1
XFILLER_0_88_719 VGND VGND VPWR VPWR sky130_fd_sc_hd__decap_8
XFILLER_0_34_29 VPWR VGND VPWR VGND sky130_ef_sc_hd__decap_12
XTAP_1631 VGND VPWR sky130_fd_sc_hd__tapvpwrvgnd_1
XTAP_1642 VGND VPWR sky130_fd_sc_hd__tapvpwrvgnd_1
XTAP_1620 VGND VPWR sky130_fd_sc_hd__tapvpwrvgnd_1
XTAP_1675 VGND VPWR sky130_fd_sc_hd__tapvpwrvgnd_1
XTAP_1664 VGND VPWR sky130_fd_sc_hd__tapvpwrvgnd_1
XTAP_1653 VGND VPWR sky130_fd_sc_hd__tapvpwrvgnd_1
XFILLER_0_95_284 VGND VGND VPWR VPWR sky130_fd_sc_hd__decap_4
XTAP_1697 VGND VPWR sky130_fd_sc_hd__tapvpwrvgnd_1
XTAP_1686 VGND VPWR sky130_fd_sc_hd__tapvpwrvgnd_1
XFILLER_0_83_457 VPWR VGND VPWR VGND sky130_ef_sc_hd__decap_12
XFILLER_0_55_137 VGND VGND VPWR VPWR sky130_fd_sc_hd__decap_6
XFILLER_0_91_490 VGND VGND VPWR VPWR sky130_fd_sc_hd__decap_8
XFILLER_0_63_181 VPWR VGND VPWR VGND sky130_ef_sc_hd__decap_12
XFILLER_0_24_557 VPWR VGND VPWR VGND sky130_ef_sc_hd__decap_12
XFILLER_0_121_242 VGND VGND VPWR VPWR sky130_fd_sc_hd__decap_6
XFILLER_0_75_69 VPWR VGND VPWR VGND sky130_ef_sc_hd__decap_12
XFILLER_0_78_207 VGND VGND VPWR VPWR sky130_fd_sc_hd__fill_1
X_5991_ sh1\[6\] sh2\[6\] VGND VGND VPWR VPWR _2999_ sky130_fd_sc_hd__and2_1
X_4942_ _1662_ _1722_ sh15\[7\] VGND VGND VPWR VPWR _1976_ sky130_fd_sc_hd__a21oi_2
X_7730_ _0636_ _0637_ net319 VGND VGND VPWR VPWR _0638_ sky130_fd_sc_hd__o21ai_1
XFILLER_0_115_97 VGND VGND VPWR VPWR sky130_fd_sc_hd__decap_6
XFILLER_0_115_75 VGND VGND VPWR VPWR sky130_fd_sc_hd__fill_1
XFILLER_0_74_402 VPWR VGND VPWR VGND sky130_ef_sc_hd__decap_12
X_7661_ _4186_ _4187_ net333 VGND VGND VPWR VPWR _4188_ sky130_fd_sc_hd__o21ai_1
XFILLER_0_19_307 VPWR VGND VPWR VGND sky130_ef_sc_hd__decap_12
X_4873_ _1900_ sh15\[7\] _1898_ VGND VGND VPWR VPWR _1908_ sky130_fd_sc_hd__a21o_1
X_6612_ _3302_ _3289_ _3602_ VGND VGND VPWR VPWR _3607_ sky130_fd_sc_hd__a21o_1
XFILLER_0_117_559 VGND VGND VPWR VPWR sky130_fd_sc_hd__fill_1
X_7592_ _4166_ VGND VGND VPWR VPWR _0583_ sky130_fd_sc_hd__inv_2
XFILLER_0_55_671 VGND VGND VPWR VPWR sky130_fd_sc_hd__fill_1
XFILLER_0_104_209 VPWR VGND VPWR VGND sky130_ef_sc_hd__decap_12
X_6543_ _3538_ _3539_ sh15\[4\] VGND VGND VPWR VPWR _3540_ sky130_fd_sc_hd__nand3_2
XFILLER_0_113_732 VGND VGND VPWR VPWR sky130_fd_sc_hd__decap_3
XFILLER_0_113_721 VGND VGND VPWR VPWR sky130_fd_sc_hd__decap_6
X_6474_ _3465_ _3469_ _3391_ VGND VGND VPWR VPWR _3472_ sky130_fd_sc_hd__nand3_2
XFILLER_0_15_579 VPWR VGND VPWR VGND sky130_ef_sc_hd__decap_12
XFILLER_0_40_83 VGND VGND VPWR VPWR sky130_fd_sc_hd__fill_1
XFILLER_0_42_365 VGND VGND VPWR VPWR sky130_fd_sc_hd__fill_2
XFILLER_0_112_242 VGND VGND VPWR VPWR sky130_fd_sc_hd__fill_1
X_8213_ sh4\[3\] _0772_ sh6\[3\] VGND VGND VPWR VPWR _1058_ sky130_fd_sc_hd__o21ai_2
X_5425_ _2419_ _2425_ _2448_ VGND VGND VPWR VPWR _2449_ sky130_fd_sc_hd__a21o_1
XFILLER_0_64_3 VPWR VGND VPWR VGND sky130_ef_sc_hd__decap_12
XFILLER_0_30_549 VPWR VGND VPWR VGND sky130_ef_sc_hd__decap_12
X_5356_ _2378_ _2380_ sh6\[2\] VGND VGND VPWR VPWR _2381_ sky130_fd_sc_hd__o21bai_4
X_8144_ _0989_ _0990_ sh15\[3\] VGND VGND VPWR VPWR _0991_ sky130_fd_sc_hd__nand3_2
X_4307_ _1242_ sh5\[5\] net34 VGND VGND VPWR VPWR _1354_ sky130_fd_sc_hd__o21ai_4
X_5287_ _2312_ _2313_ VGND VGND VPWR VPWR _2314_ sky130_fd_sc_hd__or2b_1
X_8075_ _0915_ _0922_ sh13\[3\] VGND VGND VPWR VPWR _0923_ sky130_fd_sc_hd__nand3b_1
X_4238_ _1267_ _1270_ _1273_ _1280_ _1285_ VGND VGND VPWR VPWR _1286_ sky130_fd_sc_hd__a32oi_4
X_7026_ _4010_ _4011_ VGND VGND VPWR VPWR _4012_ sky130_fd_sc_hd__nand2_1
XFILLER_0_4_83 VGND VGND VPWR VPWR sky130_fd_sc_hd__fill_1
X_7928_ _0773_ _0775_ _0776_ VGND VGND VPWR VPWR _0777_ sky130_fd_sc_hd__o21ai_2
XFILLER_0_37_104 VGND VGND VPWR VPWR sky130_fd_sc_hd__fill_1
XFILLER_0_38_616 VGND VGND VPWR VPWR sky130_fd_sc_hd__decap_6
XFILLER_0_108_526 VGND VGND VPWR VPWR sky130_fd_sc_hd__decap_6
X_7859_ net360 s6\[12\] sum4\[12\] VGND VGND VPWR VPWR _0715_ sky130_fd_sc_hd__a21o_1
XFILLER_0_77_295 VPWR VGND VPWR VGND sky130_ef_sc_hd__decap_12
XFILLER_0_46_693 VGND VGND VPWR VPWR sky130_fd_sc_hd__decap_6
XFILLER_0_21_505 VPWR VGND VPWR VGND sky130_ef_sc_hd__decap_12
XFILLER_0_45_192 VPWR VGND VPWR VGND sky130_ef_sc_hd__decap_12
XFILLER_0_61_685 VGND VGND VPWR VPWR sky130_fd_sc_hd__decap_4
XFILLER_0_103_297 VGND VGND VPWR VPWR sky130_fd_sc_hd__decap_4
XTAP_1450 VGND VPWR sky130_fd_sc_hd__tapvpwrvgnd_1
XFILLER_0_84_733 VGND VGND VPWR VPWR sky130_fd_sc_hd__fill_2
XFILLER_0_68_273 VGND VGND VPWR VPWR sky130_fd_sc_hd__decap_4
XTAP_1483 VGND VPWR sky130_fd_sc_hd__tapvpwrvgnd_1
XTAP_1461 VGND VPWR sky130_fd_sc_hd__tapvpwrvgnd_1
XTAP_1472 VGND VPWR sky130_fd_sc_hd__tapvpwrvgnd_1
XFILLER_0_56_457 VGND VGND VPWR VPWR sky130_fd_sc_hd__fill_2
XTAP_1494 VGND VPWR sky130_fd_sc_hd__tapvpwrvgnd_1
XFILLER_0_71_405 VPWR VGND VPWR VGND sky130_ef_sc_hd__decap_12
XFILLER_0_37_660 VPWR VGND VPWR VGND sky130_ef_sc_hd__decap_12
XFILLER_0_83_287 VPWR VGND VPWR VGND sky130_ef_sc_hd__decap_12
XFILLER_0_9_39 VPWR VGND VPWR VGND sky130_ef_sc_hd__decap_12
XFILLER_0_10_53 VPWR VGND VPWR VGND sky130_ef_sc_hd__decap_12
XFILLER_0_3_237 VPWR VGND VPWR VGND sky130_ef_sc_hd__decap_12
XFILLER_0_110_713 VPWR VGND VPWR VGND sky130_ef_sc_hd__decap_12
X_5210_ _2234_ _2235_ _2237_ VGND VGND VPWR VPWR _2238_ sky130_fd_sc_hd__o21ai_2
XFILLER_0_10_97 VPWR VGND VPWR VGND sky130_ef_sc_hd__decap_12
X_6190_ _2923_ _3033_ VGND VGND VPWR VPWR _3195_ sky130_fd_sc_hd__nor2_1
X_5141_ _2073_ _2074_ _2104_ VGND VGND VPWR VPWR _2170_ sky130_fd_sc_hd__and3_1
X_5072_ _2086_ _2087_ _2098_ _2100_ VGND VGND VPWR VPWR _2101_ sky130_fd_sc_hd__o211ai_4
X_8831_ clknet_leaf_4_clk net330 _0582_ VGND VGND VPWR VPWR sh10\[3\] sky130_fd_sc_hd__dfrtp_4
X_8762_ clknet_leaf_7_clk net238 _0513_ VGND VGND VPWR VPWR sh1\[6\] sky130_fd_sc_hd__dfrtp_1
X_5974_ _2935_ _2942_ _2934_ VGND VGND VPWR VPWR _2983_ sky130_fd_sc_hd__a21oi_2
X_7713_ net265 _0628_ VGND VGND VPWR VPWR _0065_ sky130_fd_sc_hd__xnor2_1
X_4925_ _1652_ _1641_ _1636_ VGND VGND VPWR VPWR _1959_ sky130_fd_sc_hd__o21a_1
XFILLER_0_74_221 VGND VGND VPWR VPWR sky130_fd_sc_hd__fill_1
X_8693_ clknet_leaf_57_clk _0157_ _0444_ VGND VGND VPWR VPWR bit_sum2\[4\] sky130_fd_sc_hd__dfrtp_1
XFILLER_0_47_424 VPWR VGND VPWR VGND sky130_ef_sc_hd__decap_12
X_4856_ _1889_ _1891_ VGND VGND VPWR VPWR _1892_ sky130_fd_sc_hd__nand2_2
XFILLER_0_90_725 VGND VGND VPWR VPWR sky130_fd_sc_hd__decap_8
XFILLER_0_74_265 VPWR VGND VPWR VGND sky130_ef_sc_hd__decap_12
X_7644_ sum3\[6\] carry3\[5\] VGND VGND VPWR VPWR _4174_ sky130_fd_sc_hd__and2_1
XFILLER_0_19_159 VGND VGND VPWR VPWR sky130_fd_sc_hd__decap_8
XFILLER_0_105_518 VGND VGND VPWR VPWR sky130_fd_sc_hd__decap_8
X_7575_ _4164_ VGND VGND VPWR VPWR _0568_ sky130_fd_sc_hd__inv_2
XFILLER_0_15_321 VGND VGND VPWR VPWR sky130_fd_sc_hd__fill_1
XFILLER_0_43_630 VPWR VGND VPWR VGND sky130_ef_sc_hd__decap_12
XFILLER_0_51_82 VGND VGND VPWR VPWR sky130_fd_sc_hd__fill_2
X_4787_ _1818_ _1808_ _1823_ VGND VGND VPWR VPWR _1824_ sky130_fd_sc_hd__a21o_1
X_6526_ _3503_ _3505_ _3514_ VGND VGND VPWR VPWR _3523_ sky130_fd_sc_hd__o21bai_2
XFILLER_0_55_490 VGND VGND VPWR VPWR sky130_fd_sc_hd__decap_4
XFILLER_0_30_302 VGND VGND VPWR VPWR sky130_fd_sc_hd__decap_6
XFILLER_0_43_685 VPWR VGND VPWR VGND sky130_ef_sc_hd__decap_12
X_6457_ _3447_ _3450_ _3454_ VGND VGND VPWR VPWR _3455_ sky130_fd_sc_hd__o21a_1
XFILLER_0_30_335 VGND VGND VPWR VPWR sky130_fd_sc_hd__fill_1
X_6388_ _3383_ _3385_ _3386_ VGND VGND VPWR VPWR _3387_ sky130_fd_sc_hd__nand3_1
X_5408_ _2431_ _2383_ _2382_ _2389_ _2388_ VGND VGND VPWR VPWR _2432_ sky130_fd_sc_hd__a221oi_2
XFILLER_0_100_267 VGND VGND VPWR VPWR sky130_fd_sc_hd__fill_2
XFILLER_0_100_245 VGND VGND VPWR VPWR sky130_fd_sc_hd__decap_6
X_5339_ _2301_ _2305_ _2309_ _2364_ VGND VGND VPWR VPWR _2365_ sky130_fd_sc_hd__o211ai_4
X_8127_ _0968_ _0970_ _0973_ VGND VGND VPWR VPWR _0974_ sky130_fd_sc_hd__nand3_4
XFILLER_0_100_289 VGND VGND VPWR VPWR sky130_fd_sc_hd__decap_4
X_8058_ _0838_ _0860_ _0898_ _0905_ VGND VGND VPWR VPWR _0906_ sky130_fd_sc_hd__o211ai_4
X_7009_ _3920_ _3923_ VGND VGND VPWR VPWR _3995_ sky130_fd_sc_hd__nand2_1
XFILLER_0_97_335 VGND VGND VPWR VPWR sky130_fd_sc_hd__fill_1
XFILLER_0_97_346 VGND VGND VPWR VPWR sky130_fd_sc_hd__decap_4
XFILLER_0_66_733 VGND VGND VPWR VPWR sky130_fd_sc_hd__fill_2
XFILLER_0_65_221 VGND VGND VPWR VPWR sky130_fd_sc_hd__decap_3
XFILLER_0_65_243 VPWR VGND VPWR VGND sky130_ef_sc_hd__decap_12
XFILLER_0_25_107 VGND VGND VPWR VPWR sky130_fd_sc_hd__fill_2
XFILLER_0_93_585 VGND VGND VPWR VPWR sky130_fd_sc_hd__decap_8
XFILLER_0_53_449 VGND VGND VPWR VPWR sky130_fd_sc_hd__decap_8
XFILLER_0_19_671 VGND VGND VPWR VPWR sky130_fd_sc_hd__fill_1
XFILLER_0_25_129 VGND VGND VPWR VPWR sky130_fd_sc_hd__fill_2
XFILLER_0_80_268 VPWR VGND VPWR VGND sky130_ef_sc_hd__decap_12
XFILLER_0_80_246 VGND VGND VPWR VPWR sky130_fd_sc_hd__decap_6
XFILLER_0_123_337 VPWR VGND VPWR VGND sky130_ef_sc_hd__decap_12
XFILLER_0_61_493 VGND VGND VPWR VPWR sky130_fd_sc_hd__decap_8
XTAP_508 VGND VPWR sky130_fd_sc_hd__tapvpwrvgnd_1
XTAP_519 VGND VPWR sky130_fd_sc_hd__tapvpwrvgnd_1
XFILLER_0_56_49 VPWR VGND VPWR VGND sky130_ef_sc_hd__decap_12
Xclkbuf_leaf_58_clk clknet_3_1__leaf_clk VGND VGND VPWR VPWR clknet_leaf_58_clk sky130_fd_sc_hd__clkbuf_16
XFILLER_0_72_15 VPWR VGND VPWR VGND sky130_ef_sc_hd__decap_12
XFILLER_0_84_541 VGND VGND VPWR VPWR sky130_fd_sc_hd__fill_2
XFILLER_0_8_307 VGND VGND VPWR VPWR sky130_fd_sc_hd__fill_1
X_4710_ _1745_ _1746_ _1743_ VGND VGND VPWR VPWR _1748_ sky130_fd_sc_hd__a21oi_1
XFILLER_0_84_563 VGND VGND VPWR VPWR sky130_fd_sc_hd__decap_6
XTAP_1291 VGND VPWR sky130_fd_sc_hd__tapvpwrvgnd_1
XTAP_1280 VGND VPWR sky130_fd_sc_hd__tapvpwrvgnd_1
XFILLER_0_8_329 VPWR VGND VPWR VGND sky130_ef_sc_hd__decap_12
X_5690_ net30 sh12\[0\] _2610_ VGND VGND VPWR VPWR _2707_ sky130_fd_sc_hd__a21oi_1
XFILLER_0_122_3 VPWR VGND VPWR VGND sky130_ef_sc_hd__decap_12
X_4641_ _1678_ _1676_ VGND VGND VPWR VPWR _1679_ sky130_fd_sc_hd__nor2_1
XFILLER_0_16_118 VGND VGND VPWR VPWR sky130_fd_sc_hd__decap_4
XFILLER_0_114_304 VGND VGND VPWR VPWR sky130_fd_sc_hd__decap_4
XFILLER_0_112_65 VPWR VGND VPWR VGND sky130_ef_sc_hd__decap_12
XFILLER_0_21_63 VGND VGND VPWR VPWR sky130_fd_sc_hd__decap_4
X_4572_ _1571_ _1612_ _1613_ _1614_ VGND VGND VPWR VPWR _1615_ sky130_fd_sc_hd__o211ai_4
XFILLER_0_25_685 VPWR VGND VPWR VGND sky130_ef_sc_hd__decap_12
X_7360_ _4143_ VGND VGND VPWR VPWR _0374_ sky130_fd_sc_hd__inv_2
X_6311_ sh6\[4\] VGND VGND VPWR VPWR _3311_ sky130_fd_sc_hd__inv_2
X_7291_ _4137_ VGND VGND VPWR VPWR _0311_ sky130_fd_sc_hd__inv_2
XFILLER_0_24_195 VGND VGND VPWR VPWR sky130_fd_sc_hd__fill_1
XFILLER_0_122_392 VGND VGND VPWR VPWR sky130_fd_sc_hd__decap_8
X_6242_ _3209_ _3202_ VGND VGND VPWR VPWR _3246_ sky130_fd_sc_hd__nand2_1
XFILLER_0_40_677 VPWR VGND VPWR VGND sky130_ef_sc_hd__decap_12
XFILLER_0_110_587 VGND VGND VPWR VPWR sky130_fd_sc_hd__fill_1
X_6173_ _3174_ _3177_ _3178_ VGND VGND VPWR VPWR _3179_ sky130_fd_sc_hd__o21ai_1
X_5124_ _2152_ _2145_ _2137_ VGND VGND VPWR VPWR _2153_ sky130_fd_sc_hd__a21o_1
X_5055_ _2082_ _2084_ VGND VGND VPWR VPWR _2085_ sky130_fd_sc_hd__and2b_1
Xclkbuf_leaf_49_clk clknet_3_4__leaf_clk VGND VGND VPWR VPWR clknet_leaf_49_clk sky130_fd_sc_hd__clkbuf_16
X_8814_ clknet_leaf_62_clk net292 _0565_ VGND VGND VPWR VPWR sh8\[2\] sky130_fd_sc_hd__dfrtp_1
XFILLER_0_1_51 VGND VGND VPWR VPWR sky130_fd_sc_hd__decap_4
X_5957_ _2953_ _2957_ _2962_ VGND VGND VPWR VPWR _2966_ sky130_fd_sc_hd__nand3_1
X_8745_ clknet_leaf_23_clk _0186_ _0496_ VGND VGND VPWR VPWR bit_sum7\[6\] sky130_fd_sc_hd__dfrtp_1
XFILLER_0_48_733 VGND VGND VPWR VPWR sky130_fd_sc_hd__fill_2
XFILLER_0_118_610 VGND VGND VPWR VPWR sky130_fd_sc_hd__fill_1
X_4908_ _1942_ _1938_ _1909_ VGND VGND VPWR VPWR _1943_ sky130_fd_sc_hd__o21ai_1
X_8676_ clknet_leaf_43_clk _0178_ _0427_ VGND VGND VPWR VPWR bit_sum0\[7\] sky130_fd_sc_hd__dfrtp_1
X_7627_ _4169_ VGND VGND VPWR VPWR _0615_ sky130_fd_sc_hd__inv_2
X_5888_ _2895_ _2896_ _2893_ VGND VGND VPWR VPWR _2898_ sky130_fd_sc_hd__o21a_1
X_4839_ _1677_ _1838_ _1839_ VGND VGND VPWR VPWR _1875_ sky130_fd_sc_hd__o21a_1
XFILLER_0_7_384 VGND VGND VPWR VPWR sky130_fd_sc_hd__decap_8
XFILLER_0_105_337 VGND VGND VPWR VPWR sky130_fd_sc_hd__fill_2
X_7558_ _4163_ VGND VGND VPWR VPWR _0552_ sky130_fd_sc_hd__inv_2
XFILLER_0_62_268 VGND VGND VPWR VPWR sky130_fd_sc_hd__decap_8
XFILLER_0_50_419 VGND VGND VPWR VPWR sky130_fd_sc_hd__fill_1
XFILLER_0_120_307 VGND VGND VPWR VPWR sky130_fd_sc_hd__fill_1
X_7489_ _4156_ VGND VGND VPWR VPWR _0490_ sky130_fd_sc_hd__inv_2
X_6509_ sh4\[4\] _3306_ VGND VGND VPWR VPWR _3506_ sky130_fd_sc_hd__nand2_1
XFILLER_0_31_666 VGND VGND VPWR VPWR sky130_fd_sc_hd__decap_6
Xhold31 bit_sum1\[6\] VGND VGND VPWR VPWR net73 sky130_fd_sc_hd__dlygate4sd3_1
Xhold20 s2\[11\] VGND VGND VPWR VPWR net62 sky130_fd_sc_hd__dlygate4sd3_1
Xhold53 final_sum\[8\] VGND VGND VPWR VPWR net95 sky130_fd_sc_hd__dlygate4sd3_1
Xhold42 bit_sum2\[2\] VGND VGND VPWR VPWR net84 sky130_fd_sc_hd__dlygate4sd3_1
Xhold64 bit_sum0\[7\] VGND VGND VPWR VPWR net106 sky130_fd_sc_hd__dlygate4sd3_1
Xhold86 final_sum\[10\] VGND VGND VPWR VPWR net128 sky130_fd_sc_hd__dlygate4sd3_1
Xhold75 bit_sum4\[5\] VGND VGND VPWR VPWR net117 sky130_fd_sc_hd__dlygate4sd3_1
Xhold97 bit_sum0\[1\] VGND VGND VPWR VPWR net139 sky130_fd_sc_hd__dlygate4sd3_1
XFILLER_0_98_699 VGND VGND VPWR VPWR sky130_fd_sc_hd__fill_1
XFILLER_0_58_519 VGND VGND VPWR VPWR sky130_fd_sc_hd__decap_6
XFILLER_0_38_221 VPWR VGND VPWR VGND sky130_ef_sc_hd__decap_12
XFILLER_0_42_29 VPWR VGND VPWR VGND sky130_ef_sc_hd__decap_12
XFILLER_0_109_632 VGND VGND VPWR VPWR sky130_fd_sc_hd__decap_3
XFILLER_0_26_405 VPWR VGND VPWR VGND sky130_ef_sc_hd__decap_12
XFILLER_0_38_265 VGND VGND VPWR VPWR sky130_fd_sc_hd__decap_3
XFILLER_0_109_643 VGND VGND VPWR VPWR sky130_fd_sc_hd__decap_3
XFILLER_0_108_131 VGND VGND VPWR VPWR sky130_fd_sc_hd__decap_8
XFILLER_0_81_500 VGND VGND VPWR VPWR sky130_fd_sc_hd__decap_4
XFILLER_0_108_175 VPWR VGND VPWR VGND sky130_ef_sc_hd__decap_12
XFILLER_0_53_235 VGND VGND VPWR VPWR sky130_fd_sc_hd__decap_6
XFILLER_0_108_197 VPWR VGND VPWR VGND sky130_ef_sc_hd__decap_12
XFILLER_0_41_408 VGND VGND VPWR VPWR sky130_fd_sc_hd__fill_1
XFILLER_0_1_505 VPWR VGND VPWR VGND sky130_ef_sc_hd__decap_12
XFILLER_0_6_29 VPWR VGND VPWR VGND sky130_ef_sc_hd__decap_12
XFILLER_0_67_15 VGND VGND VPWR VPWR sky130_fd_sc_hd__fill_1
XTAP_305 VGND VPWR sky130_fd_sc_hd__tapvpwrvgnd_1
XFILLER_0_22_699 VGND VGND VPWR VPWR sky130_fd_sc_hd__fill_1
XTAP_349 VGND VPWR sky130_fd_sc_hd__tapvpwrvgnd_1
XTAP_338 VGND VPWR sky130_fd_sc_hd__tapvpwrvgnd_1
XTAP_327 VGND VPWR sky130_fd_sc_hd__tapvpwrvgnd_1
XTAP_316 VGND VPWR sky130_fd_sc_hd__tapvpwrvgnd_1
XFILLER_0_83_69 VPWR VGND VPWR VGND sky130_ef_sc_hd__decap_12
XFILLER_0_107_65 VGND VGND VPWR VPWR sky130_fd_sc_hd__fill_2
XFILLER_0_107_54 VGND VGND VPWR VPWR sky130_fd_sc_hd__fill_2
XFILLER_0_16_41 VPWR VGND VPWR VGND sky130_ef_sc_hd__decap_12
X_6860_ _3839_ _3842_ _3843_ VGND VGND VPWR VPWR _3848_ sky130_fd_sc_hd__a21o_1
X_6791_ _3745_ _3746_ _3734_ _3733_ _3748_ VGND VGND VPWR VPWR _3780_ sky130_fd_sc_hd__o221a_2
X_5811_ _2521_ _2672_ VGND VGND VPWR VPWR _2825_ sky130_fd_sc_hd__and2_1
XFILLER_0_123_53 VGND VGND VPWR VPWR sky130_fd_sc_hd__decap_3
X_8530_ clknet_leaf_39_clk net221 _0281_ VGND VGND VPWR VPWR sum3\[4\] sky130_fd_sc_hd__dfrtp_1
X_5742_ _2753_ _2757_ VGND VGND VPWR VPWR _2758_ sky130_fd_sc_hd__nand2_1
XFILLER_0_72_522 VGND VGND VPWR VPWR sky130_fd_sc_hd__decap_8
XFILLER_0_72_500 VGND VGND VPWR VPWR sky130_fd_sc_hd__decap_3
XFILLER_0_17_416 VGND VGND VPWR VPWR sky130_fd_sc_hd__decap_4
XFILLER_0_17_427 VPWR VGND VPWR VGND sky130_ef_sc_hd__decap_12
XFILLER_0_29_298 VPWR VGND VPWR VGND sky130_ef_sc_hd__decap_12
XFILLER_0_123_97 VPWR VGND VPWR VGND sky130_ef_sc_hd__decap_12
X_8461_ clknet_leaf_26_clk net401 _0212_ VGND VGND VPWR VPWR carry5\[8\] sky130_fd_sc_hd__dfrtp_1
XFILLER_0_17_449 VPWR VGND VPWR VGND sky130_ef_sc_hd__decap_12
X_5673_ _2519_ _2520_ _2672_ VGND VGND VPWR VPWR _2690_ sky130_fd_sc_hd__o21ai_1
XFILLER_0_44_224 VPWR VGND VPWR VGND sky130_ef_sc_hd__decap_12
XFILLER_0_115_657 VPWR VGND VPWR VGND sky130_ef_sc_hd__decap_12
X_4624_ sh10\[7\] sh11\[7\] sh12\[7\] VGND VGND VPWR VPWR _1663_ sky130_fd_sc_hd__o21ai_1
X_8392_ _1152_ _1222_ VGND VGND VPWR VPWR _0163_ sky130_fd_sc_hd__nor2_1
X_7412_ _4149_ VGND VGND VPWR VPWR _0420_ sky130_fd_sc_hd__inv_2
X_4555_ _1597_ _1557_ _1560_ VGND VGND VPWR VPWR _1598_ sky130_fd_sc_hd__o21ai_1
XFILLER_0_12_121 VGND VGND VPWR VPWR sky130_fd_sc_hd__fill_1
XFILLER_0_4_365 VGND VGND VPWR VPWR sky130_fd_sc_hd__decap_4
XFILLER_0_13_622 VGND VGND VPWR VPWR sky130_fd_sc_hd__decap_8
X_7343_ _4136_ VGND VGND VPWR VPWR _4142_ sky130_fd_sc_hd__buf_4
X_4486_ _1463_ _1471_ _1528_ _1522_ VGND VGND VPWR VPWR _1531_ sky130_fd_sc_hd__a22o_1
X_7274_ _4134_ VGND VGND VPWR VPWR _0297_ sky130_fd_sc_hd__inv_2
XFILLER_0_12_187 VGND VGND VPWR VPWR sky130_fd_sc_hd__decap_4
XFILLER_0_12_165 VGND VGND VPWR VPWR sky130_fd_sc_hd__fill_2
X_6225_ _3224_ _3227_ _3229_ VGND VGND VPWR VPWR _3230_ sky130_fd_sc_hd__a21oi_1
XFILLER_0_110_384 VPWR VGND VPWR VGND sky130_ef_sc_hd__decap_12
X_6156_ _3160_ _3161_ VGND VGND VPWR VPWR _3162_ sky130_fd_sc_hd__nand2_4
XTAP_850 VGND VPWR sky130_fd_sc_hd__tapvpwrvgnd_1
XTAP_861 VGND VPWR sky130_fd_sc_hd__tapvpwrvgnd_1
X_5107_ _2066_ _2068_ _2102_ VGND VGND VPWR VPWR _2136_ sky130_fd_sc_hd__o21bai_1
XTAP_872 VGND VPWR sky130_fd_sc_hd__tapvpwrvgnd_1
XTAP_883 VGND VPWR sky130_fd_sc_hd__tapvpwrvgnd_1
XTAP_894 VGND VPWR sky130_fd_sc_hd__tapvpwrvgnd_1
X_6087_ _3092_ _3093_ _3085_ _3090_ VGND VGND VPWR VPWR _3094_ sky130_fd_sc_hd__o211a_2
X_5038_ _2067_ VGND VGND VPWR VPWR _2068_ sky130_fd_sc_hd__clkbuf_2
XFILLER_0_95_647 VPWR VGND VPWR VGND sky130_ef_sc_hd__decap_12
X_8728_ clknet_leaf_16_clk _0135_ _0479_ VGND VGND VPWR VPWR bit_sum5\[9\] sky130_fd_sc_hd__dfrtp_1
X_6989_ _3968_ _3967_ _3724_ VGND VGND VPWR VPWR _3975_ sky130_fd_sc_hd__o21ai_1
XFILLER_0_36_725 VGND VGND VPWR VPWR sky130_fd_sc_hd__decap_8
X_8659_ clknet_leaf_22_clk net104 _0410_ VGND VGND VPWR VPWR s6\[15\] sky130_fd_sc_hd__dfrtp_1
XFILLER_0_75_393 VGND VGND VPWR VPWR sky130_fd_sc_hd__decap_8
XFILLER_0_63_555 VGND VGND VPWR VPWR sky130_fd_sc_hd__decap_4
XFILLER_0_51_706 VPWR VGND VPWR VGND sky130_ef_sc_hd__decap_12
XFILLER_0_118_495 VGND VGND VPWR VPWR sky130_fd_sc_hd__decap_8
XFILLER_0_90_363 VGND VGND VPWR VPWR sky130_fd_sc_hd__fill_1
XFILLER_0_8_693 VGND VGND VPWR VPWR sky130_fd_sc_hd__decap_6
XFILLER_0_7_181 VPWR VGND VPWR VGND sky130_ef_sc_hd__decap_12
XFILLER_0_35_279 VGND VGND VPWR VPWR sky130_fd_sc_hd__fill_1
XFILLER_0_50_216 VGND VGND VPWR VPWR sky130_fd_sc_hd__fill_1
Xoutput10 net10 VGND VGND VPWR VPWR led[0] sky130_fd_sc_hd__clkbuf_4
Xoutput21 net21 VGND VGND VPWR VPWR led[5] sky130_fd_sc_hd__clkbuf_4
XFILLER_0_85_113 VPWR VGND VPWR VGND sky130_ef_sc_hd__decap_12
XFILLER_0_85_146 VGND VGND VPWR VPWR sky130_fd_sc_hd__decap_4
XPHY_160 VGND VGND VPWR VPWR sky130_fd_sc_hd__decap_3
XPHY_193 VGND VGND VPWR VPWR sky130_fd_sc_hd__decap_3
XPHY_182 VGND VGND VPWR VPWR sky130_fd_sc_hd__decap_3
XPHY_171 VGND VGND VPWR VPWR sky130_fd_sc_hd__decap_3
XFILLER_0_81_341 VGND VGND VPWR VPWR sky130_fd_sc_hd__fill_1
XFILLER_0_54_544 VGND VGND VPWR VPWR sky130_fd_sc_hd__decap_3
XFILLER_0_26_224 VGND VGND VPWR VPWR sky130_fd_sc_hd__decap_8
XFILLER_0_14_419 VGND VGND VPWR VPWR sky130_fd_sc_hd__fill_1
XFILLER_0_41_205 VGND VGND VPWR VPWR sky130_fd_sc_hd__decap_4
XFILLER_0_41_249 VPWR VGND VPWR VGND sky130_ef_sc_hd__decap_12
X_4340_ _1298_ _1381_ _1382_ _1383_ _1386_ VGND VGND VPWR VPWR _1387_ sky130_fd_sc_hd__o221ai_4
XFILLER_0_1_335 VGND VGND VPWR VPWR sky130_fd_sc_hd__fill_1
XFILLER_0_22_496 VGND VGND VPWR VPWR sky130_fd_sc_hd__fill_1
X_4271_ _1305_ _1311_ _1318_ VGND VGND VPWR VPWR _1319_ sky130_fd_sc_hd__a21bo_1
XFILLER_0_10_669 VPWR VGND VPWR VGND sky130_ef_sc_hd__decap_12
X_6010_ _3016_ _3017_ VGND VGND VPWR VPWR _3018_ sky130_fd_sc_hd__nand2_1
XFILLER_0_118_53 VPWR VGND VPWR VGND sky130_ef_sc_hd__decap_12
X_7961_ _0808_ _0809_ VGND VGND VPWR VPWR _0810_ sky130_fd_sc_hd__or2_2
X_7892_ sh4\[3\] VGND VGND VPWR VPWR _0742_ sky130_fd_sc_hd__inv_2
X_6912_ _3898_ _3899_ _3889_ _3894_ VGND VGND VPWR VPWR _3900_ sky130_fd_sc_hd__o211ai_2
X_6843_ _3785_ _3830_ VGND VGND VPWR VPWR _3831_ sky130_fd_sc_hd__nand2_1
XFILLER_0_77_669 VGND VGND VPWR VPWR sky130_fd_sc_hd__decap_3
XFILLER_0_57_371 VPWR VGND VPWR VGND sky130_ef_sc_hd__decap_12
XFILLER_0_9_446 VGND VGND VPWR VPWR sky130_fd_sc_hd__fill_2
XFILLER_0_17_213 VGND VGND VPWR VPWR sky130_fd_sc_hd__decap_8
XFILLER_0_18_725 VGND VGND VPWR VPWR sky130_fd_sc_hd__decap_8
X_6774_ sh7\[1\] sh8\[1\] VGND VGND VPWR VPWR _3763_ sky130_fd_sc_hd__nor2_1
XFILLER_0_57_393 VPWR VGND VPWR VGND sky130_ef_sc_hd__decap_12
X_8513_ clknet_leaf_40_clk net74 _0264_ VGND VGND VPWR VPWR sum5\[3\] sky130_fd_sc_hd__dfrtp_1
X_5725_ _2734_ _2739_ _2740_ VGND VGND VPWR VPWR _2741_ sky130_fd_sc_hd__nand3_1
XFILLER_0_115_421 VGND VGND VPWR VPWR sky130_fd_sc_hd__decap_6
XFILLER_0_94_3 VPWR VGND VPWR VGND sky130_ef_sc_hd__decap_12
X_8444_ clknet_leaf_27_clk net408 _0195_ VGND VGND VPWR VPWR carry4\[10\] sky130_fd_sc_hd__dfrtp_1
XFILLER_0_60_514 VGND VGND VPWR VPWR sky130_fd_sc_hd__decap_8
XFILLER_0_5_641 VPWR VGND VPWR VGND sky130_ef_sc_hd__decap_12
X_5656_ _2518_ _2672_ _2604_ VGND VGND VPWR VPWR _2673_ sky130_fd_sc_hd__a21bo_2
XFILLER_0_33_717 VGND VGND VPWR VPWR sky130_fd_sc_hd__fill_2
X_4607_ _1645_ VGND VGND VPWR VPWR _1646_ sky130_fd_sc_hd__clkbuf_4
XFILLER_0_115_476 VGND VGND VPWR VPWR sky130_fd_sc_hd__decap_4
XFILLER_0_103_605 VGND VGND VPWR VPWR sky130_fd_sc_hd__decap_6
Xhold320 sh2\[7\] VGND VGND VPWR VPWR net362 sky130_fd_sc_hd__dlygate4sd3_1
XFILLER_0_103_649 VGND VGND VPWR VPWR sky130_fd_sc_hd__fill_1
X_8375_ sum5\[14\] s7\[14\] VGND VGND VPWR VPWR _1208_ sky130_fd_sc_hd__nor2_1
XFILLER_0_5_685 VPWR VGND VPWR VGND sky130_ef_sc_hd__decap_12
X_5587_ sh8\[0\] sh9\[0\] VGND VGND VPWR VPWR _2605_ sky130_fd_sc_hd__and2_2
X_4538_ _1277_ _1506_ _1576_ _1577_ _1331_ VGND VGND VPWR VPWR _1582_ sky130_fd_sc_hd__o2111ai_2
Xhold331 s5\[7\] VGND VGND VPWR VPWR net373 sky130_fd_sc_hd__dlygate4sd3_1
Xhold353 _0016_ VGND VGND VPWR VPWR net395 sky130_fd_sc_hd__dlygate4sd3_1
XFILLER_0_4_195 VGND VGND VPWR VPWR sky130_fd_sc_hd__fill_1
XFILLER_0_40_260 VGND VGND VPWR VPWR sky130_fd_sc_hd__decap_3
X_7326_ _4140_ VGND VGND VPWR VPWR _0343_ sky130_fd_sc_hd__inv_2
Xhold342 _0008_ VGND VGND VPWR VPWR net384 sky130_fd_sc_hd__dlygate4sd3_1
X_4469_ _1501_ _1510_ _1512_ _1513_ VGND VGND VPWR VPWR _1514_ sky130_fd_sc_hd__o211ai_4
Xhold386 sh13\[4\] VGND VGND VPWR VPWR net428 sky130_fd_sc_hd__dlygate4sd3_1
X_7257_ _4133_ VGND VGND VPWR VPWR _0281_ sky130_fd_sc_hd__inv_2
Xhold364 _0015_ VGND VGND VPWR VPWR net406 sky130_fd_sc_hd__dlygate4sd3_1
Xhold375 sh4\[0\] VGND VGND VPWR VPWR net417 sky130_fd_sc_hd__dlygate4sd3_1
XFILLER_0_40_293 VGND VGND VPWR VPWR sky130_fd_sc_hd__decap_3
X_6208_ sh15\[6\] _2906_ _2922_ VGND VGND VPWR VPWR _3213_ sky130_fd_sc_hd__and3_1
Xhold397 sh14\[3\] VGND VGND VPWR VPWR net439 sky130_fd_sc_hd__dlygate4sd3_1
X_7188_ _4125_ VGND VGND VPWR VPWR _4127_ sky130_fd_sc_hd__buf_4
X_6139_ _3143_ _3144_ VGND VGND VPWR VPWR _3145_ sky130_fd_sc_hd__nand2_2
XTAP_680 VGND VPWR sky130_fd_sc_hd__tapvpwrvgnd_1
XTAP_691 VGND VPWR sky130_fd_sc_hd__tapvpwrvgnd_1
XFILLER_0_95_400 VPWR VGND VPWR VGND sky130_ef_sc_hd__decap_12
XTAP_1824 VGND VPWR sky130_fd_sc_hd__tapvpwrvgnd_1
XTAP_1802 VGND VPWR sky130_fd_sc_hd__tapvpwrvgnd_1
XTAP_1813 VGND VPWR sky130_fd_sc_hd__tapvpwrvgnd_1
XFILLER_0_67_113 VPWR VGND VPWR VGND sky130_ef_sc_hd__decap_12
XTAP_1857 VGND VPWR sky130_fd_sc_hd__tapvpwrvgnd_1
XTAP_1846 VGND VPWR sky130_fd_sc_hd__tapvpwrvgnd_1
XTAP_1835 VGND VPWR sky130_fd_sc_hd__tapvpwrvgnd_1
XFILLER_0_83_617 VGND VGND VPWR VPWR sky130_fd_sc_hd__fill_1
XFILLER_0_67_157 VGND VGND VPWR VPWR sky130_fd_sc_hd__decap_8
XTAP_1879 VGND VPWR sky130_fd_sc_hd__tapvpwrvgnd_1
XTAP_1868 VGND VPWR sky130_fd_sc_hd__tapvpwrvgnd_1
XFILLER_0_36_533 VPWR VGND VPWR VGND sky130_ef_sc_hd__decap_12
XFILLER_0_118_292 VGND VGND VPWR VPWR sky130_fd_sc_hd__decap_8
XFILLER_0_106_421 VPWR VGND VPWR VGND sky130_ef_sc_hd__decap_12
XFILLER_0_36_577 VGND VGND VPWR VPWR sky130_fd_sc_hd__decap_3
XFILLER_0_51_503 VGND VGND VPWR VPWR sky130_fd_sc_hd__fill_1
XFILLER_0_121_457 VGND VGND VPWR VPWR sky130_fd_sc_hd__fill_2
XFILLER_0_31_293 VGND VGND VPWR VPWR sky130_fd_sc_hd__decap_8
XFILLER_0_102_693 VGND VGND VPWR VPWR sky130_fd_sc_hd__decap_6
XFILLER_0_101_181 VGND VGND VPWR VPWR sky130_fd_sc_hd__fill_2
XFILLER_0_64_27 VGND VGND VPWR VPWR sky130_fd_sc_hd__fill_1
XFILLER_0_86_411 VGND VGND VPWR VPWR sky130_fd_sc_hd__fill_1
XFILLER_0_80_15 VPWR VGND VPWR VGND sky130_ef_sc_hd__decap_12
XFILLER_0_86_477 VGND VGND VPWR VPWR sky130_fd_sc_hd__decap_6
XFILLER_0_39_371 VGND VGND VPWR VPWR sky130_fd_sc_hd__fill_1
XFILLER_0_46_319 VGND VGND VPWR VPWR sky130_fd_sc_hd__decap_4
XFILLER_0_117_719 VGND VGND VPWR VPWR sky130_fd_sc_hd__decap_8
XFILLER_0_6_416 VGND VGND VPWR VPWR sky130_fd_sc_hd__decap_4
XFILLER_0_54_363 VGND VGND VPWR VPWR sky130_fd_sc_hd__fill_1
X_5510_ _2483_ _2486_ _2487_ VGND VGND VPWR VPWR _2529_ sky130_fd_sc_hd__a21oi_1
XFILLER_0_89_57 VPWR VGND VPWR VGND sky130_ef_sc_hd__decap_12
X_6490_ _3484_ _3485_ _3486_ VGND VGND VPWR VPWR _3487_ sky130_fd_sc_hd__a21oi_2
XFILLER_0_14_227 VPWR VGND VPWR VGND sky130_ef_sc_hd__decap_12
XFILLER_0_120_65 VPWR VGND VPWR VGND sky130_ef_sc_hd__decap_12
XFILLER_0_112_424 VGND VGND VPWR VPWR sky130_fd_sc_hd__fill_1
X_5441_ _2452_ _2454_ _2460_ VGND VGND VPWR VPWR _2463_ sky130_fd_sc_hd__a21o_1
X_8160_ _0736_ _0747_ VGND VGND VPWR VPWR _1006_ sky130_fd_sc_hd__nand2_1
X_5372_ _2337_ VGND VGND VPWR VPWR _2397_ sky130_fd_sc_hd__inv_2
X_4323_ _1355_ _1362_ _1245_ VGND VGND VPWR VPWR _1370_ sky130_fd_sc_hd__o21ba_1
X_8091_ _0736_ _0737_ _0723_ VGND VGND VPWR VPWR _0938_ sky130_fd_sc_hd__o21ai_2
XFILLER_0_2_699 VGND VGND VPWR VPWR sky130_fd_sc_hd__fill_1
X_7111_ _4087_ _4093_ _4094_ VGND VGND VPWR VPWR _4095_ sky130_fd_sc_hd__o21ai_1
XFILLER_0_22_282 VGND VGND VPWR VPWR sky130_fd_sc_hd__fill_2
X_7042_ sh13\[1\] sh9\[1\] VGND VGND VPWR VPWR _4027_ sky130_fd_sc_hd__and2_1
X_4254_ _1297_ _1298_ _1299_ _1301_ VGND VGND VPWR VPWR _1302_ sky130_fd_sc_hd__o22ai_4
XFILLER_0_97_709 VGND VGND VPWR VPWR sky130_fd_sc_hd__decap_8
X_7944_ _0788_ _0791_ _0792_ VGND VGND VPWR VPWR _0793_ sky130_fd_sc_hd__nand3_2
XTAP_1109 VGND VPWR sky130_fd_sc_hd__tapvpwrvgnd_1
XFILLER_0_49_113 VGND VGND VPWR VPWR sky130_fd_sc_hd__decap_3
XFILLER_0_77_444 VGND VGND VPWR VPWR sky130_fd_sc_hd__fill_1
X_7875_ sh10\[3\] sh11\[3\] VGND VGND VPWR VPWR _0725_ sky130_fd_sc_hd__and2_2
XFILLER_0_92_403 VGND VGND VPWR VPWR sky130_fd_sc_hd__decap_8
XFILLER_0_77_477 VGND VGND VPWR VPWR sky130_fd_sc_hd__decap_8
XFILLER_0_65_639 VPWR VGND VPWR VGND sky130_ef_sc_hd__decap_12
XFILLER_0_65_617 VGND VGND VPWR VPWR sky130_fd_sc_hd__decap_6
XFILLER_0_64_105 VGND VGND VPWR VPWR sky130_fd_sc_hd__fill_2
X_6826_ _3813_ _3793_ _3794_ VGND VGND VPWR VPWR _3815_ sky130_fd_sc_hd__nand3b_1
XFILLER_0_92_447 VGND VGND VPWR VPWR sky130_fd_sc_hd__fill_1
XFILLER_0_80_609 VGND VGND VPWR VPWR sky130_fd_sc_hd__decap_8
X_6757_ _3712_ _3703_ sh6\[1\] VGND VGND VPWR VPWR _3746_ sky130_fd_sc_hd__o21a_1
XFILLER_0_18_533 VGND VGND VPWR VPWR sky130_fd_sc_hd__fill_1
XFILLER_0_107_229 VGND VGND VPWR VPWR sky130_fd_sc_hd__decap_8
XFILLER_0_73_661 VGND VGND VPWR VPWR sky130_fd_sc_hd__decap_8
XFILLER_0_18_566 VGND VGND VPWR VPWR sky130_fd_sc_hd__decap_3
X_5708_ _2470_ _2668_ _2671_ _2673_ VGND VGND VPWR VPWR _2724_ sky130_fd_sc_hd__a22o_1
X_6688_ _3681_ _3638_ VGND VGND VPWR VPWR _3682_ sky130_fd_sc_hd__nand2_1
X_8427_ _1244_ _1253_ _1256_ VGND VGND VPWR VPWR _1257_ sky130_fd_sc_hd__o21ai_4
XFILLER_0_115_284 VPWR VGND VPWR VGND sky130_ef_sc_hd__decap_12
XFILLER_0_60_333 VGND VGND VPWR VPWR sky130_fd_sc_hd__decap_4
X_5639_ _2581_ _2603_ _2643_ VGND VGND VPWR VPWR _2657_ sky130_fd_sc_hd__o21ai_2
XFILLER_0_103_446 VGND VGND VPWR VPWR sky130_fd_sc_hd__fill_2
X_8358_ sum5\[11\] s7\[11\] _1190_ _1191_ _1180_ VGND VGND VPWR VPWR _1193_ sky130_fd_sc_hd__a221oi_1
Xhold150 sh12\[3\] VGND VGND VPWR VPWR net192 sky130_fd_sc_hd__dlygate4sd3_1
X_7309_ _4138_ VGND VGND VPWR VPWR _0328_ sky130_fd_sc_hd__inv_2
Xhold161 sh11\[1\] VGND VGND VPWR VPWR net203 sky130_fd_sc_hd__dlygate4sd3_1
Xhold194 sh14\[5\] VGND VGND VPWR VPWR net236 sky130_fd_sc_hd__dlygate4sd3_1
Xhold172 s4\[12\] VGND VGND VPWR VPWR net214 sky130_fd_sc_hd__dlygate4sd3_1
X_8289_ _1129_ _1131_ VGND VGND VPWR VPWR _1132_ sky130_fd_sc_hd__and2_1
Xhold183 s2\[7\] VGND VGND VPWR VPWR net225 sky130_fd_sc_hd__dlygate4sd3_1
XTAP_1632 VGND VPWR sky130_fd_sc_hd__tapvpwrvgnd_1
XTAP_1621 VGND VPWR sky130_fd_sc_hd__tapvpwrvgnd_1
XTAP_1610 VGND VPWR sky130_fd_sc_hd__tapvpwrvgnd_1
XTAP_1676 VGND VPWR sky130_fd_sc_hd__tapvpwrvgnd_1
XTAP_1665 VGND VPWR sky130_fd_sc_hd__tapvpwrvgnd_1
XTAP_1654 VGND VPWR sky130_fd_sc_hd__tapvpwrvgnd_1
XTAP_1643 VGND VPWR sky130_fd_sc_hd__tapvpwrvgnd_1
XFILLER_0_68_477 VGND VGND VPWR VPWR sky130_fd_sc_hd__fill_2
XFILLER_0_55_105 VGND VGND VPWR VPWR sky130_fd_sc_hd__decap_6
XTAP_1698 VGND VPWR sky130_fd_sc_hd__tapvpwrvgnd_1
XTAP_1687 VGND VPWR sky130_fd_sc_hd__tapvpwrvgnd_1
XFILLER_0_83_447 VGND VGND VPWR VPWR sky130_fd_sc_hd__fill_1
XFILLER_0_50_29 VGND VGND VPWR VPWR sky130_fd_sc_hd__decap_6
XFILLER_0_83_469 VGND VGND VPWR VPWR sky130_fd_sc_hd__fill_2
XFILLER_0_63_193 VPWR VGND VPWR VGND sky130_ef_sc_hd__decap_12
XFILLER_0_24_569 VPWR VGND VPWR VGND sky130_ef_sc_hd__decap_12
XFILLER_0_51_333 VGND VGND VPWR VPWR sky130_fd_sc_hd__decap_3
XFILLER_0_59_27 VGND VGND VPWR VPWR sky130_fd_sc_hd__fill_1
XFILLER_0_75_15 VPWR VGND VPWR VGND sky130_ef_sc_hd__decap_12
X_5990_ _2879_ sh3\[6\] net39 VGND VGND VPWR VPWR _2998_ sky130_fd_sc_hd__o21a_1
XFILLER_0_91_47 VGND VGND VPWR VPWR sky130_fd_sc_hd__fill_2
X_4941_ _1962_ _1974_ _1968_ _1972_ VGND VGND VPWR VPWR _1975_ sky130_fd_sc_hd__o211ai_4
X_4872_ _1833_ _1907_ VGND VGND VPWR VPWR _0184_ sky130_fd_sc_hd__xor2_1
XFILLER_0_74_414 VGND VGND VPWR VPWR sky130_fd_sc_hd__fill_2
X_7660_ sum3\[9\] carry3\[8\] VGND VGND VPWR VPWR _4187_ sky130_fd_sc_hd__nor2_1
XFILLER_0_19_319 VPWR VGND VPWR VGND sky130_ef_sc_hd__decap_12
XFILLER_0_24_85 VGND VGND VPWR VPWR sky130_fd_sc_hd__fill_1
XFILLER_0_47_617 VGND VGND VPWR VPWR sky130_fd_sc_hd__decap_4
X_6611_ _3602_ _3603_ _3561_ _3605_ VGND VGND VPWR VPWR _3606_ sky130_fd_sc_hd__o211a_1
XFILLER_0_46_127 VPWR VGND VPWR VGND sky130_ef_sc_hd__decap_12
X_7591_ _4166_ VGND VGND VPWR VPWR _0582_ sky130_fd_sc_hd__inv_2
XFILLER_0_62_609 VGND VGND VPWR VPWR sky130_fd_sc_hd__decap_8
XFILLER_0_39_190 VGND VGND VPWR VPWR sky130_fd_sc_hd__decap_8
XFILLER_0_70_631 VGND VGND VPWR VPWR sky130_fd_sc_hd__decap_3
X_6542_ _3530_ _3534_ _3527_ _3529_ VGND VGND VPWR VPWR _3539_ sky130_fd_sc_hd__o211ai_2
XFILLER_0_42_322 VGND VGND VPWR VPWR sky130_fd_sc_hd__decap_4
X_6473_ _3465_ _3469_ _3470_ _3390_ VGND VGND VPWR VPWR _3471_ sky130_fd_sc_hd__o2bb2ai_2
XFILLER_0_6_279 VGND VGND VPWR VPWR sky130_fd_sc_hd__decap_4
XFILLER_0_15_547 VGND VGND VPWR VPWR sky130_fd_sc_hd__decap_3
XFILLER_0_112_221 VGND VGND VPWR VPWR sky130_fd_sc_hd__fill_2
X_8212_ sh4\[3\] sh2\[3\] VGND VGND VPWR VPWR _1057_ sky130_fd_sc_hd__and2_2
X_5424_ _2411_ _2447_ VGND VGND VPWR VPWR _2448_ sky130_fd_sc_hd__xnor2_1
X_8143_ _0982_ _0983_ _0976_ _0980_ VGND VGND VPWR VPWR _0990_ sky130_fd_sc_hd__o211ai_2
XFILLER_0_57_3 VPWR VGND VPWR VGND sky130_ef_sc_hd__decap_12
X_5355_ _2057_ _2037_ VGND VGND VPWR VPWR _2380_ sky130_fd_sc_hd__nor2_1
X_4306_ _1352_ _1353_ VGND VGND VPWR VPWR _0128_ sky130_fd_sc_hd__nor2_1
X_5286_ _2311_ _2307_ _2309_ VGND VGND VPWR VPWR _2313_ sky130_fd_sc_hd__nand3_2
X_8074_ _0916_ _0919_ _0911_ _0912_ VGND VGND VPWR VPWR _0922_ sky130_fd_sc_hd__o211ai_2
X_4237_ _1272_ _1282_ _1283_ _1284_ VGND VGND VPWR VPWR _1285_ sky130_fd_sc_hd__o211ai_4
X_7025_ _3961_ _3960_ _3954_ _4009_ VGND VGND VPWR VPWR _4011_ sky130_fd_sc_hd__o211ai_4
XFILLER_0_69_208 VGND VGND VPWR VPWR sky130_fd_sc_hd__decap_8
XFILLER_0_77_230 VPWR VGND VPWR VGND sky130_ef_sc_hd__decap_12
X_7927_ sh6\[3\] VGND VGND VPWR VPWR _0776_ sky130_fd_sc_hd__inv_2
XFILLER_0_93_701 VPWR VGND VPWR VGND sky130_ef_sc_hd__decap_12
X_7858_ carry4\[10\] net357 _0714_ VGND VGND VPWR VPWR _0041_ sky130_fd_sc_hd__a21o_1
XFILLER_0_65_447 VGND VGND VPWR VPWR sky130_fd_sc_hd__fill_1
X_6809_ _3711_ _3714_ VGND VGND VPWR VPWR _3798_ sky130_fd_sc_hd__nand2_1
X_7789_ carry2\[11\] sum2\[12\] net214 VGND VGND VPWR VPWR _0680_ sky130_fd_sc_hd__a21o_1
XFILLER_0_18_363 VGND VGND VPWR VPWR sky130_fd_sc_hd__fill_1
XFILLER_0_33_300 VPWR VGND VPWR VGND sky130_ef_sc_hd__decap_12
XFILLER_0_116_560 VGND VGND VPWR VPWR sky130_fd_sc_hd__fill_1
XFILLER_0_60_141 VPWR VGND VPWR VGND sky130_ef_sc_hd__decap_12
XFILLER_0_104_733 VGND VGND VPWR VPWR sky130_fd_sc_hd__fill_2
XFILLER_0_103_221 VGND VGND VPWR VPWR sky130_fd_sc_hd__decap_3
XFILLER_0_21_517 VPWR VGND VPWR VGND sky130_ef_sc_hd__decap_12
XFILLER_0_33_388 VGND VGND VPWR VPWR sky130_fd_sc_hd__decap_4
XFILLER_0_68_241 VGND VGND VPWR VPWR sky130_fd_sc_hd__fill_1
XTAP_1451 VGND VPWR sky130_fd_sc_hd__tapvpwrvgnd_1
XTAP_1440 VGND VPWR sky130_fd_sc_hd__tapvpwrvgnd_1
XTAP_1484 VGND VPWR sky130_fd_sc_hd__tapvpwrvgnd_1
XTAP_1462 VGND VPWR sky130_fd_sc_hd__tapvpwrvgnd_1
XTAP_1473 VGND VPWR sky130_fd_sc_hd__tapvpwrvgnd_1
XFILLER_0_56_436 VGND VGND VPWR VPWR sky130_fd_sc_hd__fill_1
XFILLER_0_28_116 VPWR VGND VPWR VGND sky130_ef_sc_hd__decap_12
XTAP_1495 VGND VPWR sky130_fd_sc_hd__tapvpwrvgnd_1
XFILLER_0_71_417 VGND VGND VPWR VPWR sky130_fd_sc_hd__decap_4
XFILLER_0_44_609 VGND VGND VPWR VPWR sky130_fd_sc_hd__decap_8
XFILLER_0_83_299 VGND VGND VPWR VPWR sky130_fd_sc_hd__decap_4
XFILLER_0_52_620 VGND VGND VPWR VPWR sky130_fd_sc_hd__decap_8
XFILLER_0_3_205 VPWR VGND VPWR VGND sky130_ef_sc_hd__decap_12
XFILLER_0_24_344 VGND VGND VPWR VPWR sky130_fd_sc_hd__fill_1
XFILLER_0_3_249 VGND VGND VPWR VPWR sky130_fd_sc_hd__decap_8
XFILLER_0_51_141 VPWR VGND VPWR VGND sky130_ef_sc_hd__decap_12
XFILLER_0_122_563 VGND VGND VPWR VPWR sky130_fd_sc_hd__decap_4
XFILLER_0_10_65 VPWR VGND VPWR VGND sky130_ef_sc_hd__decap_12
XFILLER_0_110_725 VGND VGND VPWR VPWR sky130_fd_sc_hd__decap_8
X_5140_ _2073_ _2074_ _2104_ VGND VGND VPWR VPWR _2169_ sky130_fd_sc_hd__a21oi_2
X_5071_ _2087_ _2099_ _2069_ VGND VGND VPWR VPWR _2100_ sky130_fd_sc_hd__o21bai_2
X_8830_ clknet_leaf_62_clk net216 _0581_ VGND VGND VPWR VPWR sh10\[2\] sky130_fd_sc_hd__dfrtp_4
XFILLER_0_35_51 VGND VGND VPWR VPWR sky130_fd_sc_hd__decap_4
X_8761_ clknet_leaf_10_clk net322 _0512_ VGND VGND VPWR VPWR sh1\[5\] sky130_fd_sc_hd__dfrtp_1
X_5973_ _2977_ _2979_ _2967_ _2973_ VGND VGND VPWR VPWR _2982_ sky130_fd_sc_hd__o211ai_2
X_4924_ _1954_ _1957_ _1690_ VGND VGND VPWR VPWR _1958_ sky130_fd_sc_hd__o21ai_4
XFILLER_0_87_561 VGND VGND VPWR VPWR sky130_fd_sc_hd__decap_8
XFILLER_0_87_550 VGND VGND VPWR VPWR sky130_fd_sc_hd__decap_8
X_7712_ carry1\[4\] sum1\[5\] VGND VGND VPWR VPWR _0628_ sky130_fd_sc_hd__xnor2_1
X_8692_ clknet_leaf_57_clk _0156_ _0443_ VGND VGND VPWR VPWR bit_sum2\[3\] sky130_fd_sc_hd__dfrtp_1
XFILLER_0_117_335 VGND VGND VPWR VPWR sky130_fd_sc_hd__fill_1
XFILLER_0_117_324 VGND VGND VPWR VPWR sky130_fd_sc_hd__fill_2
X_4855_ _1890_ _1720_ _1798_ VGND VGND VPWR VPWR _1891_ sky130_fd_sc_hd__a21oi_1
X_7643_ _4172_ _4173_ VGND VGND VPWR VPWR _0085_ sky130_fd_sc_hd__nand2_1
X_4786_ _1723_ _1675_ _1718_ _1720_ VGND VGND VPWR VPWR _1823_ sky130_fd_sc_hd__a211o_1
X_7574_ _4164_ VGND VGND VPWR VPWR _0567_ sky130_fd_sc_hd__inv_2
XFILLER_0_74_277 VPWR VGND VPWR VGND sky130_ef_sc_hd__decap_12
XFILLER_0_15_300 VGND VGND VPWR VPWR sky130_fd_sc_hd__fill_1
X_6525_ _3519_ _3514_ VGND VGND VPWR VPWR _3522_ sky130_fd_sc_hd__nand2_2
XFILLER_0_7_588 VGND VGND VPWR VPWR sky130_fd_sc_hd__decap_6
XFILLER_0_43_642 VPWR VGND VPWR VGND sky130_ef_sc_hd__decap_12
XFILLER_0_15_388 VGND VGND VPWR VPWR sky130_fd_sc_hd__decap_4
XFILLER_0_42_141 VPWR VGND VPWR VGND sky130_ef_sc_hd__decap_12
XFILLER_0_43_697 VPWR VGND VPWR VGND sky130_ef_sc_hd__decap_12
X_6456_ _3450_ _3453_ _3389_ VGND VGND VPWR VPWR _3454_ sky130_fd_sc_hd__o21bai_2
XFILLER_0_113_585 VGND VGND VPWR VPWR sky130_fd_sc_hd__decap_3
XFILLER_0_100_213 VGND VGND VPWR VPWR sky130_fd_sc_hd__fill_2
X_6387_ _3384_ _3372_ _3375_ VGND VGND VPWR VPWR _3386_ sky130_fd_sc_hd__nand3_2
X_5407_ _2057_ _2038_ VGND VGND VPWR VPWR _2431_ sky130_fd_sc_hd__nand2_1
X_8126_ _0946_ _0950_ _0971_ _0972_ VGND VGND VPWR VPWR _0973_ sky130_fd_sc_hd__o2bb2ai_1
X_5338_ _2356_ _2362_ VGND VGND VPWR VPWR _2364_ sky130_fd_sc_hd__nand2_1
X_8057_ _0899_ _0900_ _0904_ VGND VGND VPWR VPWR _0905_ sky130_fd_sc_hd__o21ai_2
X_7008_ _3991_ _3992_ _3993_ VGND VGND VPWR VPWR _3994_ sky130_fd_sc_hd__nand3_2
X_5269_ _2195_ _2295_ _2285_ _2292_ VGND VGND VPWR VPWR _2296_ sky130_fd_sc_hd__o211ai_4
XFILLER_0_66_701 VPWR VGND VPWR VGND sky130_ef_sc_hd__decap_12
XFILLER_0_65_255 VPWR VGND VPWR VGND sky130_ef_sc_hd__decap_12
XFILLER_0_19_650 VGND VGND VPWR VPWR sky130_fd_sc_hd__decap_4
XFILLER_0_108_357 VGND VGND VPWR VPWR sky130_fd_sc_hd__decap_6
XFILLER_0_80_225 VGND VGND VPWR VPWR sky130_fd_sc_hd__fill_1
XFILLER_0_123_305 VGND VGND VPWR VPWR sky130_fd_sc_hd__decap_3
XFILLER_0_123_349 VPWR VGND VPWR VGND sky130_ef_sc_hd__decap_12
XFILLER_0_61_461 VGND VGND VPWR VPWR sky130_fd_sc_hd__fill_2
XFILLER_0_1_709 VPWR VGND VPWR VGND sky130_ef_sc_hd__decap_12
XFILLER_0_21_303 VGND VGND VPWR VPWR sky130_fd_sc_hd__decap_6
XTAP_509 VGND VPWR sky130_fd_sc_hd__tapvpwrvgnd_1
XFILLER_0_76_509 VGND VGND VPWR VPWR sky130_fd_sc_hd__fill_2
XFILLER_0_72_27 VGND VGND VPWR VPWR sky130_fd_sc_hd__fill_1
XFILLER_0_69_561 VGND VGND VPWR VPWR sky130_fd_sc_hd__fill_2
XTAP_1292 VGND VPWR sky130_fd_sc_hd__tapvpwrvgnd_1
XTAP_1281 VGND VPWR sky130_fd_sc_hd__tapvpwrvgnd_1
XTAP_1270 VGND VPWR sky130_fd_sc_hd__tapvpwrvgnd_1
XFILLER_0_44_406 VPWR VGND VPWR VGND sky130_ef_sc_hd__decap_12
X_4640_ _1638_ net31 VGND VGND VPWR VPWR _1678_ sky130_fd_sc_hd__nor2_1
XFILLER_0_115_3 VPWR VGND VPWR VGND sky130_ef_sc_hd__decap_12
XFILLER_0_112_77 VGND VGND VPWR VPWR sky130_fd_sc_hd__fill_1
X_4571_ _1608_ _1541_ _1605_ VGND VGND VPWR VPWR _1614_ sky130_fd_sc_hd__nand3_2
X_6310_ _3308_ _3309_ VGND VGND VPWR VPWR _3310_ sky130_fd_sc_hd__nor2_1
XFILLER_0_21_86 VGND VGND VPWR VPWR sky130_fd_sc_hd__decap_3
XFILLER_0_24_141 VGND VGND VPWR VPWR sky130_fd_sc_hd__decap_6
X_7290_ _4137_ VGND VGND VPWR VPWR _0310_ sky130_fd_sc_hd__inv_2
XFILLER_0_25_697 VGND VGND VPWR VPWR sky130_fd_sc_hd__decap_8
X_6241_ _2923_ _3033_ _3194_ VGND VGND VPWR VPWR _3245_ sky130_fd_sc_hd__a21oi_2
XFILLER_0_110_533 VGND VGND VPWR VPWR sky130_fd_sc_hd__decap_8
XFILLER_0_97_57 VGND VGND VPWR VPWR sky130_fd_sc_hd__decap_8
XFILLER_0_40_689 VGND VGND VPWR VPWR sky130_fd_sc_hd__decap_8
X_6172_ _3038_ _3101_ _3135_ VGND VGND VPWR VPWR _3178_ sky130_fd_sc_hd__a21oi_1
X_5123_ _2138_ _2139_ _2147_ _2149_ VGND VGND VPWR VPWR _2152_ sky130_fd_sc_hd__o211ai_4
XFILLER_0_20_380 VGND VGND VPWR VPWR sky130_fd_sc_hd__decap_4
X_5054_ sh15\[2\] _2083_ VGND VGND VPWR VPWR _2084_ sky130_fd_sc_hd__or2_1
XFILLER_0_79_347 VGND VGND VPWR VPWR sky130_fd_sc_hd__decap_8
X_8813_ clknet_leaf_59_clk net347 _0564_ VGND VGND VPWR VPWR sh8\[1\] sky130_fd_sc_hd__dfrtp_4
XFILLER_0_94_317 VGND VGND VPWR VPWR sky130_fd_sc_hd__fill_2
X_5956_ _2964_ _2919_ _2921_ VGND VGND VPWR VPWR _2965_ sky130_fd_sc_hd__a21boi_1
X_8744_ clknet_leaf_23_clk _0185_ _0495_ VGND VGND VPWR VPWR bit_sum7\[5\] sky130_fd_sc_hd__dfrtp_1
XFILLER_0_75_520 VPWR VGND VPWR VGND sky130_ef_sc_hd__decap_12
XFILLER_0_62_82 VGND VGND VPWR VPWR sky130_fd_sc_hd__fill_2
X_4907_ _1937_ _1935_ _1936_ VGND VGND VPWR VPWR _1942_ sky130_fd_sc_hd__and3_1
X_5887_ _2893_ _2895_ _2896_ VGND VGND VPWR VPWR _2897_ sky130_fd_sc_hd__nor3_1
XFILLER_0_75_553 VGND VGND VPWR VPWR sky130_fd_sc_hd__decap_6
X_8675_ clknet_leaf_43_clk _0177_ _0426_ VGND VGND VPWR VPWR bit_sum0\[6\] sky130_fd_sc_hd__dfrtp_1
XFILLER_0_47_244 VGND VGND VPWR VPWR sky130_fd_sc_hd__fill_1
XFILLER_0_117_121 VGND VGND VPWR VPWR sky130_fd_sc_hd__decap_3
XFILLER_0_117_110 VGND VGND VPWR VPWR sky130_fd_sc_hd__fill_2
X_4838_ _1871_ _1870_ _1872_ _1873_ VGND VGND VPWR VPWR _1874_ sky130_fd_sc_hd__o2bb2ai_2
X_7626_ _4169_ VGND VGND VPWR VPWR _0614_ sky130_fd_sc_hd__inv_2
XFILLER_0_63_726 VGND VGND VPWR VPWR sky130_fd_sc_hd__fill_2
XFILLER_0_118_677 VPWR VGND VPWR VGND sky130_ef_sc_hd__decap_12
XFILLER_0_90_556 VPWR VGND VPWR VGND sky130_ef_sc_hd__decap_12
XFILLER_0_7_374 VGND VGND VPWR VPWR sky130_fd_sc_hd__decap_4
XFILLER_0_117_187 VPWR VGND VPWR VGND sky130_ef_sc_hd__decap_12
X_4769_ _1714_ _1716_ _1710_ _1783_ _1787_ VGND VGND VPWR VPWR _1806_ sky130_fd_sc_hd__o2111ai_4
XFILLER_0_90_589 VGND VGND VPWR VPWR sky130_fd_sc_hd__fill_2
X_7557_ _4163_ VGND VGND VPWR VPWR _0551_ sky130_fd_sc_hd__inv_2
X_7488_ _4156_ VGND VGND VPWR VPWR _0489_ sky130_fd_sc_hd__inv_2
X_6508_ _3499_ _3502_ _3504_ VGND VGND VPWR VPWR _3505_ sky130_fd_sc_hd__a21oi_1
XFILLER_0_43_483 VGND VGND VPWR VPWR sky130_fd_sc_hd__fill_1
X_6439_ _3420_ _3421_ _3307_ VGND VGND VPWR VPWR _3437_ sky130_fd_sc_hd__o21bai_1
XFILLER_0_113_393 VGND VGND VPWR VPWR sky130_fd_sc_hd__fill_2
XFILLER_0_101_555 VGND VGND VPWR VPWR sky130_fd_sc_hd__decap_4
X_8109_ _0826_ _0892_ _0955_ VGND VGND VPWR VPWR _0956_ sky130_fd_sc_hd__a21o_1
Xhold10 bit_sum5\[7\] VGND VGND VPWR VPWR net52 sky130_fd_sc_hd__dlygate4sd3_1
Xhold21 bit_sum3\[8\] VGND VGND VPWR VPWR net63 sky130_fd_sc_hd__dlygate4sd3_1
Xhold32 sum4\[3\] VGND VGND VPWR VPWR net74 sky130_fd_sc_hd__dlygate4sd3_1
Xhold43 bit_sum7\[0\] VGND VGND VPWR VPWR net85 sky130_fd_sc_hd__dlygate4sd3_1
Xhold54 bit_sum4\[8\] VGND VGND VPWR VPWR net96 sky130_fd_sc_hd__dlygate4sd3_1
Xhold65 sum5\[3\] VGND VGND VPWR VPWR net107 sky130_fd_sc_hd__dlygate4sd3_1
Xhold87 sum4\[4\] VGND VGND VPWR VPWR net129 sky130_fd_sc_hd__dlygate4sd3_1
Xhold98 bit_sum3\[3\] VGND VGND VPWR VPWR net140 sky130_fd_sc_hd__dlygate4sd3_1
Xhold76 bit_sum1\[8\] VGND VGND VPWR VPWR net118 sky130_fd_sc_hd__dlygate4sd3_1
XFILLER_0_98_645 VGND VGND VPWR VPWR sky130_fd_sc_hd__decap_8
XFILLER_0_97_111 VGND VGND VPWR VPWR sky130_fd_sc_hd__fill_1
XFILLER_0_97_177 VGND VGND VPWR VPWR sky130_fd_sc_hd__decap_6
XFILLER_0_38_233 VPWR VGND VPWR VGND sky130_ef_sc_hd__decap_12
XFILLER_0_93_361 VPWR VGND VPWR VGND sky130_ef_sc_hd__decap_12
XFILLER_0_26_417 VGND VGND VPWR VPWR sky130_fd_sc_hd__decap_3
XFILLER_0_123_113 VPWR VGND VPWR VGND sky130_ef_sc_hd__decap_12
XFILLER_0_108_187 VGND VGND VPWR VPWR sky130_fd_sc_hd__decap_8
XFILLER_0_34_461 VPWR VGND VPWR VGND sky130_ef_sc_hd__decap_12
XFILLER_0_101_9 VGND VGND VPWR VPWR sky130_fd_sc_hd__fill_1
XFILLER_0_1_517 VPWR VGND VPWR VGND sky130_ef_sc_hd__decap_12
XFILLER_0_21_111 VGND VGND VPWR VPWR sky130_fd_sc_hd__fill_1
XFILLER_0_22_645 VGND VGND VPWR VPWR sky130_fd_sc_hd__decap_8
XFILLER_0_61_291 VGND VGND VPWR VPWR sky130_fd_sc_hd__decap_4
XTAP_306 VGND VPWR sky130_fd_sc_hd__tapvpwrvgnd_1
XFILLER_0_21_166 VGND VGND VPWR VPWR sky130_fd_sc_hd__fill_2
XTAP_339 VGND VPWR sky130_fd_sc_hd__tapvpwrvgnd_1
XTAP_328 VGND VPWR sky130_fd_sc_hd__tapvpwrvgnd_1
XTAP_317 VGND VPWR sky130_fd_sc_hd__tapvpwrvgnd_1
XFILLER_0_83_15 VPWR VGND VPWR VGND sky130_ef_sc_hd__decap_12
XFILLER_0_16_53 VGND VGND VPWR VPWR sky130_fd_sc_hd__decap_3
XFILLER_0_88_144 VPWR VGND VPWR VGND sky130_ef_sc_hd__decap_12
XFILLER_0_16_75 VGND VGND VPWR VPWR sky130_fd_sc_hd__decap_3
XFILLER_0_119_408 VPWR VGND VPWR VGND sky130_ef_sc_hd__decap_12
XFILLER_0_9_617 VPWR VGND VPWR VGND sky130_ef_sc_hd__decap_12
X_6790_ _3778_ _3743_ VGND VGND VPWR VPWR _3779_ sky130_fd_sc_hd__nand2_1
X_5810_ _2802_ _2801_ _2807_ VGND VGND VPWR VPWR _2824_ sky130_fd_sc_hd__o21ai_1
X_5741_ _2728_ _2755_ _2756_ VGND VGND VPWR VPWR _2757_ sky130_fd_sc_hd__nand3_2
X_8460_ clknet_leaf_26_clk net355 _0211_ VGND VGND VPWR VPWR carry5\[7\] sky130_fd_sc_hd__dfrtp_1
X_5672_ _2678_ _2679_ _2683_ _2688_ VGND VGND VPWR VPWR _2689_ sky130_fd_sc_hd__o211ai_2
XFILLER_0_17_439 VGND VGND VPWR VPWR sky130_fd_sc_hd__fill_1
XFILLER_0_32_85 VGND VGND VPWR VPWR sky130_fd_sc_hd__decap_4
XFILLER_0_44_236 VGND VGND VPWR VPWR sky130_fd_sc_hd__decap_4
X_7411_ _4149_ VGND VGND VPWR VPWR _0419_ sky130_fd_sc_hd__inv_2
X_4623_ sh11\[7\] VGND VGND VPWR VPWR _1662_ sky130_fd_sc_hd__buf_4
X_8391_ _1146_ _1151_ _1138_ VGND VGND VPWR VPWR _1222_ sky130_fd_sc_hd__a21oi_1
XFILLER_0_4_333 VPWR VGND VPWR VGND sky130_ef_sc_hd__decap_12
X_4554_ _1545_ _1547_ _1559_ VGND VGND VPWR VPWR _1597_ sky130_fd_sc_hd__o21ai_2
XFILLER_0_115_669 VGND VGND VPWR VPWR sky130_fd_sc_hd__decap_3
X_7342_ _4141_ VGND VGND VPWR VPWR _0358_ sky130_fd_sc_hd__inv_2
X_7273_ _4134_ VGND VGND VPWR VPWR _0296_ sky130_fd_sc_hd__inv_2
X_6224_ _3178_ _3177_ _3182_ VGND VGND VPWR VPWR _3229_ sky130_fd_sc_hd__o21ai_1
X_4485_ _1521_ _1522_ _1479_ _1478_ _1529_ VGND VGND VPWR VPWR _1530_ sky130_fd_sc_hd__a221o_1
XFILLER_0_110_363 VGND VGND VPWR VPWR sky130_fd_sc_hd__fill_1
XFILLER_0_0_561 VPWR VGND VPWR VGND sky130_ef_sc_hd__decap_12
X_6155_ _2926_ _3159_ _2986_ VGND VGND VPWR VPWR _3161_ sky130_fd_sc_hd__o21ai_4
XFILLER_0_110_396 VGND VGND VPWR VPWR sky130_fd_sc_hd__decap_8
XTAP_840 VGND VPWR sky130_fd_sc_hd__tapvpwrvgnd_1
XTAP_851 VGND VPWR sky130_fd_sc_hd__tapvpwrvgnd_1
XTAP_862 VGND VPWR sky130_fd_sc_hd__tapvpwrvgnd_1
X_6086_ _3088_ _3079_ VGND VGND VPWR VPWR _3093_ sky130_fd_sc_hd__nand2_1
X_5106_ sh5\[2\] sh7\[2\] _2102_ VGND VGND VPWR VPWR _2135_ sky130_fd_sc_hd__o21ai_2
XTAP_873 VGND VPWR sky130_fd_sc_hd__tapvpwrvgnd_1
XTAP_884 VGND VPWR sky130_fd_sc_hd__tapvpwrvgnd_1
XTAP_895 VGND VPWR sky130_fd_sc_hd__tapvpwrvgnd_1
X_5037_ net38 sh7\[2\] VGND VGND VPWR VPWR _2067_ sky130_fd_sc_hd__and2_1
XFILLER_0_79_111 VGND VGND VPWR VPWR sky130_fd_sc_hd__fill_1
XFILLER_0_95_604 VPWR VGND VPWR VGND sky130_ef_sc_hd__decap_12
XFILLER_0_95_659 VPWR VGND VPWR VGND sky130_ef_sc_hd__decap_12
XFILLER_0_79_199 VGND VGND VPWR VPWR sky130_fd_sc_hd__decap_8
XFILLER_0_79_177 VGND VGND VPWR VPWR sky130_fd_sc_hd__decap_3
X_8727_ clknet_leaf_15_clk _0134_ _0478_ VGND VGND VPWR VPWR bit_sum5\[8\] sky130_fd_sc_hd__dfrtp_1
X_6988_ _3740_ _3709_ _3713_ VGND VGND VPWR VPWR _3974_ sky130_fd_sc_hd__o21a_1
X_5939_ _2908_ _2903_ _2946_ VGND VGND VPWR VPWR _2948_ sky130_fd_sc_hd__a21o_1
X_8658_ clknet_leaf_29_clk net147 _0409_ VGND VGND VPWR VPWR s6\[14\] sky130_fd_sc_hd__dfrtp_1
XFILLER_0_35_225 VPWR VGND VPWR VGND sky130_ef_sc_hd__decap_12
XFILLER_0_106_636 VGND VGND VPWR VPWR sky130_fd_sc_hd__decap_8
XFILLER_0_105_113 VPWR VGND VPWR VGND sky130_ef_sc_hd__decap_12
X_7609_ _4158_ VGND VGND VPWR VPWR _4168_ sky130_fd_sc_hd__buf_8
XFILLER_0_51_718 VGND VGND VPWR VPWR sky130_fd_sc_hd__decap_8
XFILLER_0_7_193 VPWR VGND VPWR VGND sky130_ef_sc_hd__decap_12
X_8589_ clknet_leaf_36_clk _0051_ _0340_ VGND VGND VPWR VPWR sum1\[1\] sky130_fd_sc_hd__dfrtp_1
XFILLER_0_16_472 VGND VGND VPWR VPWR sky130_fd_sc_hd__decap_4
XFILLER_0_16_494 VPWR VGND VPWR VGND sky130_ef_sc_hd__decap_12
XFILLER_0_105_179 VGND VGND VPWR VPWR sky130_fd_sc_hd__decap_8
Xoutput11 net11 VGND VGND VPWR VPWR led[10] sky130_fd_sc_hd__clkbuf_4
Xoutput22 net22 VGND VGND VPWR VPWR led[6] sky130_fd_sc_hd__clkbuf_4
XFILLER_0_31_475 VGND VGND VPWR VPWR sky130_fd_sc_hd__fill_1
XFILLER_0_9_3 VPWR VGND VPWR VGND sky130_ef_sc_hd__decap_12
XFILLER_0_98_475 VGND VGND VPWR VPWR sky130_fd_sc_hd__fill_1
XFILLER_0_98_453 VGND VGND VPWR VPWR sky130_fd_sc_hd__fill_1
XFILLER_0_85_125 VGND VGND VPWR VPWR sky130_fd_sc_hd__decap_6
XFILLER_0_39_553 VGND VGND VPWR VPWR sky130_fd_sc_hd__decap_6
XFILLER_0_85_169 VGND VGND VPWR VPWR sky130_fd_sc_hd__decap_8
XPHY_161 VGND VGND VPWR VPWR sky130_fd_sc_hd__decap_3
XPHY_150 VGND VGND VPWR VPWR sky130_fd_sc_hd__decap_3
XPHY_194 VGND VGND VPWR VPWR sky130_fd_sc_hd__decap_3
XPHY_183 VGND VGND VPWR VPWR sky130_fd_sc_hd__decap_3
XPHY_172 VGND VGND VPWR VPWR sky130_fd_sc_hd__decap_3
XFILLER_0_81_364 VGND VGND VPWR VPWR sky130_fd_sc_hd__fill_1
XFILLER_0_54_589 VPWR VGND VPWR VGND sky130_ef_sc_hd__decap_12
XFILLER_0_54_578 VGND VGND VPWR VPWR sky130_fd_sc_hd__fill_1
XFILLER_0_54_567 VGND VGND VPWR VPWR sky130_fd_sc_hd__decap_4
XFILLER_0_26_269 VGND VGND VPWR VPWR sky130_fd_sc_hd__fill_1
XFILLER_0_78_15 VPWR VGND VPWR VGND sky130_ef_sc_hd__decap_12
XFILLER_0_1_358 VGND VGND VPWR VPWR sky130_fd_sc_hd__fill_2
XFILLER_0_22_464 VPWR VGND VPWR VGND sky130_ef_sc_hd__decap_12
X_4270_ _1315_ _1317_ VGND VGND VPWR VPWR _1318_ sky130_fd_sc_hd__nor2_2
XFILLER_0_118_65 VPWR VGND VPWR VGND sky130_ef_sc_hd__decap_12
X_7960_ _0803_ _0805_ _0804_ VGND VGND VPWR VPWR _0809_ sky130_fd_sc_hd__nor3_1
XFILLER_0_77_615 VGND VGND VPWR VPWR sky130_fd_sc_hd__fill_1
X_7891_ _0735_ _0739_ _0740_ VGND VGND VPWR VPWR _0741_ sky130_fd_sc_hd__nand3_1
X_6911_ _3884_ _3885_ _3887_ _3890_ VGND VGND VPWR VPWR _3899_ sky130_fd_sc_hd__a31o_1
XFILLER_0_77_648 VGND VGND VPWR VPWR sky130_fd_sc_hd__fill_1
XFILLER_0_77_637 VGND VGND VPWR VPWR sky130_fd_sc_hd__fill_2
X_6842_ _3777_ _3792_ VGND VGND VPWR VPWR _3830_ sky130_fd_sc_hd__nand2_1
XFILLER_0_49_317 VGND VGND VPWR VPWR sky130_fd_sc_hd__decap_4
XFILLER_0_43_51 VGND VGND VPWR VPWR sky130_fd_sc_hd__decap_4
XFILLER_0_64_309 VPWR VGND VPWR VGND sky130_ef_sc_hd__decap_12
X_6773_ _3756_ _3759_ _3761_ VGND VGND VPWR VPWR _3762_ sky130_fd_sc_hd__nand3_2
X_8512_ clknet_leaf_40_clk net81 _0263_ VGND VGND VPWR VPWR sum5\[2\] sky130_fd_sc_hd__dfrtp_1
X_5724_ net30 _2518_ VGND VGND VPWR VPWR _2740_ sky130_fd_sc_hd__xor2_2
X_8443_ clknet_leaf_30_clk net416 _0194_ VGND VGND VPWR VPWR carry4\[9\] sky130_fd_sc_hd__dfrtp_1
XFILLER_0_60_504 VGND VGND VPWR VPWR sky130_fd_sc_hd__decap_3
X_5655_ sh9\[0\] VGND VGND VPWR VPWR _2672_ sky130_fd_sc_hd__clkbuf_4
X_4606_ net41 sh0\[7\] VGND VGND VPWR VPWR _1645_ sky130_fd_sc_hd__and2_1
XFILLER_0_115_444 VGND VGND VPWR VPWR sky130_fd_sc_hd__decap_4
XFILLER_0_87_3 VPWR VGND VPWR VGND sky130_ef_sc_hd__decap_12
X_8374_ sum5\[14\] s7\[14\] VGND VGND VPWR VPWR _1207_ sky130_fd_sc_hd__and2_1
XFILLER_0_72_386 VGND VGND VPWR VPWR sky130_fd_sc_hd__fill_1
XFILLER_0_5_653 VPWR VGND VPWR VGND sky130_ef_sc_hd__decap_12
XFILLER_0_4_141 VPWR VGND VPWR VGND sky130_ef_sc_hd__decap_12
XFILLER_0_115_499 VGND VGND VPWR VPWR sky130_fd_sc_hd__fill_1
Xhold310 carry4\[9\] VGND VGND VPWR VPWR net352 sky130_fd_sc_hd__dlygate4sd3_1
XFILLER_0_5_697 VGND VGND VPWR VPWR sky130_fd_sc_hd__decap_8
X_5586_ sh8\[0\] sh9\[0\] sh12\[0\] VGND VGND VPWR VPWR _2604_ sky130_fd_sc_hd__o21ai_2
X_7325_ _4140_ VGND VGND VPWR VPWR _0342_ sky130_fd_sc_hd__inv_2
X_4537_ _1580_ _1527_ _1514_ VGND VGND VPWR VPWR _1581_ sky130_fd_sc_hd__o21ai_1
Xhold321 sh12\[7\] VGND VGND VPWR VPWR net363 sky130_fd_sc_hd__dlygate4sd3_1
Xhold332 _4180_ VGND VGND VPWR VPWR net374 sky130_fd_sc_hd__dlygate4sd3_1
XFILLER_0_7_51 VGND VGND VPWR VPWR sky130_fd_sc_hd__decap_4
XFILLER_0_40_250 VGND VGND VPWR VPWR sky130_fd_sc_hd__fill_2
Xhold343 sum1\[7\] VGND VGND VPWR VPWR net385 sky130_fd_sc_hd__dlygate4sd3_1
XFILLER_0_111_661 VGND VGND VPWR VPWR sky130_fd_sc_hd__fill_1
Xhold387 sh5\[5\] VGND VGND VPWR VPWR net429 sky130_fd_sc_hd__dlygate4sd3_1
X_4468_ _1450_ _1458_ _1439_ VGND VGND VPWR VPWR _1513_ sky130_fd_sc_hd__o21ai_4
Xhold376 carry3\[12\] VGND VGND VPWR VPWR net418 sky130_fd_sc_hd__dlygate4sd3_1
Xhold365 carry3\[9\] VGND VGND VPWR VPWR net407 sky130_fd_sc_hd__dlygate4sd3_1
XFILLER_0_68_81 VGND VGND VPWR VPWR sky130_fd_sc_hd__decap_3
X_7256_ _4133_ VGND VGND VPWR VPWR _0280_ sky130_fd_sc_hd__inv_2
Xhold354 sh6\[2\] VGND VGND VPWR VPWR net396 sky130_fd_sc_hd__dlygate4sd3_1
X_6207_ _2906_ _2922_ sh15\[6\] VGND VGND VPWR VPWR _3212_ sky130_fd_sc_hd__a21oi_1
XFILLER_0_111_694 VPWR VGND VPWR VGND sky130_ef_sc_hd__decap_12
Xhold398 sh15\[5\] VGND VGND VPWR VPWR net440 sky130_fd_sc_hd__dlygate4sd3_1
X_7187_ _4126_ VGND VGND VPWR VPWR _0218_ sky130_fd_sc_hd__inv_2
XFILLER_0_0_380 VGND VGND VPWR VPWR sky130_fd_sc_hd__decap_3
XFILLER_0_0_391 VGND VGND VPWR VPWR sky130_fd_sc_hd__fill_1
X_6138_ _2889_ _2890_ _3137_ VGND VGND VPWR VPWR _3144_ sky130_fd_sc_hd__a21oi_2
X_4399_ _1441_ _1443_ _1444_ VGND VGND VPWR VPWR _1445_ sky130_fd_sc_hd__a21oi_4
XTAP_670 VGND VPWR sky130_fd_sc_hd__tapvpwrvgnd_1
XTAP_681 VGND VPWR sky130_fd_sc_hd__tapvpwrvgnd_1
XTAP_692 VGND VPWR sky130_fd_sc_hd__tapvpwrvgnd_1
X_6069_ _2878_ _2879_ _2911_ VGND VGND VPWR VPWR _3076_ sky130_fd_sc_hd__o21ba_1
XTAP_1825 VGND VPWR sky130_fd_sc_hd__tapvpwrvgnd_1
XTAP_1803 VGND VPWR sky130_fd_sc_hd__tapvpwrvgnd_1
XTAP_1814 VGND VPWR sky130_fd_sc_hd__tapvpwrvgnd_1
XFILLER_0_67_125 VGND VGND VPWR VPWR sky130_fd_sc_hd__decap_8
XTAP_1858 VGND VPWR sky130_fd_sc_hd__tapvpwrvgnd_1
XTAP_1847 VGND VPWR sky130_fd_sc_hd__tapvpwrvgnd_1
XTAP_1836 VGND VPWR sky130_fd_sc_hd__tapvpwrvgnd_1
XFILLER_0_95_445 VGND VGND VPWR VPWR sky130_fd_sc_hd__decap_3
XTAP_1869 VGND VPWR sky130_fd_sc_hd__tapvpwrvgnd_1
XFILLER_0_67_169 VGND VGND VPWR VPWR sky130_fd_sc_hd__decap_6
XFILLER_0_82_139 VGND VGND VPWR VPWR sky130_fd_sc_hd__fill_1
XFILLER_0_36_545 VPWR VGND VPWR VGND sky130_ef_sc_hd__decap_12
XFILLER_0_106_433 VPWR VGND VPWR VGND sky130_ef_sc_hd__decap_12
XFILLER_0_91_673 VGND VGND VPWR VPWR sky130_fd_sc_hd__decap_8
XFILLER_0_90_161 VPWR VGND VPWR VGND sky130_ef_sc_hd__decap_12
XFILLER_0_63_386 VGND VGND VPWR VPWR sky130_fd_sc_hd__decap_6
XFILLER_0_51_537 VPWR VGND VPWR VGND sky130_ef_sc_hd__decap_12
XFILLER_0_106_477 VPWR VGND VPWR VGND sky130_ef_sc_hd__decap_12
XFILLER_0_48_29 VGND VGND VPWR VPWR sky130_fd_sc_hd__decap_4
XFILLER_0_98_261 VGND VGND VPWR VPWR sky130_fd_sc_hd__decap_4
XFILLER_0_59_637 VGND VGND VPWR VPWR sky130_fd_sc_hd__decap_4
XFILLER_0_58_103 VGND VGND VPWR VPWR sky130_fd_sc_hd__decap_3
XFILLER_0_80_27 VGND VGND VPWR VPWR sky130_fd_sc_hd__fill_1
XFILLER_0_74_629 VGND VGND VPWR VPWR sky130_fd_sc_hd__fill_1
XFILLER_0_73_106 VGND VGND VPWR VPWR sky130_fd_sc_hd__decap_6
XFILLER_0_39_350 VGND VGND VPWR VPWR sky130_fd_sc_hd__fill_1
XFILLER_0_46_309 VGND VGND VPWR VPWR sky130_fd_sc_hd__decap_6
XFILLER_0_82_673 VGND VGND VPWR VPWR sky130_fd_sc_hd__fill_1
XFILLER_0_27_556 VGND VGND VPWR VPWR sky130_fd_sc_hd__decap_4
XFILLER_0_81_161 VGND VGND VPWR VPWR sky130_fd_sc_hd__decap_6
X_5440_ _2452_ _2461_ _2462_ VGND VGND VPWR VPWR _0161_ sky130_fd_sc_hd__a21oi_1
XFILLER_0_89_69 VGND VGND VPWR VPWR sky130_fd_sc_hd__decap_8
XFILLER_0_14_239 VPWR VGND VPWR VGND sky130_ef_sc_hd__decap_12
XFILLER_0_2_601 VPWR VGND VPWR VGND sky130_ef_sc_hd__decap_12
XFILLER_0_120_77 VGND VGND VPWR VPWR sky130_fd_sc_hd__decap_6
XFILLER_0_1_111 VGND VGND VPWR VPWR sky130_fd_sc_hd__fill_1
XFILLER_0_2_645 VPWR VGND VPWR VGND sky130_ef_sc_hd__decap_12
X_5371_ _2371_ _2391_ _2395_ VGND VGND VPWR VPWR _2396_ sky130_fd_sc_hd__o21ai_2
X_4322_ _1354_ _1355_ _1361_ _1363_ _1368_ VGND VGND VPWR VPWR _1369_ sky130_fd_sc_hd__o2111ai_4
X_8090_ _0933_ _0934_ _0936_ VGND VGND VPWR VPWR _0937_ sky130_fd_sc_hd__nand3_4
X_7110_ _4087_ _4088_ _4055_ VGND VGND VPWR VPWR _4094_ sky130_fd_sc_hd__o21ai_1
X_4253_ _1298_ _1300_ VGND VGND VPWR VPWR _1301_ sky130_fd_sc_hd__nor2_1
XFILLER_0_59_7 VGND VGND VPWR VPWR sky130_fd_sc_hd__fill_1
X_7041_ _4024_ _4025_ sh14\[1\] VGND VGND VPWR VPWR _4026_ sky130_fd_sc_hd__and3b_1
XFILLER_0_96_209 VGND VGND VPWR VPWR sky130_fd_sc_hd__fill_1
X_7943_ _0778_ _0783_ _0785_ VGND VGND VPWR VPWR _0792_ sky130_fd_sc_hd__a21o_1
XFILLER_0_54_83 VGND VGND VPWR VPWR sky130_fd_sc_hd__fill_1
X_7874_ sh10\[3\] sh11\[3\] VGND VGND VPWR VPWR _0724_ sky130_fd_sc_hd__nor2_1
X_6825_ _3793_ _3794_ _3813_ VGND VGND VPWR VPWR _3814_ sky130_fd_sc_hd__a21bo_1
XFILLER_0_49_169 VGND VGND VPWR VPWR sky130_fd_sc_hd__decap_6
XFILLER_0_64_139 VGND VGND VPWR VPWR sky130_fd_sc_hd__fill_1
X_6756_ _3744_ VGND VGND VPWR VPWR _3745_ sky130_fd_sc_hd__clkbuf_4
XFILLER_0_73_673 VPWR VGND VPWR VGND sky130_ef_sc_hd__decap_12
X_5707_ _2664_ _2723_ VGND VGND VPWR VPWR _0175_ sky130_fd_sc_hd__xor2_1
XFILLER_0_45_331 VGND VGND VPWR VPWR sky130_fd_sc_hd__decap_4
XFILLER_0_45_353 VGND VGND VPWR VPWR sky130_fd_sc_hd__decap_3
XFILLER_0_115_241 VGND VGND VPWR VPWR sky130_fd_sc_hd__decap_3
X_6687_ _3680_ _3678_ VGND VGND VPWR VPWR _3681_ sky130_fd_sc_hd__nand2_1
XFILLER_0_18_589 VPWR VGND VPWR VGND sky130_ef_sc_hd__decap_12
X_8426_ _1255_ _1244_ _1252_ VGND VGND VPWR VPWR _1256_ sky130_fd_sc_hd__o21ai_2
X_5638_ _2610_ _2611_ _2614_ _2638_ _2639_ VGND VGND VPWR VPWR _2656_ sky130_fd_sc_hd__o2111a_1
XFILLER_0_33_559 VGND VGND VPWR VPWR sky130_fd_sc_hd__fill_1
XFILLER_0_115_296 VGND VGND VPWR VPWR sky130_fd_sc_hd__fill_2
X_8357_ _1178_ _1180_ _1190_ _1191_ VGND VGND VPWR VPWR _1192_ sky130_fd_sc_hd__o211a_1
X_5569_ _2576_ _2577_ _2578_ _2569_ VGND VGND VPWR VPWR _2588_ sky130_fd_sc_hd__o211ai_4
Xhold140 sh9\[4\] VGND VGND VPWR VPWR net182 sky130_fd_sc_hd__dlygate4sd3_1
X_7308_ _4138_ VGND VGND VPWR VPWR _0327_ sky130_fd_sc_hd__inv_2
Xhold151 sh11\[2\] VGND VGND VPWR VPWR net193 sky130_fd_sc_hd__dlygate4sd3_1
Xhold162 final_sum\[0\] VGND VGND VPWR VPWR net204 sky130_fd_sc_hd__dlygate4sd3_1
XFILLER_0_41_581 VPWR VGND VPWR VGND sky130_ef_sc_hd__decap_12
Xhold173 sh7\[4\] VGND VGND VPWR VPWR net215 sky130_fd_sc_hd__dlygate4sd3_1
X_8288_ _1087_ _1130_ _1118_ VGND VGND VPWR VPWR _1131_ sky130_fd_sc_hd__a21o_1
Xhold195 s2\[4\] VGND VGND VPWR VPWR net237 sky130_fd_sc_hd__clkdlybuf4s25_1
Xhold184 _0057_ VGND VGND VPWR VPWR net226 sky130_fd_sc_hd__dlygate4sd3_1
X_7239_ _4131_ VGND VGND VPWR VPWR _0265_ sky130_fd_sc_hd__inv_2
XTAP_1600 VGND VPWR sky130_fd_sc_hd__tapvpwrvgnd_1
XFILLER_0_68_412 VGND VGND VPWR VPWR sky130_fd_sc_hd__decap_8
XTAP_1633 VGND VPWR sky130_fd_sc_hd__tapvpwrvgnd_1
XTAP_1622 VGND VPWR sky130_fd_sc_hd__tapvpwrvgnd_1
XTAP_1611 VGND VPWR sky130_fd_sc_hd__tapvpwrvgnd_1
XTAP_1666 VGND VPWR sky130_fd_sc_hd__tapvpwrvgnd_1
XTAP_1655 VGND VPWR sky130_fd_sc_hd__tapvpwrvgnd_1
XTAP_1644 VGND VPWR sky130_fd_sc_hd__tapvpwrvgnd_1
XFILLER_0_83_415 VGND VGND VPWR VPWR sky130_fd_sc_hd__decap_8
XFILLER_0_28_309 VGND VGND VPWR VPWR sky130_fd_sc_hd__decap_3
XTAP_1699 VGND VPWR sky130_fd_sc_hd__tapvpwrvgnd_1
XTAP_1688 VGND VPWR sky130_fd_sc_hd__tapvpwrvgnd_1
XTAP_1677 VGND VPWR sky130_fd_sc_hd__tapvpwrvgnd_1
XFILLER_0_106_230 VGND VGND VPWR VPWR sky130_fd_sc_hd__fill_2
XFILLER_0_122_701 VPWR VGND VPWR VGND sky130_ef_sc_hd__decap_12
XFILLER_0_75_27 VPWR VGND VPWR VGND sky130_ef_sc_hd__decap_12
XFILLER_0_91_15 VPWR VGND VPWR VGND sky130_ef_sc_hd__decap_12
XFILLER_0_87_732 VGND VGND VPWR VPWR sky130_fd_sc_hd__decap_3
X_4940_ _1965_ _1966_ _1969_ VGND VGND VPWR VPWR _1974_ sky130_fd_sc_hd__o21ai_2
XFILLER_0_115_55 VGND VGND VPWR VPWR sky130_fd_sc_hd__fill_1
X_4871_ _1905_ _1906_ VGND VGND VPWR VPWR _1907_ sky130_fd_sc_hd__or2b_1
XFILLER_0_59_489 VGND VGND VPWR VPWR sky130_fd_sc_hd__decap_8
XFILLER_0_59_478 VGND VGND VPWR VPWR sky130_fd_sc_hd__decap_3
X_6610_ _3603_ _3604_ _3311_ VGND VGND VPWR VPWR _3605_ sky130_fd_sc_hd__o21ai_4
X_7590_ _4166_ VGND VGND VPWR VPWR _0581_ sky130_fd_sc_hd__inv_2
XFILLER_0_46_139 VGND VGND VPWR VPWR sky130_fd_sc_hd__fill_1
XFILLER_0_117_539 VGND VGND VPWR VPWR sky130_fd_sc_hd__decap_8
X_6541_ _3527_ _3529_ _3531_ VGND VGND VPWR VPWR _3538_ sky130_fd_sc_hd__a21o_1
XFILLER_0_82_470 VGND VGND VPWR VPWR sky130_fd_sc_hd__decap_6
XFILLER_0_15_515 VPWR VGND VPWR VGND sky130_ef_sc_hd__decap_12
XFILLER_0_27_375 VGND VGND VPWR VPWR sky130_fd_sc_hd__fill_1
XFILLER_0_40_41 VPWR VGND VPWR VGND sky130_ef_sc_hd__decap_12
XFILLER_0_70_654 VPWR VGND VPWR VGND sky130_ef_sc_hd__decap_12
XFILLER_0_70_643 VGND VGND VPWR VPWR sky130_fd_sc_hd__fill_1
X_6472_ _3388_ _3389_ VGND VGND VPWR VPWR _3470_ sky130_fd_sc_hd__or2_1
XFILLER_0_40_85 VGND VGND VPWR VPWR sky130_fd_sc_hd__decap_6
XFILLER_0_42_334 VGND VGND VPWR VPWR sky130_fd_sc_hd__fill_2
XFILLER_0_70_698 VGND VGND VPWR VPWR sky130_fd_sc_hd__fill_2
X_8211_ _0736_ _0750_ _0746_ VGND VGND VPWR VPWR _1056_ sky130_fd_sc_hd__o21a_1
XFILLER_0_30_518 VPWR VGND VPWR VGND sky130_ef_sc_hd__decap_12
X_5423_ _2445_ _2446_ VGND VGND VPWR VPWR _2447_ sky130_fd_sc_hd__nor2_1
XFILLER_0_100_417 VGND VGND VPWR VPWR sky130_fd_sc_hd__decap_3
XFILLER_0_100_406 VGND VGND VPWR VPWR sky130_fd_sc_hd__decap_4
XFILLER_0_11_721 VGND VGND VPWR VPWR sky130_fd_sc_hd__decap_6
XFILLER_0_2_475 VGND VGND VPWR VPWR sky130_fd_sc_hd__fill_1
X_5354_ sh4\[2\] _2037_ sh6\[2\] VGND VGND VPWR VPWR _2379_ sky130_fd_sc_hd__o21ai_4
X_8142_ _0987_ _0988_ _0980_ VGND VGND VPWR VPWR _0989_ sky130_fd_sc_hd__o21bai_2
X_4305_ _1351_ _1343_ _1341_ VGND VGND VPWR VPWR _1353_ sky130_fd_sc_hd__and3_1
X_5285_ _2307_ _2309_ _2311_ VGND VGND VPWR VPWR _2312_ sky130_fd_sc_hd__a21oi_2
X_8073_ _0915_ _0920_ _0767_ VGND VGND VPWR VPWR _0921_ sky130_fd_sc_hd__o21ai_1
X_4236_ _1269_ _1271_ _1246_ VGND VGND VPWR VPWR _1284_ sky130_fd_sc_hd__o21ai_1
XFILLER_0_4_41 VPWR VGND VPWR VGND sky130_ef_sc_hd__decap_12
X_7024_ _3954_ _3957_ _4009_ VGND VGND VPWR VPWR _4010_ sky130_fd_sc_hd__a21o_1
XFILLER_0_4_85 VPWR VGND VPWR VGND sky130_ef_sc_hd__decap_12
X_7926_ net42 sh2\[3\] VGND VGND VPWR VPWR _0775_ sky130_fd_sc_hd__nor2_2
XFILLER_0_93_713 VPWR VGND VPWR VGND sky130_ef_sc_hd__decap_12
XFILLER_0_81_81 VPWR VGND VPWR VGND sky130_ef_sc_hd__decap_12
X_7857_ carry4\[10\] net357 net309 VGND VGND VPWR VPWR _0714_ sky130_fd_sc_hd__o21a_1
XFILLER_0_77_242 VPWR VGND VPWR VGND sky130_ef_sc_hd__decap_12
X_6808_ sh4\[1\] VGND VGND VPWR VPWR _3797_ sky130_fd_sc_hd__inv_2
XFILLER_0_108_539 VGND VGND VPWR VPWR sky130_fd_sc_hd__decap_8
XFILLER_0_80_407 VPWR VGND VPWR VGND sky130_ef_sc_hd__decap_12
X_7788_ carry2\[10\] net243 _0679_ VGND VGND VPWR VPWR _0021_ sky130_fd_sc_hd__o21a_1
XFILLER_0_52_109 VPWR VGND VPWR VGND sky130_ef_sc_hd__decap_12
X_6739_ _3715_ _3711_ _3714_ _3728_ VGND VGND VPWR VPWR _3729_ sky130_fd_sc_hd__a31o_1
XFILLER_0_33_312 VPWR VGND VPWR VGND sky130_ef_sc_hd__decap_12
XFILLER_0_45_172 VGND VGND VPWR VPWR sky130_fd_sc_hd__fill_2
XFILLER_0_104_701 VPWR VGND VPWR VGND sky130_ef_sc_hd__decap_12
X_8409_ sh0\[5\] VGND VGND VPWR VPWR _1239_ sky130_fd_sc_hd__clkbuf_4
XFILLER_0_60_153 VPWR VGND VPWR VGND sky130_ef_sc_hd__decap_12
XFILLER_0_21_529 VPWR VGND VPWR VGND sky130_ef_sc_hd__decap_12
XFILLER_0_14_570 VPWR VGND VPWR VGND sky130_ef_sc_hd__decap_12
XTAP_1441 VGND VPWR sky130_fd_sc_hd__tapvpwrvgnd_1
XTAP_1430 VGND VPWR sky130_fd_sc_hd__tapvpwrvgnd_1
XFILLER_0_68_253 VGND VGND VPWR VPWR sky130_fd_sc_hd__decap_6
XTAP_1463 VGND VPWR sky130_fd_sc_hd__tapvpwrvgnd_1
XTAP_1474 VGND VPWR sky130_fd_sc_hd__tapvpwrvgnd_1
XTAP_1452 VGND VPWR sky130_fd_sc_hd__tapvpwrvgnd_1
XFILLER_0_83_223 VGND VGND VPWR VPWR sky130_fd_sc_hd__fill_1
XFILLER_0_28_128 VPWR VGND VPWR VGND sky130_ef_sc_hd__decap_12
XTAP_1496 VGND VPWR sky130_fd_sc_hd__tapvpwrvgnd_1
XTAP_1485 VGND VPWR sky130_fd_sc_hd__tapvpwrvgnd_1
XFILLER_0_37_673 VPWR VGND VPWR VGND sky130_ef_sc_hd__decap_12
XFILLER_0_107_561 VGND VGND VPWR VPWR sky130_fd_sc_hd__fill_1
XFILLER_0_52_643 VGND VGND VPWR VPWR sky130_fd_sc_hd__fill_1
XFILLER_0_3_217 VGND VGND VPWR VPWR sky130_fd_sc_hd__decap_6
XFILLER_0_101_68 VGND VGND VPWR VPWR sky130_fd_sc_hd__decap_8
XFILLER_0_101_57 VGND VGND VPWR VPWR sky130_fd_sc_hd__decap_6
XFILLER_0_52_665 VGND VGND VPWR VPWR sky130_fd_sc_hd__decap_6
XFILLER_0_12_518 VPWR VGND VPWR VGND sky130_ef_sc_hd__decap_12
XFILLER_0_51_153 VGND VGND VPWR VPWR sky130_fd_sc_hd__decap_6
XFILLER_0_52_698 VGND VGND VPWR VPWR sky130_fd_sc_hd__fill_2
XFILLER_0_10_77 VGND VGND VPWR VPWR sky130_fd_sc_hd__decap_6
XFILLER_0_51_175 VGND VGND VPWR VPWR sky130_fd_sc_hd__fill_1
XFILLER_0_86_15 VPWR VGND VPWR VGND sky130_ef_sc_hd__decap_12
XFILLER_0_20_540 VPWR VGND VPWR VGND sky130_ef_sc_hd__decap_12
XFILLER_0_19_31 VGND VGND VPWR VPWR sky130_fd_sc_hd__fill_1
X_5070_ _2061_ _2038_ VGND VGND VPWR VPWR _2099_ sky130_fd_sc_hd__nor2_1
X_5972_ _2967_ _2973_ _2980_ VGND VGND VPWR VPWR _2981_ sky130_fd_sc_hd__a21o_1
X_8760_ clknet_leaf_4_clk net178 _0511_ VGND VGND VPWR VPWR sh1\[4\] sky130_fd_sc_hd__dfrtp_1
X_4923_ sh4\[7\] _1668_ VGND VGND VPWR VPWR _1957_ sky130_fd_sc_hd__and2_1
X_7711_ net305 _0627_ VGND VGND VPWR VPWR _0064_ sky130_fd_sc_hd__xnor2_1
XFILLER_0_74_201 VPWR VGND VPWR VGND sky130_ef_sc_hd__decap_12
X_8691_ clknet_leaf_58_clk _0155_ _0442_ VGND VGND VPWR VPWR bit_sum2\[2\] sky130_fd_sc_hd__dfrtp_1
X_4854_ _1637_ _1639_ _1793_ _1796_ _1696_ VGND VGND VPWR VPWR _1890_ sky130_fd_sc_hd__a221o_1
XFILLER_0_74_245 VGND VGND VPWR VPWR sky130_fd_sc_hd__decap_6
X_7642_ net345 _4170_ _4171_ VGND VGND VPWR VPWR _4173_ sky130_fd_sc_hd__or3_1
XFILLER_0_7_501 VGND VGND VPWR VPWR sky130_fd_sc_hd__decap_3
XFILLER_0_51_51 VGND VGND VPWR VPWR sky130_fd_sc_hd__decap_4
X_4785_ _1767_ _1753_ _1819_ _1821_ VGND VGND VPWR VPWR _1822_ sky130_fd_sc_hd__o211ai_2
XFILLER_0_74_289 VPWR VGND VPWR VGND sky130_ef_sc_hd__decap_12
X_7573_ _4164_ VGND VGND VPWR VPWR _0566_ sky130_fd_sc_hd__inv_2
XFILLER_0_62_429 VGND VGND VPWR VPWR sky130_fd_sc_hd__decap_3
XFILLER_0_27_150 VGND VGND VPWR VPWR sky130_fd_sc_hd__fill_1
X_6524_ _3515_ _3517_ _3520_ VGND VGND VPWR VPWR _3521_ sky130_fd_sc_hd__nand3_2
XFILLER_0_43_654 VPWR VGND VPWR VGND sky130_ef_sc_hd__decap_12
XFILLER_0_42_153 VGND VGND VPWR VPWR sky130_fd_sc_hd__decap_8
XFILLER_0_101_704 VPWR VGND VPWR VGND sky130_ef_sc_hd__decap_12
X_6455_ _3452_ _3449_ _3446_ VGND VGND VPWR VPWR _3453_ sky130_fd_sc_hd__a21oi_2
XFILLER_0_42_197 VPWR VGND VPWR VGND sky130_ef_sc_hd__decap_12
XFILLER_0_100_225 VGND VGND VPWR VPWR sky130_fd_sc_hd__fill_1
X_6386_ _3372_ _3375_ _3384_ VGND VGND VPWR VPWR _3385_ sky130_fd_sc_hd__a21o_1
X_5406_ _2385_ _2428_ _2429_ VGND VGND VPWR VPWR _2430_ sky130_fd_sc_hd__a21oi_1
X_8125_ _0961_ VGND VGND VPWR VPWR _0972_ sky130_fd_sc_hd__inv_2
X_5337_ _2306_ _2316_ _2356_ _2362_ VGND VGND VPWR VPWR _2363_ sky130_fd_sc_hd__o211ai_2
X_5268_ _2196_ _2195_ VGND VGND VPWR VPWR _2295_ sky130_fd_sc_hd__nor2_1
X_8056_ _0891_ _0890_ _0841_ _0903_ VGND VGND VPWR VPWR _0904_ sky130_fd_sc_hd__o2bb2ai_2
X_4219_ _1237_ _1238_ _1266_ VGND VGND VPWR VPWR _1267_ sky130_fd_sc_hd__a21o_1
X_7007_ _3940_ _3936_ _3924_ VGND VGND VPWR VPWR _3993_ sky130_fd_sc_hd__a21oi_1
X_5199_ _2150_ _2156_ _2215_ _2221_ VGND VGND VPWR VPWR _2227_ sky130_fd_sc_hd__o211a_1
XFILLER_0_66_713 VPWR VGND VPWR VGND sky130_ef_sc_hd__decap_12
X_7909_ _0728_ _0729_ _0755_ _0756_ VGND VGND VPWR VPWR _0759_ sky130_fd_sc_hd__a2bb2o_1
XFILLER_0_65_212 VGND VGND VPWR VPWR sky130_fd_sc_hd__fill_2
XFILLER_0_53_407 VGND VGND VPWR VPWR sky130_fd_sc_hd__decap_4
XFILLER_0_108_336 VGND VGND VPWR VPWR sky130_fd_sc_hd__fill_2
XFILLER_0_65_267 VGND VGND VPWR VPWR sky130_fd_sc_hd__decap_8
XFILLER_0_19_673 VPWR VGND VPWR VGND sky130_ef_sc_hd__decap_12
XFILLER_0_18_194 VGND VGND VPWR VPWR sky130_fd_sc_hd__fill_2
XFILLER_0_34_643 VGND VGND VPWR VPWR sky130_fd_sc_hd__fill_1
XFILLER_0_0_209 VPWR VGND VPWR VGND sky130_ef_sc_hd__decap_12
XFILLER_0_56_18 VGND VGND VPWR VPWR sky130_fd_sc_hd__decap_8
XFILLER_0_8_309 VGND VGND VPWR VPWR sky130_fd_sc_hd__decap_8
XFILLER_0_29_437 VGND VGND VPWR VPWR sky130_fd_sc_hd__decap_8
XTAP_1293 VGND VPWR sky130_fd_sc_hd__tapvpwrvgnd_1
XTAP_1282 VGND VPWR sky130_fd_sc_hd__tapvpwrvgnd_1
XTAP_1271 VGND VPWR sky130_fd_sc_hd__tapvpwrvgnd_1
XTAP_1260 VGND VPWR sky130_fd_sc_hd__tapvpwrvgnd_1
XFILLER_0_44_418 VGND VGND VPWR VPWR sky130_fd_sc_hd__fill_2
X_4570_ sh15\[5\] _1227_ _1299_ _1605_ _1608_ VGND VGND VPWR VPWR _1613_ sky130_fd_sc_hd__a32o_1
XFILLER_0_71_259 VGND VGND VPWR VPWR sky130_fd_sc_hd__fill_1
XFILLER_0_108_3 VPWR VGND VPWR VGND sky130_ef_sc_hd__decap_12
XFILLER_0_52_440 VGND VGND VPWR VPWR sky130_fd_sc_hd__fill_1
XFILLER_0_4_537 VGND VGND VPWR VPWR sky130_fd_sc_hd__fill_1
XFILLER_0_21_98 VGND VGND VPWR VPWR sky130_fd_sc_hd__fill_2
XFILLER_0_97_47 VGND VGND VPWR VPWR sky130_fd_sc_hd__decap_8
XFILLER_0_97_36 VGND VGND VPWR VPWR sky130_fd_sc_hd__decap_3
XFILLER_0_52_484 VGND VGND VPWR VPWR sky130_fd_sc_hd__decap_4
X_6240_ _3244_ VGND VGND VPWR VPWR _0141_ sky130_fd_sc_hd__clkbuf_1
X_6171_ _3176_ _3173_ _3136_ VGND VGND VPWR VPWR _3177_ sky130_fd_sc_hd__a21oi_2
XFILLER_0_110_589 VGND VGND VPWR VPWR sky130_fd_sc_hd__decap_3
X_5122_ _2097_ _2117_ _2113_ _2114_ VGND VGND VPWR VPWR _2151_ sky130_fd_sc_hd__o2bb2ai_2
X_5053_ _2080_ _2081_ VGND VGND VPWR VPWR _2083_ sky130_fd_sc_hd__and2b_1
XFILLER_0_46_51 VGND VGND VPWR VPWR sky130_fd_sc_hd__fill_1
XFILLER_0_46_73 VGND VGND VPWR VPWR sky130_fd_sc_hd__decap_8
X_8812_ clknet_leaf_47_clk net36 _0563_ VGND VGND VPWR VPWR sh8\[0\] sky130_fd_sc_hd__dfrtp_4
X_8743_ clknet_leaf_21_clk _0184_ _0494_ VGND VGND VPWR VPWR bit_sum7\[4\] sky130_fd_sc_hd__dfrtp_1
X_5955_ _2924_ _2926_ _2923_ _2928_ VGND VGND VPWR VPWR _2964_ sky130_fd_sc_hd__o22a_1
XFILLER_0_75_532 VGND VGND VPWR VPWR sky130_fd_sc_hd__decap_4
X_4906_ _1939_ _1940_ VGND VGND VPWR VPWR _1941_ sky130_fd_sc_hd__nand2_1
X_5886_ net37 _2894_ VGND VGND VPWR VPWR _2896_ sky130_fd_sc_hd__and2_1
X_8674_ clknet_leaf_43_clk _0176_ _0425_ VGND VGND VPWR VPWR bit_sum0\[5\] sky130_fd_sc_hd__dfrtp_1
XFILLER_0_118_645 VGND VGND VPWR VPWR sky130_fd_sc_hd__fill_2
X_4837_ _1797_ _1798_ _1720_ VGND VGND VPWR VPWR _1873_ sky130_fd_sc_hd__o21a_1
X_7625_ _4169_ VGND VGND VPWR VPWR _0613_ sky130_fd_sc_hd__inv_2
XFILLER_0_47_278 VGND VGND VPWR VPWR sky130_fd_sc_hd__fill_2
XFILLER_0_118_689 VGND VGND VPWR VPWR sky130_fd_sc_hd__decap_8
XFILLER_0_117_166 VGND VGND VPWR VPWR sky130_fd_sc_hd__fill_2
XFILLER_0_7_353 VGND VGND VPWR VPWR sky130_fd_sc_hd__fill_1
XFILLER_0_117_199 VPWR VGND VPWR VGND sky130_ef_sc_hd__decap_12
X_4768_ _1783_ _1787_ _1788_ VGND VGND VPWR VPWR _1805_ sky130_fd_sc_hd__a21o_1
XFILLER_0_90_568 VPWR VGND VPWR VGND sky130_ef_sc_hd__decap_12
X_7556_ _4163_ VGND VGND VPWR VPWR _0550_ sky130_fd_sc_hd__inv_2
XFILLER_0_15_153 VGND VGND VPWR VPWR sky130_fd_sc_hd__decap_8
XFILLER_0_120_309 VGND VGND VPWR VPWR sky130_fd_sc_hd__decap_6
X_4699_ _1680_ _1692_ _1689_ VGND VGND VPWR VPWR _1737_ sky130_fd_sc_hd__nand3_2
X_7487_ _4147_ VGND VGND VPWR VPWR _4156_ sky130_fd_sc_hd__buf_4
X_6507_ _3486_ _3431_ _3436_ VGND VGND VPWR VPWR _3504_ sky130_fd_sc_hd__o21ai_1
XFILLER_0_70_270 VGND VGND VPWR VPWR sky130_fd_sc_hd__decap_8
XFILLER_0_43_495 VGND VGND VPWR VPWR sky130_fd_sc_hd__fill_1
XFILLER_0_113_361 VGND VGND VPWR VPWR sky130_fd_sc_hd__decap_8
X_6438_ _3432_ _3426_ _3368_ _3427_ VGND VGND VPWR VPWR _3436_ sky130_fd_sc_hd__o211ai_4
XFILLER_0_101_567 VPWR VGND VPWR VGND sky130_ef_sc_hd__decap_12
X_6369_ _3366_ _3367_ VGND VGND VPWR VPWR _3368_ sky130_fd_sc_hd__nand2_4
X_8108_ _0762_ sh9\[3\] _0726_ VGND VGND VPWR VPWR _0955_ sky130_fd_sc_hd__o21a_1
Xhold22 bit_sum5\[6\] VGND VGND VPWR VPWR net64 sky130_fd_sc_hd__dlygate4sd3_1
Xhold11 bit_sum1\[5\] VGND VGND VPWR VPWR net53 sky130_fd_sc_hd__dlygate4sd3_1
Xhold33 bit_sum7\[2\] VGND VGND VPWR VPWR net75 sky130_fd_sc_hd__dlygate4sd3_1
Xhold44 bit_sum1\[2\] VGND VGND VPWR VPWR net86 sky130_fd_sc_hd__dlygate4sd3_1
Xhold55 bit_sum0\[6\] VGND VGND VPWR VPWR net97 sky130_fd_sc_hd__dlygate4sd3_1
X_8039_ _0762_ sh9\[3\] VGND VGND VPWR VPWR _0887_ sky130_fd_sc_hd__and2_2
Xhold77 bit_sum6\[5\] VGND VGND VPWR VPWR net119 sky130_fd_sc_hd__dlygate4sd3_1
Xhold99 bit_sum6\[3\] VGND VGND VPWR VPWR net141 sky130_fd_sc_hd__dlygate4sd3_1
Xhold66 bit_sum1\[4\] VGND VGND VPWR VPWR net108 sky130_fd_sc_hd__dlygate4sd3_1
Xhold88 bit_sum0\[5\] VGND VGND VPWR VPWR net130 sky130_fd_sc_hd__dlygate4sd3_1
XFILLER_0_38_245 VGND VGND VPWR VPWR sky130_fd_sc_hd__decap_6
XFILLER_0_109_656 VGND VGND VPWR VPWR sky130_fd_sc_hd__decap_4
XFILLER_0_93_373 VPWR VGND VPWR VGND sky130_ef_sc_hd__decap_12
XFILLER_0_81_557 VGND VGND VPWR VPWR sky130_fd_sc_hd__decap_3
XFILLER_0_19_492 VGND VGND VPWR VPWR sky130_fd_sc_hd__decap_4
XFILLER_0_123_125 VPWR VGND VPWR VGND sky130_ef_sc_hd__decap_12
XFILLER_0_34_440 VGND VGND VPWR VPWR sky130_fd_sc_hd__decap_8
XFILLER_0_123_169 VPWR VGND VPWR VGND sky130_ef_sc_hd__decap_12
XFILLER_0_61_281 VGND VGND VPWR VPWR sky130_fd_sc_hd__decap_6
XFILLER_0_34_473 VGND VGND VPWR VPWR sky130_fd_sc_hd__decap_3
XFILLER_0_1_529 VPWR VGND VPWR VGND sky130_ef_sc_hd__decap_12
XTAP_329 VGND VPWR sky130_fd_sc_hd__tapvpwrvgnd_1
XTAP_318 VGND VPWR sky130_fd_sc_hd__tapvpwrvgnd_1
XTAP_307 VGND VPWR sky130_fd_sc_hd__tapvpwrvgnd_1
XFILLER_0_83_27 VPWR VGND VPWR VGND sky130_ef_sc_hd__decap_12
XFILLER_0_88_156 VGND VGND VPWR VPWR sky130_fd_sc_hd__fill_1
XFILLER_0_76_307 VGND VGND VPWR VPWR sky130_fd_sc_hd__fill_1
XFILLER_0_16_98 VGND VGND VPWR VPWR sky130_fd_sc_hd__decap_3
XFILLER_0_57_532 VPWR VGND VPWR VGND sky130_ef_sc_hd__decap_12
XFILLER_0_9_629 VPWR VGND VPWR VGND sky130_ef_sc_hd__decap_12
X_5740_ _2749_ _2750_ _2743_ _2747_ VGND VGND VPWR VPWR _2756_ sky130_fd_sc_hd__a2bb2o_1
XFILLER_0_29_223 VGND VGND VPWR VPWR sky130_fd_sc_hd__fill_1
XFILLER_0_84_373 VGND VGND VPWR VPWR sky130_fd_sc_hd__fill_1
XFILLER_0_84_351 VGND VGND VPWR VPWR sky130_fd_sc_hd__decap_8
XTAP_1090 VGND VPWR sky130_fd_sc_hd__tapvpwrvgnd_1
XFILLER_0_8_139 VGND VGND VPWR VPWR sky130_fd_sc_hd__fill_1
XFILLER_0_45_727 VGND VGND VPWR VPWR sky130_fd_sc_hd__fill_1
XFILLER_0_115_604 VGND VGND VPWR VPWR sky130_fd_sc_hd__decap_8
XFILLER_0_72_557 VGND VGND VPWR VPWR sky130_fd_sc_hd__fill_2
X_5671_ _2684_ _2685_ _2687_ VGND VGND VPWR VPWR _2688_ sky130_fd_sc_hd__nand3_2
X_7410_ _4147_ VGND VGND VPWR VPWR _4149_ sky130_fd_sc_hd__buf_4
XFILLER_0_115_626 VGND VGND VPWR VPWR sky130_fd_sc_hd__decap_8
X_4622_ _1656_ _1655_ _1660_ VGND VGND VPWR VPWR _1661_ sky130_fd_sc_hd__or3b_2
X_8390_ _1217_ _1221_ VGND VGND VPWR VPWR _0169_ sky130_fd_sc_hd__xnor2_1
X_4553_ _1243_ _1223_ _1549_ VGND VGND VPWR VPWR _1596_ sky130_fd_sc_hd__a21oi_2
XFILLER_0_102_309 VGND VGND VPWR VPWR sky130_fd_sc_hd__fill_1
XFILLER_0_4_345 VPWR VGND VPWR VGND sky130_ef_sc_hd__decap_12
X_7341_ _4141_ VGND VGND VPWR VPWR _0357_ sky130_fd_sc_hd__inv_2
XFILLER_0_40_421 VGND VGND VPWR VPWR sky130_fd_sc_hd__decap_8
X_4484_ _1528_ _1522_ _1520_ VGND VGND VPWR VPWR _1529_ sky130_fd_sc_hd__a21oi_1
X_7272_ _4134_ VGND VGND VPWR VPWR _0295_ sky130_fd_sc_hd__inv_2
X_6223_ _3174_ _3190_ _3224_ _3227_ VGND VGND VPWR VPWR _3228_ sky130_fd_sc_hd__o211a_1
XFILLER_0_0_573 VPWR VGND VPWR VGND sky130_ef_sc_hd__decap_12
X_6154_ _2870_ _2872_ _2926_ _3159_ VGND VGND VPWR VPWR _3160_ sky130_fd_sc_hd__or4_2
XFILLER_0_57_50 VGND VGND VPWR VPWR sky130_fd_sc_hd__decap_6
XTAP_830 VGND VPWR sky130_fd_sc_hd__tapvpwrvgnd_1
XTAP_841 VGND VPWR sky130_fd_sc_hd__tapvpwrvgnd_1
XTAP_852 VGND VPWR sky130_fd_sc_hd__tapvpwrvgnd_1
X_6085_ _3000_ _3016_ _3080_ _2882_ _3081_ VGND VGND VPWR VPWR _3092_ sky130_fd_sc_hd__o221a_2
XFILLER_0_57_83 VGND VGND VPWR VPWR sky130_fd_sc_hd__decap_8
X_5105_ _2129_ _2130_ _2132_ _2082_ VGND VGND VPWR VPWR _2134_ sky130_fd_sc_hd__o31ai_4
XTAP_874 VGND VPWR sky130_fd_sc_hd__tapvpwrvgnd_1
XTAP_863 VGND VPWR sky130_fd_sc_hd__tapvpwrvgnd_1
XTAP_885 VGND VPWR sky130_fd_sc_hd__tapvpwrvgnd_1
X_5036_ net38 sh7\[2\] VGND VGND VPWR VPWR _2066_ sky130_fd_sc_hd__nor2_1
XFILLER_0_32_3 VPWR VGND VPWR VGND sky130_ef_sc_hd__decap_12
XTAP_896 VGND VPWR sky130_fd_sc_hd__tapvpwrvgnd_1
XFILLER_0_79_167 VGND VGND VPWR VPWR sky130_fd_sc_hd__fill_1
X_6987_ _3972_ _3968_ VGND VGND VPWR VPWR _3973_ sky130_fd_sc_hd__nand2_4
X_5938_ _2902_ _2877_ _2908_ _2946_ VGND VGND VPWR VPWR _2947_ sky130_fd_sc_hd__o211a_1
X_8726_ clknet_leaf_14_clk _0133_ _0477_ VGND VGND VPWR VPWR bit_sum5\[7\] sky130_fd_sc_hd__dfrtp_1
X_5869_ sh0\[6\] VGND VGND VPWR VPWR _2879_ sky130_fd_sc_hd__clkbuf_4
X_8657_ clknet_leaf_29_clk net92 _0408_ VGND VGND VPWR VPWR s6\[13\] sky130_fd_sc_hd__dfrtp_1
XFILLER_0_63_546 VGND VGND VPWR VPWR sky130_fd_sc_hd__fill_1
XFILLER_0_35_237 VGND VGND VPWR VPWR sky130_fd_sc_hd__fill_1
XFILLER_0_105_125 VPWR VGND VPWR VGND sky130_ef_sc_hd__decap_12
XFILLER_0_105_103 VGND VGND VPWR VPWR sky130_fd_sc_hd__fill_2
X_7608_ _4167_ VGND VGND VPWR VPWR _0598_ sky130_fd_sc_hd__inv_2
XFILLER_0_7_161 VGND VGND VPWR VPWR sky130_fd_sc_hd__decap_6
X_8588_ clknet_leaf_37_clk net61 _0339_ VGND VGND VPWR VPWR sum1\[0\] sky130_fd_sc_hd__dfrtp_1
X_7539_ _4161_ VGND VGND VPWR VPWR _0535_ sky130_fd_sc_hd__inv_2
XFILLER_0_43_281 VGND VGND VPWR VPWR sky130_fd_sc_hd__fill_1
XFILLER_0_120_139 VGND VGND VPWR VPWR sky130_fd_sc_hd__fill_1
Xoutput12 net12 VGND VGND VPWR VPWR led[11] sky130_fd_sc_hd__clkbuf_4
Xoutput23 net23 VGND VGND VPWR VPWR led[7] sky130_fd_sc_hd__clkbuf_4
XFILLER_0_98_421 VPWR VGND VPWR VGND sky130_ef_sc_hd__decap_12
XFILLER_0_58_307 VGND VGND VPWR VPWR sky130_fd_sc_hd__fill_1
XPHY_151 VGND VGND VPWR VPWR sky130_fd_sc_hd__decap_3
XPHY_140 VGND VGND VPWR VPWR sky130_fd_sc_hd__decap_3
XFILLER_0_66_373 VGND VGND VPWR VPWR sky130_fd_sc_hd__fill_2
XFILLER_0_66_362 VGND VGND VPWR VPWR sky130_fd_sc_hd__fill_2
XFILLER_0_27_727 VGND VGND VPWR VPWR sky130_fd_sc_hd__fill_1
XPHY_184 VGND VGND VPWR VPWR sky130_fd_sc_hd__decap_3
XPHY_173 VGND VGND VPWR VPWR sky130_fd_sc_hd__decap_3
XPHY_162 VGND VGND VPWR VPWR sky130_fd_sc_hd__decap_3
XPHY_195 VGND VGND VPWR VPWR sky130_fd_sc_hd__decap_3
XFILLER_0_81_387 VGND VGND VPWR VPWR sky130_fd_sc_hd__decap_4
XFILLER_0_78_27 VGND VGND VPWR VPWR sky130_fd_sc_hd__fill_1
XFILLER_0_22_421 VGND VGND VPWR VPWR sky130_fd_sc_hd__decap_4
XFILLER_0_94_15 VPWR VGND VPWR VGND sky130_ef_sc_hd__decap_12
XFILLER_0_94_37 VGND VGND VPWR VPWR sky130_fd_sc_hd__decap_6
XFILLER_0_118_77 VGND VGND VPWR VPWR sky130_fd_sc_hd__decap_6
XFILLER_0_89_410 VPWR VGND VPWR VGND sky130_ef_sc_hd__decap_12
X_7890_ sh4\[3\] VGND VGND VPWR VPWR _0740_ sky130_fd_sc_hd__clkbuf_4
X_6910_ _3831_ _3871_ _3879_ VGND VGND VPWR VPWR _3898_ sky130_fd_sc_hd__and3_2
X_6841_ _3828_ _3829_ VGND VGND VPWR VPWR _0146_ sky130_fd_sc_hd__nor2_1
XFILLER_0_119_217 VGND VGND VPWR VPWR sky130_fd_sc_hd__decap_6
XFILLER_0_92_608 VPWR VGND VPWR VGND sky130_ef_sc_hd__decap_12
XFILLER_0_119_239 VGND VGND VPWR VPWR sky130_fd_sc_hd__fill_2
XFILLER_0_85_660 VPWR VGND VPWR VGND sky130_ef_sc_hd__decap_12
X_6772_ _3708_ _3760_ VGND VGND VPWR VPWR _3761_ sky130_fd_sc_hd__nor2_1
X_8511_ clknet_leaf_41_clk net90 _0262_ VGND VGND VPWR VPWR sum5\[1\] sky130_fd_sc_hd__dfrtp_1
XFILLER_0_72_332 VGND VGND VPWR VPWR sky130_fd_sc_hd__decap_4
XFILLER_0_72_321 VGND VGND VPWR VPWR sky130_fd_sc_hd__decap_8
X_5723_ _2732_ _2736_ _2737_ _2738_ VGND VGND VPWR VPWR _2739_ sky130_fd_sc_hd__o211ai_2
XFILLER_0_45_546 VGND VGND VPWR VPWR sky130_fd_sc_hd__fill_1
XFILLER_0_72_365 VGND VGND VPWR VPWR sky130_fd_sc_hd__decap_4
X_8442_ clknet_leaf_30_clk net296 _0193_ VGND VGND VPWR VPWR carry4\[8\] sky130_fd_sc_hd__dfrtp_1
XFILLER_0_17_259 VGND VGND VPWR VPWR sky130_fd_sc_hd__decap_3
X_5654_ _2470_ _2472_ _2670_ VGND VGND VPWR VPWR _2671_ sky130_fd_sc_hd__a21o_2
X_4605_ net41 _1643_ VGND VGND VPWR VPWR _1644_ sky130_fd_sc_hd__nor2_2
XFILLER_0_115_467 VGND VGND VPWR VPWR sky130_fd_sc_hd__fill_1
X_8373_ _1205_ _1206_ VGND VGND VPWR VPWR _0167_ sky130_fd_sc_hd__nor2_1
XFILLER_0_5_665 VGND VGND VPWR VPWR sky130_fd_sc_hd__decap_6
XFILLER_0_13_410 VPWR VGND VPWR VGND sky130_ef_sc_hd__decap_12
Xhold300 s5\[10\] VGND VGND VPWR VPWR net342 sky130_fd_sc_hd__dlygate4sd3_1
Xhold311 _0040_ VGND VGND VPWR VPWR net353 sky130_fd_sc_hd__dlygate4sd3_1
XFILLER_0_4_153 VPWR VGND VPWR VGND sky130_ef_sc_hd__decap_12
X_5585_ _2517_ _2528_ _2588_ _2589_ _2602_ VGND VGND VPWR VPWR _2603_ sky130_fd_sc_hd__a41oi_4
XFILLER_0_25_281 VGND VGND VPWR VPWR sky130_fd_sc_hd__decap_4
X_7324_ _4140_ VGND VGND VPWR VPWR _0341_ sky130_fd_sc_hd__inv_2
X_4536_ _1444_ _1448_ _1442_ VGND VGND VPWR VPWR _1580_ sky130_fd_sc_hd__o21a_1
Xhold322 s6\[10\] VGND VGND VPWR VPWR net364 sky130_fd_sc_hd__dlygate4sd3_1
Xhold333 s6\[7\] VGND VGND VPWR VPWR net375 sky130_fd_sc_hd__dlygate4sd3_1
Xhold344 _0017_ VGND VGND VPWR VPWR net386 sky130_fd_sc_hd__dlygate4sd3_1
XFILLER_0_4_197 VPWR VGND VPWR VGND sky130_ef_sc_hd__decap_12
X_4467_ _1511_ _1505_ _1507_ _1508_ VGND VGND VPWR VPWR _1512_ sky130_fd_sc_hd__o2bb2ai_2
Xhold377 _0033_ VGND VGND VPWR VPWR net419 sky130_fd_sc_hd__dlygate4sd3_1
Xhold366 _0030_ VGND VGND VPWR VPWR net408 sky130_fd_sc_hd__dlygate4sd3_1
X_7255_ _4133_ VGND VGND VPWR VPWR _0279_ sky130_fd_sc_hd__inv_2
Xhold355 s0\[4\] VGND VGND VPWR VPWR net397 sky130_fd_sc_hd__dlygate4sd3_1
X_6206_ _3206_ _3210_ VGND VGND VPWR VPWR _3211_ sky130_fd_sc_hd__nand2_2
XFILLER_0_110_172 VGND VGND VPWR VPWR sky130_fd_sc_hd__decap_6
XFILLER_0_110_161 VGND VGND VPWR VPWR sky130_fd_sc_hd__decap_4
X_4398_ _1388_ _1383_ VGND VGND VPWR VPWR _1444_ sky130_fd_sc_hd__and2_2
Xhold399 sh15\[7\] VGND VGND VPWR VPWR net441 sky130_fd_sc_hd__dlygate4sd3_1
X_7186_ _4126_ VGND VGND VPWR VPWR _0217_ sky130_fd_sc_hd__inv_2
Xhold388 sum2\[12\] VGND VGND VPWR VPWR net430 sky130_fd_sc_hd__dlygate4sd3_1
X_6137_ _3138_ _3139_ _3141_ VGND VGND VPWR VPWR _3143_ sky130_fd_sc_hd__o21ai_1
XTAP_660 VGND VPWR sky130_fd_sc_hd__tapvpwrvgnd_1
XFILLER_0_99_218 VGND VGND VPWR VPWR sky130_fd_sc_hd__decap_6
XTAP_671 VGND VPWR sky130_fd_sc_hd__tapvpwrvgnd_1
XTAP_682 VGND VPWR sky130_fd_sc_hd__tapvpwrvgnd_1
XTAP_693 VGND VPWR sky130_fd_sc_hd__tapvpwrvgnd_1
X_6068_ _3000_ _3016_ VGND VGND VPWR VPWR _3075_ sky130_fd_sc_hd__nor2_1
X_5019_ _2047_ _2048_ VGND VGND VPWR VPWR _2049_ sky130_fd_sc_hd__nand2_1
XTAP_1804 VGND VPWR sky130_fd_sc_hd__tapvpwrvgnd_1
XTAP_1815 VGND VPWR sky130_fd_sc_hd__tapvpwrvgnd_1
XTAP_1848 VGND VPWR sky130_fd_sc_hd__tapvpwrvgnd_1
XTAP_1837 VGND VPWR sky130_fd_sc_hd__tapvpwrvgnd_1
XTAP_1826 VGND VPWR sky130_fd_sc_hd__tapvpwrvgnd_1
XTAP_1859 VGND VPWR sky130_fd_sc_hd__tapvpwrvgnd_1
XFILLER_0_118_250 VGND VGND VPWR VPWR sky130_fd_sc_hd__fill_2
XFILLER_0_63_321 VGND VGND VPWR VPWR sky130_fd_sc_hd__fill_2
X_8709_ clknet_leaf_55_clk _0101_ _0460_ VGND VGND VPWR VPWR bit_sum4\[0\] sky130_fd_sc_hd__dfrtp_1
XFILLER_0_118_283 VGND VGND VPWR VPWR sky130_fd_sc_hd__decap_3
XFILLER_0_36_557 VPWR VGND VPWR VGND sky130_ef_sc_hd__decap_12
XFILLER_0_51_505 VPWR VGND VPWR VGND sky130_ef_sc_hd__decap_12
XFILLER_0_106_445 VPWR VGND VPWR VGND sky130_ef_sc_hd__decap_12
XFILLER_0_90_173 VGND VGND VPWR VPWR sky130_fd_sc_hd__fill_2
XFILLER_0_106_489 VGND VGND VPWR VPWR sky130_fd_sc_hd__decap_8
XFILLER_0_16_292 VPWR VGND VPWR VGND sky130_ef_sc_hd__decap_12
XFILLER_0_51_549 VGND VGND VPWR VPWR sky130_fd_sc_hd__decap_8
XFILLER_0_64_29 VPWR VGND VPWR VGND sky130_ef_sc_hd__decap_12
XFILLER_0_98_251 VGND VGND VPWR VPWR sky130_fd_sc_hd__fill_1
XFILLER_0_86_446 VGND VGND VPWR VPWR sky130_fd_sc_hd__fill_2
XFILLER_0_67_671 VGND VGND VPWR VPWR sky130_fd_sc_hd__fill_1
XFILLER_0_27_502 VGND VGND VPWR VPWR sky130_fd_sc_hd__fill_2
XFILLER_0_104_57 VGND VGND VPWR VPWR sky130_fd_sc_hd__decap_4
XFILLER_0_54_321 VGND VGND VPWR VPWR sky130_fd_sc_hd__decap_3
XFILLER_0_6_407 VGND VGND VPWR VPWR sky130_fd_sc_hd__decap_4
XFILLER_0_89_15 VPWR VGND VPWR VGND sky130_ef_sc_hd__decap_12
XFILLER_0_54_365 VGND VGND VPWR VPWR sky130_fd_sc_hd__fill_2
XFILLER_0_2_613 VPWR VGND VPWR VGND sky130_ef_sc_hd__decap_12
XFILLER_0_112_448 VGND VGND VPWR VPWR sky130_fd_sc_hd__fill_1
XFILLER_0_2_657 VPWR VGND VPWR VGND sky130_ef_sc_hd__decap_12
XFILLER_0_22_251 VGND VGND VPWR VPWR sky130_fd_sc_hd__fill_1
X_5370_ _2391_ _2371_ _2394_ VGND VGND VPWR VPWR _2395_ sky130_fd_sc_hd__a21oi_1
X_4321_ _1360_ _1366_ _1367_ VGND VGND VPWR VPWR _1368_ sky130_fd_sc_hd__a21o_1
XFILLER_0_1_167 VGND VGND VPWR VPWR sky130_fd_sc_hd__fill_1
X_4252_ _1247_ net34 VGND VGND VPWR VPWR _1300_ sky130_fd_sc_hd__nor2_1
X_7040_ sh13\[1\] _3858_ VGND VGND VPWR VPWR _4025_ sky130_fd_sc_hd__nand2_1
XFILLER_0_38_41 VPWR VGND VPWR VGND sky130_ef_sc_hd__decap_12
XFILLER_0_38_85 VPWR VGND VPWR VGND sky130_ef_sc_hd__decap_12
X_7942_ _0789_ _0790_ _0783_ _0785_ VGND VGND VPWR VPWR _0791_ sky130_fd_sc_hd__o211ai_1
XFILLER_0_54_62 VGND VGND VPWR VPWR sky130_fd_sc_hd__fill_1
X_7873_ sh2\[3\] VGND VGND VPWR VPWR _0723_ sky130_fd_sc_hd__buf_4
XFILLER_0_9_223 VGND VGND VPWR VPWR sky130_fd_sc_hd__fill_1
X_6824_ _3800_ _3808_ _3812_ VGND VGND VPWR VPWR _3813_ sky130_fd_sc_hd__a21boi_1
XFILLER_0_49_159 VGND VGND VPWR VPWR sky130_fd_sc_hd__decap_8
X_6755_ sh0\[1\] sh2\[1\] VGND VGND VPWR VPWR _3744_ sky130_fd_sc_hd__and2_1
XFILLER_0_70_83 VGND VGND VPWR VPWR sky130_fd_sc_hd__fill_1
X_5706_ _2721_ _2722_ VGND VGND VPWR VPWR _2723_ sky130_fd_sc_hd__or2b_1
X_8425_ _1240_ _1234_ _1235_ _1254_ _1243_ VGND VGND VPWR VPWR _1255_ sky130_fd_sc_hd__o221a_1
X_6686_ _3671_ _3672_ _3675_ VGND VGND VPWR VPWR _3680_ sky130_fd_sc_hd__a21o_1
XFILLER_0_73_685 VGND VGND VPWR VPWR sky130_fd_sc_hd__decap_8
Xclkbuf_leaf_30_clk clknet_3_6__leaf_clk VGND VGND VPWR VPWR clknet_leaf_30_clk sky130_fd_sc_hd__clkbuf_16
XFILLER_0_33_516 VGND VGND VPWR VPWR sky130_fd_sc_hd__fill_1
XFILLER_0_45_365 VGND VGND VPWR VPWR sky130_fd_sc_hd__fill_1
XFILLER_0_72_184 VGND VGND VPWR VPWR sky130_fd_sc_hd__decap_3
XFILLER_0_60_357 VGND VGND VPWR VPWR sky130_fd_sc_hd__decap_3
XFILLER_0_5_462 VGND VGND VPWR VPWR sky130_fd_sc_hd__decap_4
X_5637_ _2644_ _2648_ net453 VGND VGND VPWR VPWR _2655_ sky130_fd_sc_hd__a21o_1
XFILLER_0_79_81 VPWR VGND VPWR VGND sky130_ef_sc_hd__decap_12
X_8356_ _1188_ _1189_ carry5\[11\] VGND VGND VPWR VPWR _1191_ sky130_fd_sc_hd__o21bai_1
XFILLER_0_5_495 VGND VGND VPWR VPWR sky130_fd_sc_hd__decap_4
XFILLER_0_5_484 VGND VGND VPWR VPWR sky130_fd_sc_hd__decap_4
X_5568_ _2551_ _2552_ _2581_ _2586_ VGND VGND VPWR VPWR _2587_ sky130_fd_sc_hd__o22ai_4
X_4519_ _1493_ _1496_ _1497_ VGND VGND VPWR VPWR _1563_ sky130_fd_sc_hd__a21oi_1
Xhold130 final_sum\[13\] VGND VGND VPWR VPWR net172 sky130_fd_sc_hd__dlygate4sd3_1
Xhold152 s4\[9\] VGND VGND VPWR VPWR net194 sky130_fd_sc_hd__dlygate4sd3_1
X_7307_ _4138_ VGND VGND VPWR VPWR _0326_ sky130_fd_sc_hd__inv_2
X_8287_ _1089_ _1050_ _1090_ _1041_ VGND VGND VPWR VPWR _1130_ sky130_fd_sc_hd__a31o_1
Xhold141 sh5\[0\] VGND VGND VPWR VPWR net183 sky130_fd_sc_hd__dlygate4sd3_1
XFILLER_0_41_593 VGND VGND VPWR VPWR sky130_fd_sc_hd__decap_4
Xhold185 s4\[5\] VGND VGND VPWR VPWR net227 sky130_fd_sc_hd__dlygate4sd3_1
X_7238_ _4131_ VGND VGND VPWR VPWR _0264_ sky130_fd_sc_hd__inv_2
Xhold163 s3\[6\] VGND VGND VPWR VPWR net205 sky130_fd_sc_hd__clkdlybuf4s25_1
X_5499_ sh8\[0\] VGND VGND VPWR VPWR _2518_ sky130_fd_sc_hd__clkbuf_4
Xhold174 sh9\[2\] VGND VGND VPWR VPWR net216 sky130_fd_sc_hd__dlygate4sd3_1
Xhold196 sh0\[6\] VGND VGND VPWR VPWR net238 sky130_fd_sc_hd__dlygate4sd3_1
X_7169_ _4124_ VGND VGND VPWR VPWR _0202_ sky130_fd_sc_hd__inv_2
XTAP_490 VGND VPWR sky130_fd_sc_hd__tapvpwrvgnd_1
XTAP_1623 VGND VPWR sky130_fd_sc_hd__tapvpwrvgnd_1
XTAP_1612 VGND VPWR sky130_fd_sc_hd__tapvpwrvgnd_1
XTAP_1601 VGND VPWR sky130_fd_sc_hd__tapvpwrvgnd_1
XTAP_1667 VGND VPWR sky130_fd_sc_hd__tapvpwrvgnd_1
XTAP_1656 VGND VPWR sky130_fd_sc_hd__tapvpwrvgnd_1
XTAP_1634 VGND VPWR sky130_fd_sc_hd__tapvpwrvgnd_1
XTAP_1645 VGND VPWR sky130_fd_sc_hd__tapvpwrvgnd_1
XFILLER_0_49_671 VGND VGND VPWR VPWR sky130_fd_sc_hd__fill_1
XTAP_1689 VGND VPWR sky130_fd_sc_hd__tapvpwrvgnd_1
XTAP_1678 VGND VPWR sky130_fd_sc_hd__tapvpwrvgnd_1
XFILLER_0_64_641 VGND VGND VPWR VPWR sky130_fd_sc_hd__decap_3
Xclkbuf_leaf_21_clk clknet_3_7__leaf_clk VGND VGND VPWR VPWR clknet_leaf_21_clk sky130_fd_sc_hd__clkbuf_16
XFILLER_0_63_162 VGND VGND VPWR VPWR sky130_fd_sc_hd__decap_6
XFILLER_0_122_713 VGND VGND VPWR VPWR sky130_fd_sc_hd__fill_2
XFILLER_0_121_223 VGND VGND VPWR VPWR sky130_fd_sc_hd__fill_1
XFILLER_0_51_368 VGND VGND VPWR VPWR sky130_fd_sc_hd__decap_3
XFILLER_0_20_733 VGND VGND VPWR VPWR sky130_fd_sc_hd__fill_2
XFILLER_0_75_39 VPWR VGND VPWR VGND sky130_ef_sc_hd__decap_12
XFILLER_0_91_27 VPWR VGND VPWR VGND sky130_ef_sc_hd__decap_12
XFILLER_0_24_32 VGND VGND VPWR VPWR sky130_fd_sc_hd__decap_4
X_4870_ _1899_ _1902_ _1904_ VGND VGND VPWR VPWR _1906_ sky130_fd_sc_hd__nand3_2
X_6540_ _3532_ _3535_ _3536_ VGND VGND VPWR VPWR _3537_ sky130_fd_sc_hd__o21ai_2
XFILLER_0_7_727 VGND VGND VPWR VPWR sky130_fd_sc_hd__fill_1
Xclkbuf_leaf_12_clk clknet_3_3__leaf_clk VGND VGND VPWR VPWR clknet_leaf_12_clk sky130_fd_sc_hd__clkbuf_16
XFILLER_0_15_505 VGND VGND VPWR VPWR sky130_fd_sc_hd__decap_3
XFILLER_0_15_527 VPWR VGND VPWR VGND sky130_ef_sc_hd__decap_12
XFILLER_0_40_53 VPWR VGND VPWR VGND sky130_ef_sc_hd__decap_12
X_6471_ _3466_ _3467_ _3468_ VGND VGND VPWR VPWR _3469_ sky130_fd_sc_hd__nand3_2
XFILLER_0_54_195 VGND VGND VPWR VPWR sky130_fd_sc_hd__fill_1
XFILLER_0_70_666 VPWR VGND VPWR VGND sky130_ef_sc_hd__decap_12
X_8210_ _1052_ _1054_ sh14\[3\] VGND VGND VPWR VPWR _1055_ sky130_fd_sc_hd__o21bai_2
XFILLER_0_2_421 VPWR VGND VPWR VGND sky130_ef_sc_hd__decap_12
X_5422_ _2407_ _2404_ _2443_ _2444_ VGND VGND VPWR VPWR _2446_ sky130_fd_sc_hd__o211a_1
X_5353_ sh4\[2\] _2037_ VGND VGND VPWR VPWR _2378_ sky130_fd_sc_hd__and2_2
X_8141_ _0901_ _0891_ _0967_ _0974_ VGND VGND VPWR VPWR _0988_ sky130_fd_sc_hd__o211a_1
XFILLER_0_100_429 VGND VGND VPWR VPWR sky130_fd_sc_hd__decap_8
X_4304_ _1341_ _1343_ _1351_ VGND VGND VPWR VPWR _1352_ sky130_fd_sc_hd__a21oi_2
XFILLER_0_49_51 VGND VGND VPWR VPWR sky130_fd_sc_hd__decap_4
X_5284_ _2107_ _2310_ _2242_ VGND VGND VPWR VPWR _2311_ sky130_fd_sc_hd__o21ai_2
X_8072_ _0916_ _0919_ _0911_ _0912_ VGND VGND VPWR VPWR _0920_ sky130_fd_sc_hd__o211a_1
X_4235_ _1237_ _1238_ _1266_ VGND VGND VPWR VPWR _1283_ sky130_fd_sc_hd__a21oi_1
X_7023_ _4001_ _4002_ _4003_ _4008_ VGND VGND VPWR VPWR _4009_ sky130_fd_sc_hd__o31ai_4
XFILLER_0_4_53 VPWR VGND VPWR VGND sky130_ef_sc_hd__decap_12
XFILLER_0_65_61 VGND VGND VPWR VPWR sky130_fd_sc_hd__fill_2
XFILLER_0_4_97 VPWR VGND VPWR VGND sky130_ef_sc_hd__decap_12
X_7925_ _0737_ _0772_ _0746_ VGND VGND VPWR VPWR _0774_ sky130_fd_sc_hd__o21ai_4
XFILLER_0_77_254 VPWR VGND VPWR VGND sky130_ef_sc_hd__decap_12
X_7856_ net352 s6\[10\] _0713_ VGND VGND VPWR VPWR _0040_ sky130_fd_sc_hd__o21a_1
XFILLER_0_65_405 VGND VGND VPWR VPWR sky130_fd_sc_hd__fill_2
XFILLER_0_93_725 VGND VGND VPWR VPWR sky130_fd_sc_hd__decap_3
XFILLER_0_81_93 VPWR VGND VPWR VGND sky130_ef_sc_hd__decap_12
XFILLER_0_65_449 VPWR VGND VPWR VGND sky130_ef_sc_hd__decap_12
XFILLER_0_65_427 VPWR VGND VPWR VGND sky130_ef_sc_hd__decap_12
X_6807_ _3762_ _3774_ _3771_ VGND VGND VPWR VPWR _3796_ sky130_fd_sc_hd__a21oi_1
X_4999_ _2028_ _2029_ _2027_ VGND VGND VPWR VPWR _2031_ sky130_fd_sc_hd__a21oi_1
X_7787_ carry2\[10\] net243 s4\[11\] VGND VGND VPWR VPWR _0679_ sky130_fd_sc_hd__a21o_1
XFILLER_0_18_321 VPWR VGND VPWR VGND sky130_ef_sc_hd__decap_12
XFILLER_0_80_419 VGND VGND VPWR VPWR sky130_fd_sc_hd__fill_1
X_6738_ _3720_ _3719_ _3725_ _3726_ VGND VGND VPWR VPWR _3728_ sky130_fd_sc_hd__o2bb2ai_1
XFILLER_0_104_713 VPWR VGND VPWR VGND sky130_ef_sc_hd__decap_12
X_6669_ _3606_ _3653_ _3624_ VGND VGND VPWR VPWR _3663_ sky130_fd_sc_hd__o21ai_1
XFILLER_0_61_633 VPWR VGND VPWR VGND sky130_ef_sc_hd__decap_12
XFILLER_0_33_324 VPWR VGND VPWR VGND sky130_ef_sc_hd__decap_12
X_8408_ sh0\[5\] VGND VGND VPWR VPWR _1238_ sky130_fd_sc_hd__clkbuf_4
XFILLER_0_116_595 VPWR VGND VPWR VGND sky130_ef_sc_hd__decap_12
XFILLER_0_60_165 VPWR VGND VPWR VGND sky130_ef_sc_hd__decap_12
XFILLER_0_5_281 VGND VGND VPWR VPWR sky130_fd_sc_hd__fill_2
XFILLER_0_33_379 VGND VGND VPWR VPWR sky130_fd_sc_hd__fill_1
X_8339_ _1167_ _1165_ _1175_ VGND VGND VPWR VPWR _1176_ sky130_fd_sc_hd__a21oi_1
XFILLER_0_5_292 VGND VGND VPWR VPWR sky130_fd_sc_hd__decap_6
XFILLER_0_14_582 VGND VGND VPWR VPWR sky130_fd_sc_hd__fill_2
XFILLER_0_103_278 VGND VGND VPWR VPWR sky130_fd_sc_hd__fill_2
XTAP_1442 VGND VPWR sky130_fd_sc_hd__tapvpwrvgnd_1
XTAP_1431 VGND VPWR sky130_fd_sc_hd__tapvpwrvgnd_1
XTAP_1420 VGND VPWR sky130_fd_sc_hd__tapvpwrvgnd_1
XTAP_1464 VGND VPWR sky130_fd_sc_hd__tapvpwrvgnd_1
XTAP_1475 VGND VPWR sky130_fd_sc_hd__tapvpwrvgnd_1
XTAP_1453 VGND VPWR sky130_fd_sc_hd__tapvpwrvgnd_1
XTAP_1497 VGND VPWR sky130_fd_sc_hd__tapvpwrvgnd_1
XTAP_1486 VGND VPWR sky130_fd_sc_hd__tapvpwrvgnd_1
XFILLER_0_83_279 VGND VGND VPWR VPWR sky130_fd_sc_hd__fill_1
XFILLER_0_37_685 VGND VGND VPWR VPWR sky130_fd_sc_hd__fill_1
XFILLER_0_107_551 VGND VGND VPWR VPWR sky130_fd_sc_hd__decap_8
XFILLER_0_12_508 VGND VGND VPWR VPWR sky130_fd_sc_hd__decap_6
XFILLER_0_86_27 VGND VGND VPWR VPWR sky130_fd_sc_hd__fill_1
XFILLER_0_20_552 VPWR VGND VPWR VGND sky130_ef_sc_hd__decap_12
Xclkbuf_leaf_1_clk clknet_3_1__leaf_clk VGND VGND VPWR VPWR clknet_leaf_1_clk sky130_fd_sc_hd__clkbuf_16
X_5971_ _2977_ _2979_ VGND VGND VPWR VPWR _2980_ sky130_fd_sc_hd__or2_1
X_4922_ _1954_ _1955_ _1636_ VGND VGND VPWR VPWR _1956_ sky130_fd_sc_hd__nand3b_4
XFILLER_0_59_243 VPWR VGND VPWR VGND sky130_ef_sc_hd__decap_12
X_8690_ clknet_leaf_58_clk _0154_ _0441_ VGND VGND VPWR VPWR bit_sum2\[1\] sky130_fd_sc_hd__dfrtp_1
X_7710_ carry1\[3\] sum1\[4\] VGND VGND VPWR VPWR _0627_ sky130_fd_sc_hd__xnor2_1
XFILLER_0_74_213 VGND VGND VPWR VPWR sky130_fd_sc_hd__decap_8
X_7641_ _4170_ _4171_ net345 VGND VGND VPWR VPWR _4172_ sky130_fd_sc_hd__o21ai_1
X_4853_ _1869_ _1879_ _1888_ VGND VGND VPWR VPWR _1889_ sky130_fd_sc_hd__o21ai_1
X_4784_ _1818_ _1808_ _1820_ VGND VGND VPWR VPWR _1821_ sky130_fd_sc_hd__a21o_1
XFILLER_0_62_419 VGND VGND VPWR VPWR sky130_fd_sc_hd__fill_1
X_7572_ _4164_ VGND VGND VPWR VPWR _0565_ sky130_fd_sc_hd__inv_2
X_6523_ _3508_ _3512_ _3513_ _3518_ _3519_ VGND VGND VPWR VPWR _3520_ sky130_fd_sc_hd__o2111ai_2
X_6454_ _3377_ _3451_ _3448_ VGND VGND VPWR VPWR _3452_ sky130_fd_sc_hd__a21o_1
XFILLER_0_43_666 VGND VGND VPWR VPWR sky130_fd_sc_hd__decap_6
X_5405_ _2063_ _2091_ _2379_ VGND VGND VPWR VPWR _2429_ sky130_fd_sc_hd__o21ai_1
XFILLER_0_101_716 VPWR VGND VPWR VGND sky130_ef_sc_hd__decap_12
XFILLER_0_100_204 VGND VGND VPWR VPWR sky130_fd_sc_hd__decap_6
X_6385_ _3376_ _3309_ _3377_ _3310_ VGND VGND VPWR VPWR _3384_ sky130_fd_sc_hd__o22a_2
XFILLER_0_62_3 VGND VGND VPWR VPWR sky130_fd_sc_hd__decap_6
XFILLER_0_2_251 VGND VGND VPWR VPWR sky130_fd_sc_hd__fill_1
XFILLER_0_100_259 VGND VGND VPWR VPWR sky130_fd_sc_hd__decap_8
X_8124_ _0957_ VGND VGND VPWR VPWR _0971_ sky130_fd_sc_hd__inv_2
X_5336_ _2357_ _2358_ _2359_ _2361_ VGND VGND VPWR VPWR _2362_ sky130_fd_sc_hd__o211ai_4
X_5267_ _2285_ _2292_ _2293_ _2198_ VGND VGND VPWR VPWR _2294_ sky130_fd_sc_hd__o2bb2ai_1
X_8055_ _0901_ _0902_ VGND VGND VPWR VPWR _0903_ sky130_fd_sc_hd__nor2_1
X_7006_ _3987_ _3988_ _3982_ _3985_ VGND VGND VPWR VPWR _3992_ sky130_fd_sc_hd__o211ai_1
X_5198_ _2215_ _2221_ _2222_ VGND VGND VPWR VPWR _2226_ sky130_fd_sc_hd__a21oi_2
XFILLER_0_97_327 VGND VGND VPWR VPWR sky130_fd_sc_hd__decap_8
XFILLER_0_92_70 VPWR VGND VPWR VGND sky130_ef_sc_hd__decap_12
X_7908_ _0729_ _0757_ VGND VGND VPWR VPWR _0758_ sky130_fd_sc_hd__or2_1
XFILLER_0_66_725 VGND VGND VPWR VPWR sky130_fd_sc_hd__decap_8
XFILLER_0_38_427 VGND VGND VPWR VPWR sky130_fd_sc_hd__fill_1
XFILLER_0_108_315 VGND VGND VPWR VPWR sky130_fd_sc_hd__fill_2
X_7839_ sum3\[11\] carry3\[10\] net280 VGND VGND VPWR VPWR _0705_ sky130_fd_sc_hd__a21o_1
XFILLER_0_93_599 VPWR VGND VPWR VGND sky130_ef_sc_hd__decap_12
XFILLER_0_19_663 VGND VGND VPWR VPWR sky130_fd_sc_hd__decap_8
XFILLER_0_19_685 VPWR VGND VPWR VGND sky130_ef_sc_hd__decap_12
XFILLER_0_116_381 VGND VGND VPWR VPWR sky130_fd_sc_hd__decap_8
XFILLER_0_116_370 VGND VGND VPWR VPWR sky130_fd_sc_hd__decap_6
XFILLER_0_104_576 VPWR VGND VPWR VGND sky130_ef_sc_hd__decap_12
XFILLER_0_72_29 VPWR VGND VPWR VGND sky130_ef_sc_hd__decap_12
XFILLER_0_96_382 VPWR VGND VPWR VGND sky130_ef_sc_hd__decap_12
XTAP_1250 VGND VPWR sky130_fd_sc_hd__tapvpwrvgnd_1
XFILLER_0_57_714 VPWR VGND VPWR VGND sky130_ef_sc_hd__decap_12
XFILLER_0_29_405 VPWR VGND VPWR VGND sky130_ef_sc_hd__decap_12
XFILLER_0_84_533 VGND VGND VPWR VPWR sky130_fd_sc_hd__decap_8
XTAP_1283 VGND VPWR sky130_fd_sc_hd__tapvpwrvgnd_1
XTAP_1272 VGND VPWR sky130_fd_sc_hd__tapvpwrvgnd_1
XTAP_1261 VGND VPWR sky130_fd_sc_hd__tapvpwrvgnd_1
XFILLER_0_29_449 VGND VGND VPWR VPWR sky130_fd_sc_hd__decap_6
XTAP_1294 VGND VPWR sky130_fd_sc_hd__tapvpwrvgnd_1
XFILLER_0_97_15 VPWR VGND VPWR VGND sky130_ef_sc_hd__decap_12
XFILLER_0_24_176 VGND VGND VPWR VPWR sky130_fd_sc_hd__decap_3
XFILLER_0_110_524 VGND VGND VPWR VPWR sky130_fd_sc_hd__fill_1
X_6170_ _3158_ _3157_ _3163_ VGND VGND VPWR VPWR _3176_ sky130_fd_sc_hd__o21ai_1
X_5121_ _2138_ _2139_ _2147_ _2149_ VGND VGND VPWR VPWR _2150_ sky130_fd_sc_hd__o211a_1
X_5052_ _2080_ _2081_ sh15\[2\] VGND VGND VPWR VPWR _2082_ sky130_fd_sc_hd__and3b_1
X_8811_ clknet_leaf_19_clk net230 _0562_ VGND VGND VPWR VPWR sh7\[7\] sky130_fd_sc_hd__dfrtp_1
X_8742_ clknet_leaf_23_clk _0183_ _0493_ VGND VGND VPWR VPWR bit_sum7\[3\] sky130_fd_sc_hd__dfrtp_1
X_5954_ _2953_ _2957_ _2962_ VGND VGND VPWR VPWR _2963_ sky130_fd_sc_hd__a21o_1
X_4905_ _1937_ _1935_ _1936_ VGND VGND VPWR VPWR _1940_ sky130_fd_sc_hd__nand3_1
X_5885_ net37 _2894_ VGND VGND VPWR VPWR _2895_ sky130_fd_sc_hd__nor2_1
XFILLER_0_87_393 VGND VGND VPWR VPWR sky130_fd_sc_hd__decap_8
X_8673_ clknet_leaf_36_clk _0175_ _0424_ VGND VGND VPWR VPWR bit_sum0\[4\] sky130_fd_sc_hd__dfrtp_1
X_4836_ _1662_ sh12\[7\] _1797_ _1798_ VGND VGND VPWR VPWR _1872_ sky130_fd_sc_hd__a211oi_1
XFILLER_0_75_577 VGND VGND VPWR VPWR sky130_fd_sc_hd__fill_2
XFILLER_0_63_706 VPWR VGND VPWR VGND sky130_ef_sc_hd__decap_12
X_7624_ _4169_ VGND VGND VPWR VPWR _0612_ sky130_fd_sc_hd__inv_2
XFILLER_0_16_622 VGND VGND VPWR VPWR sky130_fd_sc_hd__fill_1
X_7555_ _4163_ VGND VGND VPWR VPWR _0549_ sky130_fd_sc_hd__inv_2
X_4767_ _1803_ _1727_ _1730_ VGND VGND VPWR VPWR _1804_ sky130_fd_sc_hd__a21oi_1
X_6506_ _3433_ _3487_ _3499_ _3502_ VGND VGND VPWR VPWR _3503_ sky130_fd_sc_hd__o211a_2
X_4698_ _1735_ _1660_ _1656_ VGND VGND VPWR VPWR _1736_ sky130_fd_sc_hd__a21oi_2
X_7486_ _4155_ VGND VGND VPWR VPWR _0488_ sky130_fd_sc_hd__inv_2
X_6437_ _3427_ _3430_ _3368_ VGND VGND VPWR VPWR _3435_ sky130_fd_sc_hd__a21o_1
XFILLER_0_30_135 VGND VGND VPWR VPWR sky130_fd_sc_hd__decap_4
X_6368_ _3296_ sh3\[4\] sh4\[4\] VGND VGND VPWR VPWR _3367_ sky130_fd_sc_hd__o21ai_4
XFILLER_0_101_579 VPWR VGND VPWR VGND sky130_ef_sc_hd__decap_12
X_8107_ _0727_ _0722_ _0953_ VGND VGND VPWR VPWR _0954_ sky130_fd_sc_hd__a21oi_4
X_5319_ _2039_ _2047_ _2103_ _2253_ VGND VGND VPWR VPWR _2345_ sky130_fd_sc_hd__o22a_1
X_6299_ _3295_ _3297_ _3298_ VGND VGND VPWR VPWR _3299_ sky130_fd_sc_hd__o21bai_1
Xhold12 bit_sum2\[5\] VGND VGND VPWR VPWR net54 sky130_fd_sc_hd__dlygate4sd3_1
Xhold23 sum1\[1\] VGND VGND VPWR VPWR net65 sky130_fd_sc_hd__dlygate4sd3_1
Xhold34 bit_sum5\[5\] VGND VGND VPWR VPWR net76 sky130_fd_sc_hd__dlygate4sd3_1
Xhold56 bit_sum5\[1\] VGND VGND VPWR VPWR net98 sky130_fd_sc_hd__dlygate4sd3_1
Xhold45 bit_sum2\[1\] VGND VGND VPWR VPWR net87 sky130_fd_sc_hd__dlygate4sd3_1
X_8038_ _0762_ sh9\[3\] _0726_ VGND VGND VPWR VPWR _0886_ sky130_fd_sc_hd__o21ai_2
Xhold78 bit_sum5\[8\] VGND VGND VPWR VPWR net120 sky130_fd_sc_hd__dlygate4sd3_1
Xhold89 sum5\[2\] VGND VGND VPWR VPWR net131 sky130_fd_sc_hd__dlygate4sd3_1
Xhold67 bit_sum1\[3\] VGND VGND VPWR VPWR net109 sky130_fd_sc_hd__dlygate4sd3_1
XFILLER_0_98_636 VGND VGND VPWR VPWR sky130_fd_sc_hd__decap_8
XFILLER_0_109_613 VGND VGND VPWR VPWR sky130_fd_sc_hd__decap_3
XFILLER_0_66_533 VGND VGND VPWR VPWR sky130_fd_sc_hd__fill_2
XFILLER_0_108_112 VGND VGND VPWR VPWR sky130_fd_sc_hd__fill_1
XFILLER_0_38_279 VGND VGND VPWR VPWR sky130_fd_sc_hd__fill_1
XFILLER_0_108_167 VGND VGND VPWR VPWR sky130_fd_sc_hd__fill_1
XFILLER_0_93_385 VGND VGND VPWR VPWR sky130_fd_sc_hd__decap_3
XFILLER_0_53_249 VGND VGND VPWR VPWR sky130_fd_sc_hd__fill_1
XFILLER_0_123_137 VGND VGND VPWR VPWR sky130_fd_sc_hd__decap_3
XFILLER_0_21_113 VGND VGND VPWR VPWR sky130_fd_sc_hd__fill_1
XTAP_319 VGND VPWR sky130_fd_sc_hd__tapvpwrvgnd_1
XTAP_308 VGND VPWR sky130_fd_sc_hd__tapvpwrvgnd_1
XFILLER_0_83_39 VPWR VGND VPWR VGND sky130_ef_sc_hd__decap_12
XFILLER_0_107_57 VGND VGND VPWR VPWR sky130_fd_sc_hd__decap_8
XFILLER_0_89_658 VPWR VGND VPWR VGND sky130_ef_sc_hd__decap_12
XFILLER_0_69_393 VGND VGND VPWR VPWR sky130_fd_sc_hd__decap_4
XFILLER_0_57_544 VPWR VGND VPWR VGND sky130_ef_sc_hd__decap_12
XTAP_1091 VGND VPWR sky130_fd_sc_hd__tapvpwrvgnd_1
XTAP_1080 VGND VPWR sky130_fd_sc_hd__tapvpwrvgnd_1
X_5670_ _2686_ _2485_ VGND VGND VPWR VPWR _2687_ sky130_fd_sc_hd__nand2_1
XFILLER_0_120_3 VPWR VGND VPWR VGND sky130_ef_sc_hd__decap_12
X_4621_ _1642_ _1640_ _1658_ VGND VGND VPWR VPWR _1660_ sky130_fd_sc_hd__o21ai_1
XFILLER_0_60_709 VPWR VGND VPWR VGND sky130_ef_sc_hd__decap_12
XFILLER_0_4_313 VGND VGND VPWR VPWR sky130_fd_sc_hd__fill_1
XFILLER_0_44_249 VGND VGND VPWR VPWR sky130_fd_sc_hd__decap_3
X_4552_ _1543_ _1568_ _1566_ VGND VGND VPWR VPWR _1595_ sky130_fd_sc_hd__o21ai_1
XFILLER_0_108_690 VGND VGND VPWR VPWR sky130_fd_sc_hd__decap_8
XFILLER_0_4_357 VGND VGND VPWR VPWR sky130_fd_sc_hd__decap_6
XFILLER_0_25_474 VGND VGND VPWR VPWR sky130_fd_sc_hd__decap_8
X_7340_ _4141_ VGND VGND VPWR VPWR _0356_ sky130_fd_sc_hd__inv_2
X_4483_ _1523_ _1527_ _1484_ VGND VGND VPWR VPWR _1528_ sky130_fd_sc_hd__o21ai_1
X_7271_ _4134_ VGND VGND VPWR VPWR _0294_ sky130_fd_sc_hd__inv_2
XFILLER_0_13_669 VGND VGND VPWR VPWR sky130_fd_sc_hd__decap_3
X_6222_ _3225_ _3226_ _3161_ VGND VGND VPWR VPWR _3227_ sky130_fd_sc_hd__o21ai_4
XFILLER_0_110_321 VPWR VGND VPWR VGND sky130_ef_sc_hd__decap_12
XFILLER_0_40_455 VGND VGND VPWR VPWR sky130_fd_sc_hd__decap_4
XFILLER_0_110_365 VGND VGND VPWR VPWR sky130_fd_sc_hd__decap_4
X_6153_ _2893_ _2922_ _3033_ VGND VGND VPWR VPWR _3159_ sky130_fd_sc_hd__o21a_2
XFILLER_0_0_585 VGND VGND VPWR VPWR sky130_fd_sc_hd__decap_3
XTAP_820 VGND VPWR sky130_fd_sc_hd__tapvpwrvgnd_1
XTAP_831 VGND VPWR sky130_fd_sc_hd__tapvpwrvgnd_1
XTAP_842 VGND VPWR sky130_fd_sc_hd__tapvpwrvgnd_1
XTAP_853 VGND VPWR sky130_fd_sc_hd__tapvpwrvgnd_1
X_6084_ _3085_ _3089_ _3090_ VGND VGND VPWR VPWR _3091_ sky130_fd_sc_hd__a21oi_1
X_5104_ _2129_ _2130_ _2132_ VGND VGND VPWR VPWR _2133_ sky130_fd_sc_hd__o21ai_4
XTAP_875 VGND VPWR sky130_fd_sc_hd__tapvpwrvgnd_1
XTAP_864 VGND VPWR sky130_fd_sc_hd__tapvpwrvgnd_1
XTAP_886 VGND VPWR sky130_fd_sc_hd__tapvpwrvgnd_1
X_5035_ _2062_ _2055_ _2063_ _2064_ VGND VGND VPWR VPWR _2065_ sky130_fd_sc_hd__o211ai_2
XTAP_897 VGND VPWR sky130_fd_sc_hd__tapvpwrvgnd_1
XFILLER_0_79_113 VPWR VGND VPWR VGND sky130_ef_sc_hd__decap_12
XFILLER_0_25_3 VGND VGND VPWR VPWR sky130_fd_sc_hd__decap_8
XFILLER_0_73_72 VPWR VGND VPWR VGND sky130_ef_sc_hd__decap_12
X_6986_ _3717_ sh5\[1\] VGND VGND VPWR VPWR _3972_ sky130_fd_sc_hd__nand2_1
X_5937_ _2934_ _2943_ _2945_ VGND VGND VPWR VPWR _2946_ sky130_fd_sc_hd__o21ai_1
X_8725_ clknet_leaf_14_clk _0132_ _0476_ VGND VGND VPWR VPWR bit_sum5\[6\] sky130_fd_sc_hd__dfrtp_1
X_8656_ clknet_leaf_29_clk net155 _0407_ VGND VGND VPWR VPWR s6\[12\] sky130_fd_sc_hd__dfrtp_1
X_5868_ sh1\[6\] VGND VGND VPWR VPWR _2878_ sky130_fd_sc_hd__clkbuf_4
X_7607_ _4167_ VGND VGND VPWR VPWR _0597_ sky130_fd_sc_hd__inv_2
X_4819_ _1853_ _1854_ _1837_ _1845_ VGND VGND VPWR VPWR _1855_ sky130_fd_sc_hd__o2bb2ai_1
X_5799_ _2810_ _2811_ _2812_ VGND VGND VPWR VPWR _2814_ sky130_fd_sc_hd__nand3_1
X_8587_ clknet_leaf_53_clk _0000_ _0338_ VGND VGND VPWR VPWR carry1\[10\] sky130_fd_sc_hd__dfrtp_1
XFILLER_0_105_159 VGND VGND VPWR VPWR sky130_fd_sc_hd__decap_6
X_7538_ _4161_ VGND VGND VPWR VPWR _0534_ sky130_fd_sc_hd__inv_2
XFILLER_0_16_463 VGND VGND VPWR VPWR sky130_fd_sc_hd__fill_1
XFILLER_0_114_671 VPWR VGND VPWR VGND sky130_ef_sc_hd__decap_12
X_7469_ _4154_ VGND VGND VPWR VPWR _0472_ sky130_fd_sc_hd__inv_2
XFILLER_0_31_444 VGND VGND VPWR VPWR sky130_fd_sc_hd__fill_1
Xoutput13 net13 VGND VGND VPWR VPWR led[12] sky130_fd_sc_hd__clkbuf_4
XFILLER_0_101_332 VGND VGND VPWR VPWR sky130_fd_sc_hd__decap_4
Xoutput24 net24 VGND VGND VPWR VPWR led[8] sky130_fd_sc_hd__clkbuf_4
XFILLER_0_98_433 VPWR VGND VPWR VGND sky130_ef_sc_hd__decap_12
XFILLER_0_98_477 VGND VGND VPWR VPWR sky130_fd_sc_hd__decap_4
XFILLER_0_85_105 VGND VGND VPWR VPWR sky130_fd_sc_hd__decap_6
XPHY_152 VGND VGND VPWR VPWR sky130_fd_sc_hd__decap_3
XPHY_141 VGND VGND VPWR VPWR sky130_fd_sc_hd__decap_3
XPHY_130 VGND VGND VPWR VPWR sky130_fd_sc_hd__decap_3
XFILLER_0_27_717 VGND VGND VPWR VPWR sky130_fd_sc_hd__fill_2
XFILLER_0_39_577 VGND VGND VPWR VPWR sky130_fd_sc_hd__fill_1
XPHY_185 VGND VGND VPWR VPWR sky130_fd_sc_hd__decap_3
XPHY_174 VGND VGND VPWR VPWR sky130_fd_sc_hd__decap_3
XPHY_163 VGND VGND VPWR VPWR sky130_fd_sc_hd__decap_3
XFILLER_0_54_514 VPWR VGND VPWR VGND sky130_ef_sc_hd__decap_12
XFILLER_0_26_216 VGND VGND VPWR VPWR sky130_fd_sc_hd__fill_2
XPHY_196 VGND VGND VPWR VPWR sky130_fd_sc_hd__decap_3
Xclkbuf_3_1__f_clk clknet_0_clk VGND VGND VPWR VPWR clknet_3_1__leaf_clk sky130_fd_sc_hd__clkbuf_16
XFILLER_0_10_628 VPWR VGND VPWR VGND sky130_ef_sc_hd__decap_12
XFILLER_0_94_27 VGND VGND VPWR VPWR sky130_fd_sc_hd__fill_1
XFILLER_0_27_54 VGND VGND VPWR VPWR sky130_fd_sc_hd__fill_2
XFILLER_0_89_422 VGND VGND VPWR VPWR sky130_fd_sc_hd__decap_6
XFILLER_0_89_499 VGND VGND VPWR VPWR sky130_fd_sc_hd__fill_2
XFILLER_0_77_617 VPWR VGND VPWR VGND sky130_ef_sc_hd__decap_12
X_6840_ _3818_ _3819_ _3826_ _3827_ VGND VGND VPWR VPWR _3829_ sky130_fd_sc_hd__and4bb_1
XFILLER_0_49_308 VGND VGND VPWR VPWR sky130_fd_sc_hd__decap_6
XFILLER_0_76_149 VGND VGND VPWR VPWR sky130_fd_sc_hd__decap_3
XFILLER_0_9_405 VPWR VGND VPWR VGND sky130_ef_sc_hd__decap_12
X_6771_ _3717_ _3712_ _3710_ VGND VGND VPWR VPWR _3760_ sky130_fd_sc_hd__o21a_2
XFILLER_0_91_108 VGND VGND VPWR VPWR sky130_fd_sc_hd__fill_1
X_5722_ _2731_ _2730_ _2489_ VGND VGND VPWR VPWR _2738_ sky130_fd_sc_hd__o21ai_1
XFILLER_0_9_449 VGND VGND VPWR VPWR sky130_fd_sc_hd__fill_2
X_8510_ clknet_leaf_40_clk net45 _0261_ VGND VGND VPWR VPWR sum5\[0\] sky130_fd_sc_hd__dfrtp_1
XFILLER_0_72_300 VGND VGND VPWR VPWR sky130_fd_sc_hd__decap_8
X_8441_ clknet_leaf_26_clk net313 _0192_ VGND VGND VPWR VPWR carry4\[7\] sky130_fd_sc_hd__dfrtp_1
X_5653_ _2487_ _2491_ _2667_ VGND VGND VPWR VPWR _2670_ sky130_fd_sc_hd__a21o_1
XFILLER_0_33_709 VGND VGND VPWR VPWR sky130_fd_sc_hd__decap_8
XFILLER_0_45_558 VGND VGND VPWR VPWR sky130_fd_sc_hd__fill_2
X_4604_ sh0\[7\] VGND VGND VPWR VPWR _1643_ sky130_fd_sc_hd__clkbuf_4
X_8372_ _1192_ _1195_ _1204_ VGND VGND VPWR VPWR _1206_ sky130_fd_sc_hd__o21a_1
XFILLER_0_4_121 VPWR VGND VPWR VGND sky130_ef_sc_hd__decap_12
X_5584_ _2591_ VGND VGND VPWR VPWR _2602_ sky130_fd_sc_hd__inv_2
X_4535_ _1540_ _1574_ _1578_ VGND VGND VPWR VPWR _1579_ sky130_fd_sc_hd__nand3_1
Xhold301 sh5\[4\] VGND VGND VPWR VPWR net343 sky130_fd_sc_hd__dlygate4sd3_1
XFILLER_0_4_165 VPWR VGND VPWR VGND sky130_ef_sc_hd__decap_12
XFILLER_0_13_422 VGND VGND VPWR VPWR sky130_fd_sc_hd__decap_4
X_7323_ _4140_ VGND VGND VPWR VPWR _0340_ sky130_fd_sc_hd__inv_2
Xhold323 _0654_ VGND VGND VPWR VPWR net365 sky130_fd_sc_hd__dlygate4sd3_1
Xhold334 _0642_ VGND VGND VPWR VPWR net376 sky130_fd_sc_hd__dlygate4sd3_1
Xhold312 carry4\[6\] VGND VGND VPWR VPWR net354 sky130_fd_sc_hd__dlygate4sd3_1
X_4466_ _1485_ _1499_ _1500_ VGND VGND VPWR VPWR _1511_ sky130_fd_sc_hd__nand3_1
Xhold378 s5\[6\] VGND VGND VPWR VPWR net420 sky130_fd_sc_hd__dlygate4sd3_1
XFILLER_0_68_61 VGND VGND VPWR VPWR sky130_fd_sc_hd__decap_8
X_7254_ _4125_ VGND VGND VPWR VPWR _4133_ sky130_fd_sc_hd__buf_4
Xhold367 sh5\[1\] VGND VGND VPWR VPWR net409 sky130_fd_sc_hd__dlygate4sd3_1
Xhold345 s1\[7\] VGND VGND VPWR VPWR net387 sky130_fd_sc_hd__dlygate4sd3_1
Xhold356 _0004_ VGND VGND VPWR VPWR net398 sky130_fd_sc_hd__dlygate4sd3_1
X_6205_ _3207_ _3208_ _3209_ VGND VGND VPWR VPWR _3210_ sky130_fd_sc_hd__o21ai_2
X_4397_ _1440_ _1354_ VGND VGND VPWR VPWR _1443_ sky130_fd_sc_hd__and2_1
X_7185_ _4126_ VGND VGND VPWR VPWR _0216_ sky130_fd_sc_hd__inv_2
Xhold389 _0022_ VGND VGND VPWR VPWR net431 sky130_fd_sc_hd__dlygate4sd3_1
XFILLER_0_110_195 VGND VGND VPWR VPWR sky130_fd_sc_hd__fill_1
X_6136_ _2882_ _3137_ _3138_ _3139_ _3141_ VGND VGND VPWR VPWR _3142_ sky130_fd_sc_hd__o221ai_4
XFILLER_0_0_393 VPWR VGND VPWR VGND sky130_ef_sc_hd__decap_12
XTAP_650 VGND VPWR sky130_fd_sc_hd__tapvpwrvgnd_1
XTAP_661 VGND VPWR sky130_fd_sc_hd__tapvpwrvgnd_1
XFILLER_0_99_208 VGND VGND VPWR VPWR sky130_fd_sc_hd__fill_2
XTAP_672 VGND VPWR sky130_fd_sc_hd__tapvpwrvgnd_1
XTAP_683 VGND VPWR sky130_fd_sc_hd__tapvpwrvgnd_1
XTAP_694 VGND VPWR sky130_fd_sc_hd__tapvpwrvgnd_1
X_6067_ _2884_ _2881_ _2875_ VGND VGND VPWR VPWR _3074_ sky130_fd_sc_hd__o21ai_2
X_5018_ sh10\[2\] _2040_ VGND VGND VPWR VPWR _2048_ sky130_fd_sc_hd__nand2_1
XTAP_1805 VGND VPWR sky130_fd_sc_hd__tapvpwrvgnd_1
XTAP_1816 VGND VPWR sky130_fd_sc_hd__tapvpwrvgnd_1
XTAP_1849 VGND VPWR sky130_fd_sc_hd__tapvpwrvgnd_1
XTAP_1838 VGND VPWR sky130_fd_sc_hd__tapvpwrvgnd_1
XTAP_1827 VGND VPWR sky130_fd_sc_hd__tapvpwrvgnd_1
X_6969_ _3898_ _3891_ _3949_ _3951_ VGND VGND VPWR VPWR _3956_ sky130_fd_sc_hd__o211a_1
XFILLER_0_48_341 VGND VGND VPWR VPWR sky130_fd_sc_hd__decap_3
X_8708_ clknet_leaf_32_clk _0117_ _0459_ VGND VGND VPWR VPWR bit_sum3\[9\] sky130_fd_sc_hd__dfrtp_1
XFILLER_0_106_402 VGND VGND VPWR VPWR sky130_fd_sc_hd__fill_1
XFILLER_0_90_141 VGND VGND VPWR VPWR sky130_fd_sc_hd__decap_4
X_8639_ clknet_leaf_14_clk net114 _0390_ VGND VGND VPWR VPWR s4\[13\] sky130_fd_sc_hd__dfrtp_1
XFILLER_0_36_569 VGND VGND VPWR VPWR sky130_fd_sc_hd__fill_1
XFILLER_0_106_457 VPWR VGND VPWR VGND sky130_ef_sc_hd__decap_12
XFILLER_0_121_449 VGND VGND VPWR VPWR sky130_fd_sc_hd__decap_8
XFILLER_0_80_29 VPWR VGND VPWR VGND sky130_ef_sc_hd__decap_12
XFILLER_0_104_69 VPWR VGND VPWR VGND sky130_ef_sc_hd__decap_12
XFILLER_0_66_193 VGND VGND VPWR VPWR sky130_fd_sc_hd__decap_3
XFILLER_0_15_709 VPWR VGND VPWR VGND sky130_ef_sc_hd__decap_12
XFILLER_0_89_27 VPWR VGND VPWR VGND sky130_ef_sc_hd__decap_12
XFILLER_0_82_697 VGND VGND VPWR VPWR sky130_fd_sc_hd__decap_3
XFILLER_0_42_517 VPWR VGND VPWR VGND sky130_ef_sc_hd__decap_12
XFILLER_0_1_113 VPWR VGND VPWR VGND sky130_ef_sc_hd__decap_12
XFILLER_0_2_625 VPWR VGND VPWR VGND sky130_ef_sc_hd__decap_12
XFILLER_0_22_230 VGND VGND VPWR VPWR sky130_fd_sc_hd__fill_2
XFILLER_0_50_561 VGND VGND VPWR VPWR sky130_fd_sc_hd__fill_1
X_4320_ _1238_ _1235_ _1293_ VGND VGND VPWR VPWR _1367_ sky130_fd_sc_hd__o21a_1
XFILLER_0_2_669 VPWR VGND VPWR VGND sky130_ef_sc_hd__decap_12
XFILLER_0_22_263 VGND VGND VPWR VPWR sky130_fd_sc_hd__fill_2
X_4251_ net32 VGND VGND VPWR VPWR _1299_ sky130_fd_sc_hd__buf_4
XFILLER_0_10_447 VPWR VGND VPWR VGND sky130_ef_sc_hd__decap_12
XFILLER_0_38_53 VGND VGND VPWR VPWR sky130_fd_sc_hd__fill_2
XFILLER_0_38_97 VGND VGND VPWR VPWR sky130_fd_sc_hd__fill_1
X_7941_ _0733_ _0771_ _0777_ VGND VGND VPWR VPWR _0790_ sky130_fd_sc_hd__o21ai_2
X_7872_ sh10\[3\] sh11\[3\] _0721_ VGND VGND VPWR VPWR _0722_ sky130_fd_sc_hd__a21o_1
X_6823_ _3799_ _3809_ _3811_ VGND VGND VPWR VPWR _3812_ sky130_fd_sc_hd__nand3_1
XFILLER_0_49_149 VGND VGND VPWR VPWR sky130_fd_sc_hd__fill_1
X_6754_ _3735_ _3738_ _3742_ VGND VGND VPWR VPWR _3743_ sky130_fd_sc_hd__nand3_4
X_6685_ _3677_ _3678_ VGND VGND VPWR VPWR _3679_ sky130_fd_sc_hd__nand2_1
XFILLER_0_18_558 VGND VGND VPWR VPWR sky130_fd_sc_hd__decap_8
X_5705_ _2720_ _2716_ _2719_ VGND VGND VPWR VPWR _2722_ sky130_fd_sc_hd__nand3_2
X_8424_ _1232_ _1234_ VGND VGND VPWR VPWR _1254_ sky130_fd_sc_hd__nor2_1
XFILLER_0_115_210 VPWR VGND VPWR VGND sky130_ef_sc_hd__decap_12
XFILLER_0_73_697 VGND VGND VPWR VPWR sky130_fd_sc_hd__fill_1
X_5636_ _2597_ _2651_ _2596_ VGND VGND VPWR VPWR _2654_ sky130_fd_sc_hd__o21ai_1
XFILLER_0_103_449 VPWR VGND VPWR VGND sky130_ef_sc_hd__decap_12
XFILLER_0_103_438 VGND VGND VPWR VPWR sky130_fd_sc_hd__decap_8
X_8355_ _1188_ _1189_ carry5\[11\] VGND VGND VPWR VPWR _1190_ sky130_fd_sc_hd__or3b_1
X_5567_ _2584_ _2580_ _2585_ VGND VGND VPWR VPWR _2586_ sky130_fd_sc_hd__a21boi_2
X_4518_ _1547_ _1545_ _1559_ _1560_ _1561_ VGND VGND VPWR VPWR _1562_ sky130_fd_sc_hd__o2111ai_4
Xhold120 sh4\[5\] VGND VGND VPWR VPWR net162 sky130_fd_sc_hd__dlygate4sd3_1
XFILLER_0_79_93 VPWR VGND VPWR VGND sky130_ef_sc_hd__decap_12
Xhold153 _0079_ VGND VGND VPWR VPWR net195 sky130_fd_sc_hd__dlygate4sd3_1
X_7306_ _4138_ VGND VGND VPWR VPWR _0325_ sky130_fd_sc_hd__inv_2
X_8286_ _1117_ _1128_ VGND VGND VPWR VPWR _1129_ sky130_fd_sc_hd__xnor2_1
Xhold131 sh15\[3\] VGND VGND VPWR VPWR net173 sky130_fd_sc_hd__dlygate4sd3_1
X_5498_ _2481_ _2511_ _2513_ _2509_ _2516_ VGND VGND VPWR VPWR _2517_ sky130_fd_sc_hd__o221ai_4
Xhold142 final_sum\[2\] VGND VGND VPWR VPWR net184 sky130_fd_sc_hd__dlygate4sd3_1
X_4449_ _1237_ _1247_ VGND VGND VPWR VPWR _1494_ sky130_fd_sc_hd__nand2_1
Xhold175 s4\[7\] VGND VGND VPWR VPWR net217 sky130_fd_sc_hd__dlygate4sd3_1
Xhold186 _0075_ VGND VGND VPWR VPWR net228 sky130_fd_sc_hd__dlygate4sd3_1
Xhold164 sh3\[1\] VGND VGND VPWR VPWR net206 sky130_fd_sc_hd__dlygate4sd3_1
X_7237_ _4131_ VGND VGND VPWR VPWR _0263_ sky130_fd_sc_hd__inv_2
XFILLER_0_111_493 VGND VGND VPWR VPWR sky130_fd_sc_hd__fill_1
Xhold197 sh11\[6\] VGND VGND VPWR VPWR net239 sky130_fd_sc_hd__dlygate4sd3_1
X_7168_ _4124_ VGND VGND VPWR VPWR _0201_ sky130_fd_sc_hd__inv_2
X_6119_ _3116_ _3119_ VGND VGND VPWR VPWR _3126_ sky130_fd_sc_hd__nand2_1
X_7099_ _4080_ _4081_ _4082_ VGND VGND VPWR VPWR _4083_ sky130_fd_sc_hd__o21ai_2
XTAP_480 VGND VPWR sky130_fd_sc_hd__tapvpwrvgnd_1
XTAP_491 VGND VPWR sky130_fd_sc_hd__tapvpwrvgnd_1
XFILLER_0_96_701 VPWR VGND VPWR VGND sky130_ef_sc_hd__decap_12
XTAP_1624 VGND VPWR sky130_fd_sc_hd__tapvpwrvgnd_1
XTAP_1613 VGND VPWR sky130_fd_sc_hd__tapvpwrvgnd_1
XTAP_1602 VGND VPWR sky130_fd_sc_hd__tapvpwrvgnd_1
XTAP_1657 VGND VPWR sky130_fd_sc_hd__tapvpwrvgnd_1
XTAP_1635 VGND VPWR sky130_fd_sc_hd__tapvpwrvgnd_1
XTAP_1646 VGND VPWR sky130_fd_sc_hd__tapvpwrvgnd_1
XTAP_1679 VGND VPWR sky130_fd_sc_hd__tapvpwrvgnd_1
XTAP_1668 VGND VPWR sky130_fd_sc_hd__tapvpwrvgnd_1
XFILLER_0_64_620 VGND VGND VPWR VPWR sky130_fd_sc_hd__fill_1
XFILLER_0_64_631 VGND VGND VPWR VPWR sky130_fd_sc_hd__fill_2
XFILLER_0_63_152 VGND VGND VPWR VPWR sky130_fd_sc_hd__decap_3
XFILLER_0_24_517 VPWR VGND VPWR VGND sky130_ef_sc_hd__decap_12
XFILLER_0_51_303 VGND VGND VPWR VPWR sky130_fd_sc_hd__fill_2
XFILLER_0_51_325 VGND VGND VPWR VPWR sky130_fd_sc_hd__decap_8
XFILLER_0_20_701 VPWR VGND VPWR VGND sky130_ef_sc_hd__decap_12
XFILLER_0_121_279 VGND VGND VPWR VPWR sky130_fd_sc_hd__fill_1
XFILLER_0_99_572 VGND VGND VPWR VPWR sky130_fd_sc_hd__decap_3
XFILLER_0_91_39 VGND VGND VPWR VPWR sky130_fd_sc_hd__decap_8
XFILLER_0_115_57 VPWR VGND VPWR VGND sky130_ef_sc_hd__decap_12
XFILLER_0_46_108 VGND VGND VPWR VPWR sky130_fd_sc_hd__fill_1
XFILLER_0_39_182 VGND VGND VPWR VPWR sky130_fd_sc_hd__decap_4
X_6470_ _3457_ _3458_ _3441_ _3443_ VGND VGND VPWR VPWR _3468_ sky130_fd_sc_hd__o211ai_2
XFILLER_0_70_623 VGND VGND VPWR VPWR sky130_fd_sc_hd__decap_8
XFILLER_0_54_174 VGND VGND VPWR VPWR sky130_fd_sc_hd__fill_2
XFILLER_0_15_539 VGND VGND VPWR VPWR sky130_fd_sc_hd__decap_8
XFILLER_0_27_399 VGND VGND VPWR VPWR sky130_fd_sc_hd__fill_1
XFILLER_0_40_65 VPWR VGND VPWR VGND sky130_ef_sc_hd__decap_12
XFILLER_0_70_678 VPWR VGND VPWR VGND sky130_ef_sc_hd__decap_12
X_5421_ _2443_ _2444_ _2407_ _2404_ VGND VGND VPWR VPWR _2445_ sky130_fd_sc_hd__a211oi_1
XFILLER_0_112_246 VGND VGND VPWR VPWR sky130_fd_sc_hd__decap_6
XFILLER_0_2_433 VPWR VGND VPWR VGND sky130_ef_sc_hd__decap_12
XFILLER_0_23_561 VGND VGND VPWR VPWR sky130_fd_sc_hd__decap_8
X_5352_ _2052_ net38 sh6\[2\] VGND VGND VPWR VPWR _2377_ sky130_fd_sc_hd__o21a_1
X_8140_ _0967_ _0974_ _0986_ VGND VGND VPWR VPWR _0987_ sky130_fd_sc_hd__a21oi_1
X_4303_ _1344_ _1349_ _1350_ VGND VGND VPWR VPWR _1351_ sky130_fd_sc_hd__o21a_1
XFILLER_0_2_477 VPWR VGND VPWR VGND sky130_ef_sc_hd__decap_12
X_8071_ _0917_ _0918_ _0855_ VGND VGND VPWR VPWR _0919_ sky130_fd_sc_hd__a21oi_1
X_5283_ _2240_ _2241_ _2239_ VGND VGND VPWR VPWR _2310_ sky130_fd_sc_hd__a21oi_1
X_7022_ _4002_ _4005_ _4007_ VGND VGND VPWR VPWR _4008_ sky130_fd_sc_hd__nand3_1
X_4234_ _1281_ _1269_ VGND VGND VPWR VPWR _1282_ sky130_fd_sc_hd__nand2_1
XFILLER_0_65_51 VGND VGND VPWR VPWR sky130_fd_sc_hd__fill_2
XFILLER_0_4_65 VPWR VGND VPWR VGND sky130_ef_sc_hd__decap_12
XFILLER_0_78_701 VGND VGND VPWR VPWR sky130_fd_sc_hd__decap_8
X_7924_ net42 _0772_ VGND VGND VPWR VPWR _0773_ sky130_fd_sc_hd__and2_2
XFILLER_0_77_266 VPWR VGND VPWR VGND sky130_ef_sc_hd__decap_12
X_7855_ net352 s6\[10\] sum4\[10\] VGND VGND VPWR VPWR _0713_ sky130_fd_sc_hd__a21o_1
XFILLER_0_65_439 VGND VGND VPWR VPWR sky130_fd_sc_hd__decap_8
X_6806_ _3781_ _3782_ _3762_ _3771_ VGND VGND VPWR VPWR _3795_ sky130_fd_sc_hd__o211a_1
X_4998_ _2027_ _2028_ _2029_ VGND VGND VPWR VPWR _2030_ sky130_fd_sc_hd__and3_1
X_7786_ carry2\[9\] net248 _0678_ VGND VGND VPWR VPWR _0020_ sky130_fd_sc_hd__o21a_1
XFILLER_0_18_333 VGND VGND VPWR VPWR sky130_fd_sc_hd__decap_6
XFILLER_0_46_631 VPWR VGND VPWR VGND sky130_ef_sc_hd__decap_12
X_6737_ _3716_ _3721_ _3725_ _3726_ VGND VGND VPWR VPWR _3727_ sky130_fd_sc_hd__a211o_1
XFILLER_0_116_552 VGND VGND VPWR VPWR sky130_fd_sc_hd__decap_8
X_6668_ _3660_ _3657_ _3661_ VGND VGND VPWR VPWR _3662_ sky130_fd_sc_hd__a21o_1
XFILLER_0_61_645 VGND VGND VPWR VPWR sky130_fd_sc_hd__decap_4
X_8407_ sh1\[5\] VGND VGND VPWR VPWR _1237_ sky130_fd_sc_hd__clkbuf_4
XFILLER_0_104_725 VGND VGND VPWR VPWR sky130_fd_sc_hd__decap_8
XFILLER_0_103_213 VGND VGND VPWR VPWR sky130_fd_sc_hd__decap_8
X_6599_ _3593_ _3594_ VGND VGND VPWR VPWR _3595_ sky130_fd_sc_hd__nor2_1
XFILLER_0_61_689 VGND VGND VPWR VPWR sky130_fd_sc_hd__fill_1
X_5619_ _2578_ _2570_ VGND VGND VPWR VPWR _2637_ sky130_fd_sc_hd__nand2_1
XFILLER_0_5_271 VGND VGND VPWR VPWR sky130_fd_sc_hd__decap_4
X_8338_ _1157_ _1172_ _1174_ VGND VGND VPWR VPWR _1175_ sky130_fd_sc_hd__a21o_1
XFILLER_0_60_177 VPWR VGND VPWR VGND sky130_ef_sc_hd__decap_12
X_8269_ _1110_ _1112_ _1072_ VGND VGND VPWR VPWR _1113_ sky130_fd_sc_hd__a21o_1
XTAP_1432 VGND VPWR sky130_fd_sc_hd__tapvpwrvgnd_1
XTAP_1421 VGND VPWR sky130_fd_sc_hd__tapvpwrvgnd_1
XTAP_1410 VGND VPWR sky130_fd_sc_hd__tapvpwrvgnd_1
XTAP_1465 VGND VPWR sky130_fd_sc_hd__tapvpwrvgnd_1
XTAP_1454 VGND VPWR sky130_fd_sc_hd__tapvpwrvgnd_1
XTAP_1443 VGND VPWR sky130_fd_sc_hd__tapvpwrvgnd_1
XFILLER_0_68_277 VGND VGND VPWR VPWR sky130_fd_sc_hd__fill_1
XFILLER_0_56_428 VGND VGND VPWR VPWR sky130_fd_sc_hd__decap_8
XTAP_1498 VGND VPWR sky130_fd_sc_hd__tapvpwrvgnd_1
XTAP_1487 VGND VPWR sky130_fd_sc_hd__tapvpwrvgnd_1
XTAP_1476 VGND VPWR sky130_fd_sc_hd__tapvpwrvgnd_1
XFILLER_0_64_461 VGND VGND VPWR VPWR sky130_fd_sc_hd__fill_1
XFILLER_0_36_141 VPWR VGND VPWR VGND sky130_ef_sc_hd__decap_12
XFILLER_0_51_111 VGND VGND VPWR VPWR sky130_fd_sc_hd__fill_1
XFILLER_0_122_533 VGND VGND VPWR VPWR sky130_fd_sc_hd__decap_8
XFILLER_0_51_133 VGND VGND VPWR VPWR sky130_fd_sc_hd__decap_3
XFILLER_0_51_166 VGND VGND VPWR VPWR sky130_fd_sc_hd__fill_2
XFILLER_0_51_199 VGND VGND VPWR VPWR sky130_fd_sc_hd__fill_1
XFILLER_0_20_564 VPWR VGND VPWR VGND sky130_ef_sc_hd__decap_12
X_5970_ _2978_ _2927_ _2975_ _2976_ _2974_ VGND VGND VPWR VPWR _2979_ sky130_fd_sc_hd__o221a_1
X_4921_ _1649_ _1668_ VGND VGND VPWR VPWR _1955_ sky130_fd_sc_hd__nand2_2
XFILLER_0_59_255 VPWR VGND VPWR VGND sky130_ef_sc_hd__decap_12
X_4852_ _1790_ _1880_ _1881_ _1887_ VGND VGND VPWR VPWR _1888_ sky130_fd_sc_hd__o211ai_4
XFILLER_0_87_575 VPWR VGND VPWR VGND sky130_ef_sc_hd__decap_12
XFILLER_0_75_726 VGND VGND VPWR VPWR sky130_fd_sc_hd__fill_2
X_7640_ sum3\[5\] net449 VGND VGND VPWR VPWR _4171_ sky130_fd_sc_hd__nor2_1
X_4783_ _1677_ _1725_ _1721_ VGND VGND VPWR VPWR _1820_ sky130_fd_sc_hd__o21a_1
XFILLER_0_7_558 VGND VGND VPWR VPWR sky130_fd_sc_hd__fill_2
X_7571_ _4164_ VGND VGND VPWR VPWR _0564_ sky130_fd_sc_hd__inv_2
X_6522_ _3499_ _3502_ _3504_ VGND VGND VPWR VPWR _3519_ sky130_fd_sc_hd__a21o_1
XFILLER_0_27_163 VGND VGND VPWR VPWR sky130_fd_sc_hd__decap_4
XFILLER_0_42_111 VPWR VGND VPWR VGND sky130_ef_sc_hd__decap_12
X_6453_ sh9\[4\] VGND VGND VPWR VPWR _3451_ sky130_fd_sc_hd__buf_2
XFILLER_0_82_291 VGND VGND VPWR VPWR sky130_fd_sc_hd__decap_6
X_5404_ _2389_ _2382_ VGND VGND VPWR VPWR _2428_ sky130_fd_sc_hd__nand2_1
XFILLER_0_42_188 VGND VGND VPWR VPWR sky130_fd_sc_hd__decap_8
XFILLER_0_113_577 VGND VGND VPWR VPWR sky130_fd_sc_hd__decap_8
X_6384_ _3330_ _3332_ _3341_ _3347_ VGND VGND VPWR VPWR _3383_ sky130_fd_sc_hd__a2bb2o_1
X_8123_ _0954_ _0969_ _0957_ _0946_ _0950_ VGND VGND VPWR VPWR _0970_ sky130_fd_sc_hd__o2111ai_4
XFILLER_0_30_339 VGND VGND VPWR VPWR sky130_fd_sc_hd__decap_8
XFILLER_0_11_553 VGND VGND VPWR VPWR sky130_fd_sc_hd__fill_1
X_5335_ _2349_ _2353_ _2360_ VGND VGND VPWR VPWR _2361_ sky130_fd_sc_hd__a21o_1
X_5266_ _2040_ sh12\[2\] _2195_ VGND VGND VPWR VPWR _2293_ sky130_fd_sc_hd__a21oi_1
X_8054_ _0893_ _0889_ _0830_ VGND VGND VPWR VPWR _0902_ sky130_fd_sc_hd__a21oi_1
XFILLER_0_76_83 VGND VGND VPWR VPWR sky130_fd_sc_hd__fill_1
X_7005_ _3990_ _3989_ VGND VGND VPWR VPWR _3991_ sky130_fd_sc_hd__nand2_1
X_5197_ _2200_ _2223_ _2224_ VGND VGND VPWR VPWR _2225_ sky130_fd_sc_hd__nand3b_2
XFILLER_0_92_93 VGND VGND VPWR VPWR sky130_fd_sc_hd__decap_3
XFILLER_0_92_82 VGND VGND VPWR VPWR sky130_fd_sc_hd__fill_2
X_7907_ _0755_ _0756_ VGND VGND VPWR VPWR _0757_ sky130_fd_sc_hd__nand2_1
X_7838_ sum3\[10\] net407 _0704_ VGND VGND VPWR VPWR _0030_ sky130_fd_sc_hd__o21a_1
XFILLER_0_19_631 VGND VGND VPWR VPWR sky130_fd_sc_hd__decap_3
X_7769_ carry4\[13\] sum4\[14\] VGND VGND VPWR VPWR _0669_ sky130_fd_sc_hd__nor2_1
XFILLER_0_81_729 VGND VGND VPWR VPWR sky130_fd_sc_hd__decap_6
XFILLER_0_80_206 VGND VGND VPWR VPWR sky130_fd_sc_hd__fill_2
XFILLER_0_18_141 VGND VGND VPWR VPWR sky130_fd_sc_hd__decap_8
XFILLER_0_19_697 VPWR VGND VPWR VGND sky130_ef_sc_hd__decap_12
XFILLER_0_33_111 VGND VGND VPWR VPWR sky130_fd_sc_hd__fill_1
XFILLER_0_34_645 VGND VGND VPWR VPWR sky130_fd_sc_hd__fill_2
XFILLER_0_116_360 VGND VGND VPWR VPWR sky130_fd_sc_hd__decap_4
XFILLER_0_34_656 VPWR VGND VPWR VGND sky130_ef_sc_hd__decap_12
XFILLER_0_104_544 VGND VGND VPWR VPWR sky130_fd_sc_hd__decap_4
XFILLER_0_104_533 VGND VGND VPWR VPWR sky130_fd_sc_hd__decap_6
XFILLER_0_33_166 VGND VGND VPWR VPWR sky130_fd_sc_hd__fill_2
XFILLER_0_33_177 VGND VGND VPWR VPWR sky130_fd_sc_hd__fill_2
XFILLER_0_84_512 VPWR VGND VPWR VGND sky130_ef_sc_hd__decap_12
XTAP_1240 VGND VPWR sky130_fd_sc_hd__tapvpwrvgnd_1
XFILLER_0_57_726 VGND VGND VPWR VPWR sky130_fd_sc_hd__fill_2
XFILLER_0_29_417 VGND VGND VPWR VPWR sky130_fd_sc_hd__decap_4
XFILLER_0_29_428 VGND VGND VPWR VPWR sky130_fd_sc_hd__fill_2
XFILLER_0_96_394 VGND VGND VPWR VPWR sky130_fd_sc_hd__decap_8
XTAP_1284 VGND VPWR sky130_fd_sc_hd__tapvpwrvgnd_1
XTAP_1273 VGND VPWR sky130_fd_sc_hd__tapvpwrvgnd_1
XTAP_1262 VGND VPWR sky130_fd_sc_hd__tapvpwrvgnd_1
XTAP_1251 VGND VPWR sky130_fd_sc_hd__tapvpwrvgnd_1
XFILLER_0_56_247 VGND VGND VPWR VPWR sky130_fd_sc_hd__decap_4
XTAP_1295 VGND VPWR sky130_fd_sc_hd__tapvpwrvgnd_1
XFILLER_0_4_506 VGND VGND VPWR VPWR sky130_fd_sc_hd__decap_6
XFILLER_0_21_67 VGND VGND VPWR VPWR sky130_fd_sc_hd__fill_1
XFILLER_0_107_393 VGND VGND VPWR VPWR sky130_fd_sc_hd__fill_2
XFILLER_0_97_27 VGND VGND VPWR VPWR sky130_fd_sc_hd__decap_6
XFILLER_0_110_514 VGND VGND VPWR VPWR sky130_fd_sc_hd__decap_4
XFILLER_0_0_701 VPWR VGND VPWR VGND sky130_ef_sc_hd__decap_12
X_5120_ _2139_ _2148_ _2063_ VGND VGND VPWR VPWR _2149_ sky130_fd_sc_hd__o21ai_2
X_5051_ _2046_ _2050_ _2077_ _2079_ VGND VGND VPWR VPWR _2081_ sky130_fd_sc_hd__nand4_1
X_8810_ clknet_leaf_6_clk net37 _0561_ VGND VGND VPWR VPWR sh7\[6\] sky130_fd_sc_hd__dfrtp_4
XFILLER_0_79_317 VGND VGND VPWR VPWR sky130_fd_sc_hd__fill_1
XFILLER_0_94_309 VGND VGND VPWR VPWR sky130_fd_sc_hd__decap_8
X_8741_ clknet_leaf_23_clk _0182_ _0492_ VGND VGND VPWR VPWR bit_sum7\[2\] sky130_fd_sc_hd__dfrtp_1
XFILLER_0_1_55 VGND VGND VPWR VPWR sky130_fd_sc_hd__fill_1
X_5953_ _2958_ _2959_ _2961_ VGND VGND VPWR VPWR _2962_ sky130_fd_sc_hd__o21ai_2
X_4904_ _1909_ _1938_ VGND VGND VPWR VPWR _1939_ sky130_fd_sc_hd__nor2_1
X_5884_ sh5\[6\] VGND VGND VPWR VPWR _2894_ sky130_fd_sc_hd__clkbuf_4
XFILLER_0_62_85 VGND VGND VPWR VPWR sky130_fd_sc_hd__decap_4
X_8672_ clknet_leaf_51_clk _0174_ _0423_ VGND VGND VPWR VPWR bit_sum0\[3\] sky130_fd_sc_hd__dfrtp_1
XFILLER_0_47_225 VGND VGND VPWR VPWR sky130_fd_sc_hd__fill_2
XFILLER_0_117_113 VGND VGND VPWR VPWR sky130_fd_sc_hd__decap_8
XFILLER_0_117_102 VGND VGND VPWR VPWR sky130_fd_sc_hd__decap_8
X_4835_ _1714_ _1716_ _1710_ VGND VGND VPWR VPWR _1871_ sky130_fd_sc_hd__o21ai_4
XFILLER_0_63_729 VGND VGND VPWR VPWR sky130_fd_sc_hd__decap_6
XFILLER_0_63_718 VGND VGND VPWR VPWR sky130_fd_sc_hd__decap_8
XFILLER_0_16_601 VGND VGND VPWR VPWR sky130_fd_sc_hd__fill_2
X_7623_ _4169_ VGND VGND VPWR VPWR _0611_ sky130_fd_sc_hd__inv_2
X_4766_ _1717_ _1693_ VGND VGND VPWR VPWR _1803_ sky130_fd_sc_hd__nand2_1
X_7554_ _4158_ VGND VGND VPWR VPWR _4163_ sky130_fd_sc_hd__buf_8
XFILLER_0_15_100 VGND VGND VPWR VPWR sky130_fd_sc_hd__fill_1
XFILLER_0_105_319 VPWR VGND VPWR VGND sky130_ef_sc_hd__decap_12
X_6505_ _3491_ _3495_ _3500_ _3501_ VGND VGND VPWR VPWR _3502_ sky130_fd_sc_hd__o2bb2ai_2
X_4697_ _1685_ _1646_ _1649_ _1648_ VGND VGND VPWR VPWR _1735_ sky130_fd_sc_hd__o211ai_2
X_7485_ _4155_ VGND VGND VPWR VPWR _0487_ sky130_fd_sc_hd__inv_2
XFILLER_0_70_250 VGND VGND VPWR VPWR sky130_fd_sc_hd__fill_2
XFILLER_0_15_166 VGND VGND VPWR VPWR sky130_fd_sc_hd__fill_2
X_6436_ _3422_ _3424_ _3431_ _3433_ VGND VGND VPWR VPWR _3434_ sky130_fd_sc_hd__o22ai_4
XFILLER_0_3_561 VPWR VGND VPWR VGND sky130_ef_sc_hd__decap_12
XFILLER_0_3_550 VGND VGND VPWR VPWR sky130_fd_sc_hd__decap_3
X_6367_ _3296_ _3298_ VGND VGND VPWR VPWR _3366_ sky130_fd_sc_hd__nand2_1
X_8106_ _0740_ _0747_ _0951_ VGND VGND VPWR VPWR _0953_ sky130_fd_sc_hd__a21o_1
XFILLER_0_11_372 VPWR VGND VPWR VGND sky130_ef_sc_hd__decap_12
X_5318_ _2048_ _2041_ _2110_ _2343_ VGND VGND VPWR VPWR _2344_ sky130_fd_sc_hd__and4_1
X_6298_ sh3\[4\] VGND VGND VPWR VPWR _3298_ sky130_fd_sc_hd__clkbuf_4
Xhold13 bit_sum3\[6\] VGND VGND VPWR VPWR net55 sky130_fd_sc_hd__dlygate4sd3_1
Xhold35 bit_sum4\[1\] VGND VGND VPWR VPWR net77 sky130_fd_sc_hd__dlygate4sd3_1
Xhold24 sum5\[4\] VGND VGND VPWR VPWR net66 sky130_fd_sc_hd__dlygate4sd3_1
X_5249_ _2249_ _2267_ _2273_ _2275_ VGND VGND VPWR VPWR _2276_ sky130_fd_sc_hd__o2bb2ai_2
Xhold46 sum3\[1\] VGND VGND VPWR VPWR net88 sky130_fd_sc_hd__dlygate4sd3_1
X_8037_ _0832_ _0836_ _0818_ _0882_ _0876_ VGND VGND VPWR VPWR _0885_ sky130_fd_sc_hd__o2111ai_4
Xhold68 final_sum\[9\] VGND VGND VPWR VPWR net110 sky130_fd_sc_hd__dlygate4sd3_1
Xhold79 sum3\[3\] VGND VGND VPWR VPWR net121 sky130_fd_sc_hd__dlygate4sd3_1
Xhold57 bit_sum0\[8\] VGND VGND VPWR VPWR net99 sky130_fd_sc_hd__dlygate4sd3_1
XFILLER_0_97_169 VGND VGND VPWR VPWR sky130_fd_sc_hd__decap_4
XFILLER_0_78_361 VGND VGND VPWR VPWR sky130_fd_sc_hd__decap_3
XFILLER_0_66_589 VGND VGND VPWR VPWR sky130_fd_sc_hd__decap_6
XFILLER_0_22_637 VGND VGND VPWR VPWR sky130_fd_sc_hd__decap_6
XFILLER_0_21_158 VGND VGND VPWR VPWR sky130_fd_sc_hd__decap_8
XTAP_309 VGND VPWR sky130_fd_sc_hd__tapvpwrvgnd_1
XFILLER_0_57_501 VGND VGND VPWR VPWR sky130_fd_sc_hd__decap_3
XFILLER_0_29_225 VGND VGND VPWR VPWR sky130_fd_sc_hd__fill_2
XFILLER_0_123_57 VPWR VGND VPWR VGND sky130_ef_sc_hd__decap_12
XTAP_1092 VGND VPWR sky130_fd_sc_hd__tapvpwrvgnd_1
XTAP_1081 VGND VPWR sky130_fd_sc_hd__tapvpwrvgnd_1
XTAP_1070 VGND VPWR sky130_fd_sc_hd__tapvpwrvgnd_1
XFILLER_0_57_556 VGND VGND VPWR VPWR sky130_fd_sc_hd__decap_4
XFILLER_0_32_55 VPWR VGND VPWR VGND sky130_ef_sc_hd__decap_12
XFILLER_0_45_729 VGND VGND VPWR VPWR sky130_fd_sc_hd__decap_6
X_4620_ _1640_ _1642_ _1655_ _1656_ _1658_ VGND VGND VPWR VPWR _1659_ sky130_fd_sc_hd__o221ai_4
XFILLER_0_113_3 VPWR VGND VPWR VGND sky130_ef_sc_hd__decap_12
X_4551_ _1593_ _1531_ _1579_ VGND VGND VPWR VPWR _1594_ sky130_fd_sc_hd__or3b_1
XFILLER_0_13_615 VGND VGND VPWR VPWR sky130_fd_sc_hd__fill_1
X_4482_ _1526_ _1512_ _1513_ VGND VGND VPWR VPWR _1527_ sky130_fd_sc_hd__a21oi_1
X_7270_ _4134_ VGND VGND VPWR VPWR _0293_ sky130_fd_sc_hd__inv_2
XFILLER_0_4_369 VGND VGND VPWR VPWR sky130_fd_sc_hd__fill_1
X_6221_ _3216_ _3220_ _3222_ VGND VGND VPWR VPWR _3226_ sky130_fd_sc_hd__a21oi_2
XFILLER_0_110_333 VPWR VGND VPWR VGND sky130_ef_sc_hd__decap_12
X_6152_ _3079_ _3088_ _3092_ VGND VGND VPWR VPWR _3158_ sky130_fd_sc_hd__a21oi_2
XTAP_810 VGND VPWR sky130_fd_sc_hd__tapvpwrvgnd_1
X_5103_ _2050_ _2077_ _2079_ _2131_ VGND VGND VPWR VPWR _2132_ sky130_fd_sc_hd__a31o_2
XTAP_821 VGND VPWR sky130_fd_sc_hd__tapvpwrvgnd_1
XTAP_832 VGND VPWR sky130_fd_sc_hd__tapvpwrvgnd_1
XTAP_843 VGND VPWR sky130_fd_sc_hd__tapvpwrvgnd_1
X_6083_ _3027_ _3019_ _3004_ VGND VGND VPWR VPWR _3090_ sky130_fd_sc_hd__o21ai_2
XTAP_854 VGND VPWR sky130_fd_sc_hd__tapvpwrvgnd_1
XTAP_876 VGND VPWR sky130_fd_sc_hd__tapvpwrvgnd_1
XTAP_865 VGND VPWR sky130_fd_sc_hd__tapvpwrvgnd_1
X_5034_ _2053_ _2055_ sh3\[2\] VGND VGND VPWR VPWR _2064_ sky130_fd_sc_hd__o21ai_1
XTAP_887 VGND VPWR sky130_fd_sc_hd__tapvpwrvgnd_1
XTAP_898 VGND VPWR sky130_fd_sc_hd__tapvpwrvgnd_1
XFILLER_0_79_125 VPWR VGND VPWR VGND sky130_ef_sc_hd__decap_12
XFILLER_0_18_3 VPWR VGND VPWR VGND sky130_ef_sc_hd__decap_12
XFILLER_0_88_670 VGND VGND VPWR VPWR sky130_fd_sc_hd__fill_2
XFILLER_0_79_169 VGND VGND VPWR VPWR sky130_fd_sc_hd__decap_8
XFILLER_0_73_84 VPWR VGND VPWR VGND sky130_ef_sc_hd__decap_12
X_6985_ _3708_ _3916_ _3967_ _3968_ _3970_ VGND VGND VPWR VPWR _3971_ sky130_fd_sc_hd__o221ai_4
X_5936_ _2934_ _2944_ _2942_ VGND VGND VPWR VPWR _2945_ sky130_fd_sc_hd__o21bai_1
X_8724_ clknet_leaf_14_clk _0131_ _0475_ VGND VGND VPWR VPWR bit_sum5\[5\] sky130_fd_sc_hd__dfrtp_1
XFILLER_0_87_180 VPWR VGND VPWR VGND sky130_ef_sc_hd__decap_12
XFILLER_0_75_320 VGND VGND VPWR VPWR sky130_fd_sc_hd__decap_4
X_8655_ clknet_leaf_29_clk net119 _0406_ VGND VGND VPWR VPWR s6\[11\] sky130_fd_sc_hd__dfrtp_1
XFILLER_0_48_567 VGND VGND VPWR VPWR sky130_fd_sc_hd__decap_3
X_5867_ _2871_ _2874_ _2875_ VGND VGND VPWR VPWR _2877_ sky130_fd_sc_hd__a21oi_1
XFILLER_0_75_375 VPWR VGND VPWR VGND sky130_ef_sc_hd__decap_12
X_7606_ _4167_ VGND VGND VPWR VPWR _0596_ sky130_fd_sc_hd__inv_2
XFILLER_0_48_589 VGND VGND VPWR VPWR sky130_fd_sc_hd__decap_4
XFILLER_0_118_477 VGND VGND VPWR VPWR sky130_fd_sc_hd__decap_4
X_4818_ _1847_ _1844_ VGND VGND VPWR VPWR _1854_ sky130_fd_sc_hd__nand2_1
XFILLER_0_63_559 VGND VGND VPWR VPWR sky130_fd_sc_hd__fill_1
X_5798_ _2810_ _2811_ _2812_ _2765_ VGND VGND VPWR VPWR _2813_ sky130_fd_sc_hd__a31oi_4
X_8586_ clknet_leaf_54_clk net378 _0337_ VGND VGND VPWR VPWR carry1\[9\] sky130_fd_sc_hd__dfrtp_1
X_4749_ _1781_ _1775_ _1779_ _1776_ VGND VGND VPWR VPWR _1786_ sky130_fd_sc_hd__o211ai_4
X_7537_ _4161_ VGND VGND VPWR VPWR _0533_ sky130_fd_sc_hd__inv_2
X_7468_ _4154_ VGND VGND VPWR VPWR _0471_ sky130_fd_sc_hd__inv_2
XFILLER_0_43_272 VGND VGND VPWR VPWR sky130_fd_sc_hd__fill_1
Xoutput14 net14 VGND VGND VPWR VPWR led[13] sky130_fd_sc_hd__clkbuf_4
XFILLER_0_114_683 VPWR VGND VPWR VGND sky130_ef_sc_hd__decap_12
XFILLER_0_101_322 VGND VGND VPWR VPWR sky130_fd_sc_hd__fill_2
Xoutput25 net25 VGND VGND VPWR VPWR led[9] sky130_fd_sc_hd__clkbuf_4
X_6419_ _3383_ _3385_ _3386_ VGND VGND VPWR VPWR _3417_ sky130_fd_sc_hd__and3_1
X_7399_ _4147_ VGND VGND VPWR VPWR _4148_ sky130_fd_sc_hd__buf_4
XFILLER_0_3_391 VGND VGND VPWR VPWR sky130_fd_sc_hd__fill_1
XFILLER_0_98_445 VGND VGND VPWR VPWR sky130_fd_sc_hd__decap_8
XPHY_142 VGND VGND VPWR VPWR sky130_fd_sc_hd__decap_3
XPHY_131 VGND VGND VPWR VPWR sky130_fd_sc_hd__decap_3
XPHY_120 VGND VGND VPWR VPWR sky130_fd_sc_hd__decap_3
XFILLER_0_54_504 VGND VGND VPWR VPWR sky130_fd_sc_hd__decap_6
XPHY_175 VGND VGND VPWR VPWR sky130_fd_sc_hd__decap_3
XPHY_164 VGND VGND VPWR VPWR sky130_fd_sc_hd__decap_3
XPHY_153 VGND VGND VPWR VPWR sky130_fd_sc_hd__decap_3
XFILLER_0_54_526 VGND VGND VPWR VPWR sky130_fd_sc_hd__decap_6
XFILLER_0_27_729 VGND VGND VPWR VPWR sky130_fd_sc_hd__decap_6
XFILLER_0_109_488 VPWR VGND VPWR VGND sky130_ef_sc_hd__decap_12
XPHY_197 VGND VGND VPWR VPWR sky130_fd_sc_hd__decap_3
XPHY_186 VGND VGND VPWR VPWR sky130_fd_sc_hd__decap_3
XFILLER_0_81_356 VGND VGND VPWR VPWR sky130_fd_sc_hd__fill_1
XFILLER_0_62_570 VGND VGND VPWR VPWR sky130_fd_sc_hd__fill_1
XFILLER_0_34_250 VGND VGND VPWR VPWR sky130_fd_sc_hd__fill_2
XFILLER_0_41_209 VGND VGND VPWR VPWR sky130_fd_sc_hd__fill_1
XFILLER_0_111_108 VGND VGND VPWR VPWR sky130_fd_sc_hd__decap_4
XFILLER_0_78_29 VPWR VGND VPWR VGND sky130_ef_sc_hd__decap_12
XFILLER_0_34_272 VGND VGND VPWR VPWR sky130_fd_sc_hd__fill_2
XFILLER_0_1_328 VGND VGND VPWR VPWR sky130_fd_sc_hd__fill_1
XFILLER_0_27_88 VGND VGND VPWR VPWR sky130_fd_sc_hd__decap_6
XFILLER_0_77_629 VGND VGND VPWR VPWR sky130_fd_sc_hd__decap_8
XFILLER_0_119_208 VGND VGND VPWR VPWR sky130_fd_sc_hd__decap_4
XFILLER_0_76_139 VGND VGND VPWR VPWR sky130_fd_sc_hd__fill_1
XFILLER_0_9_417 VPWR VGND VPWR VGND sky130_ef_sc_hd__decap_12
XPHY_0 VGND VGND VPWR VPWR sky130_fd_sc_hd__decap_3
X_6770_ _3757_ _3758_ _3741_ VGND VGND VPWR VPWR _3759_ sky130_fd_sc_hd__nand3_1
XFILLER_0_85_673 VPWR VGND VPWR VGND sky130_ef_sc_hd__decap_12
X_5721_ _2484_ _2477_ _2680_ VGND VGND VPWR VPWR _2737_ sky130_fd_sc_hd__a21oi_1
X_8440_ clknet_leaf_38_clk net260 _0191_ VGND VGND VPWR VPWR carry4\[6\] sky130_fd_sc_hd__dfrtp_1
X_5652_ _2668_ _2470_ VGND VGND VPWR VPWR _2669_ sky130_fd_sc_hd__nand2_1
X_4603_ _1636_ _1641_ VGND VGND VPWR VPWR _1642_ sky130_fd_sc_hd__and2_2
X_8371_ _1192_ _1195_ _1204_ VGND VGND VPWR VPWR _1205_ sky130_fd_sc_hd__nor3_1
XFILLER_0_4_133 VGND VGND VPWR VPWR sky130_fd_sc_hd__decap_6
XFILLER_0_32_209 VGND VGND VPWR VPWR sky130_fd_sc_hd__decap_6
X_5583_ _2599_ _2600_ _2601_ VGND VGND VPWR VPWR _0173_ sky130_fd_sc_hd__a21oi_1
X_4534_ _1575_ _1576_ _1577_ VGND VGND VPWR VPWR _1578_ sky130_fd_sc_hd__nand3_1
Xhold302 sh3\[6\] VGND VGND VPWR VPWR net344 sky130_fd_sc_hd__dlygate4sd3_1
XFILLER_0_41_721 VGND VGND VPWR VPWR sky130_fd_sc_hd__decap_6
XFILLER_0_41_732 VGND VGND VPWR VPWR sky130_fd_sc_hd__decap_3
X_7322_ _4140_ VGND VGND VPWR VPWR _0339_ sky130_fd_sc_hd__inv_2
XFILLER_0_111_631 VPWR VGND VPWR VGND sky130_ef_sc_hd__decap_12
Xhold313 _0047_ VGND VGND VPWR VPWR net355 sky130_fd_sc_hd__dlygate4sd3_1
XFILLER_0_4_177 VPWR VGND VPWR VGND sky130_ef_sc_hd__decap_12
Xhold324 sh14\[2\] VGND VGND VPWR VPWR net366 sky130_fd_sc_hd__dlygate4sd3_1
Xhold335 s1\[9\] VGND VGND VPWR VPWR net377 sky130_fd_sc_hd__dlygate4sd3_1
X_4465_ _1505_ _1509_ VGND VGND VPWR VPWR _1510_ sky130_fd_sc_hd__nand2_2
XFILLER_0_110_141 VGND VGND VPWR VPWR sky130_fd_sc_hd__decap_6
Xhold368 sh8\[6\] VGND VGND VPWR VPWR net410 sky130_fd_sc_hd__dlygate4sd3_1
Xhold346 _0007_ VGND VGND VPWR VPWR net388 sky130_fd_sc_hd__dlygate4sd3_1
Xhold357 s2\[10\] VGND VGND VPWR VPWR net399 sky130_fd_sc_hd__dlygate4sd3_1
X_7253_ _4132_ VGND VGND VPWR VPWR _0278_ sky130_fd_sc_hd__inv_2
X_6204_ _3193_ _3194_ _3196_ VGND VGND VPWR VPWR _3209_ sky130_fd_sc_hd__o21ai_1
X_4396_ _1440_ _1354_ _1441_ VGND VGND VPWR VPWR _1442_ sky130_fd_sc_hd__a21o_2
X_7184_ _4126_ VGND VGND VPWR VPWR _0215_ sky130_fd_sc_hd__inv_2
Xhold379 _4176_ VGND VGND VPWR VPWR net421 sky130_fd_sc_hd__dlygate4sd3_1
X_6135_ _3138_ _3140_ net37 VGND VGND VPWR VPWR _3141_ sky130_fd_sc_hd__o21bai_4
XTAP_640 VGND VPWR sky130_fd_sc_hd__tapvpwrvgnd_1
XTAP_651 VGND VPWR sky130_fd_sc_hd__tapvpwrvgnd_1
X_6066_ _2976_ _3041_ _3036_ VGND VGND VPWR VPWR _3073_ sky130_fd_sc_hd__a21boi_4
XTAP_662 VGND VPWR sky130_fd_sc_hd__tapvpwrvgnd_1
XTAP_673 VGND VPWR sky130_fd_sc_hd__tapvpwrvgnd_1
XTAP_684 VGND VPWR sky130_fd_sc_hd__tapvpwrvgnd_1
XTAP_695 VGND VPWR sky130_fd_sc_hd__tapvpwrvgnd_1
XFILLER_0_84_83 VGND VGND VPWR VPWR sky130_fd_sc_hd__fill_1
X_5017_ sh10\[2\] _2040_ sh12\[2\] VGND VGND VPWR VPWR _2047_ sky130_fd_sc_hd__o21a_1
XTAP_1806 VGND VPWR sky130_fd_sc_hd__tapvpwrvgnd_1
XFILLER_0_95_415 VPWR VGND VPWR VGND sky130_ef_sc_hd__decap_12
XFILLER_0_67_106 VGND VGND VPWR VPWR sky130_fd_sc_hd__decap_6
XTAP_1839 VGND VPWR sky130_fd_sc_hd__tapvpwrvgnd_1
XTAP_1828 VGND VPWR sky130_fd_sc_hd__tapvpwrvgnd_1
XTAP_1817 VGND VPWR sky130_fd_sc_hd__tapvpwrvgnd_1
XFILLER_0_82_109 VPWR VGND VPWR VGND sky130_ef_sc_hd__decap_12
X_8707_ clknet_leaf_0_clk _0116_ _0458_ VGND VGND VPWR VPWR bit_sum3\[8\] sky130_fd_sc_hd__dfrtp_1
X_6968_ _3953_ _3954_ sh15\[1\] VGND VGND VPWR VPWR _3955_ sky130_fd_sc_hd__a21oi_1
X_5919_ _2926_ _2927_ VGND VGND VPWR VPWR _2928_ sky130_fd_sc_hd__nor2_1
X_6899_ _3783_ _3784_ _3886_ _3777_ _3792_ VGND VGND VPWR VPWR _3887_ sky130_fd_sc_hd__a32oi_4
X_8638_ clknet_leaf_13_clk net96 _0389_ VGND VGND VPWR VPWR s4\[12\] sky130_fd_sc_hd__dfrtp_1
XFILLER_0_63_334 VGND VGND VPWR VPWR sky130_fd_sc_hd__fill_2
XFILLER_0_8_472 VGND VGND VPWR VPWR sky130_fd_sc_hd__decap_4
X_8569_ clknet_leaf_34_clk _0064_ _0320_ VGND VGND VPWR VPWR sum2\[4\] sky130_fd_sc_hd__dfrtp_1
XFILLER_0_106_469 VGND VGND VPWR VPWR sky130_fd_sc_hd__decap_6
XFILLER_0_90_197 VGND VGND VPWR VPWR sky130_fd_sc_hd__fill_1
XFILLER_0_31_242 VPWR VGND VPWR VGND sky130_ef_sc_hd__decap_12
XFILLER_0_101_163 VGND VGND VPWR VPWR sky130_fd_sc_hd__decap_4
XFILLER_0_7_3 VPWR VGND VPWR VGND sky130_ef_sc_hd__decap_12
XFILLER_0_99_721 VGND VGND VPWR VPWR sky130_fd_sc_hd__decap_6
XFILLER_0_98_253 VGND VGND VPWR VPWR sky130_fd_sc_hd__decap_4
XFILLER_0_86_415 VGND VGND VPWR VPWR sky130_fd_sc_hd__decap_4
XFILLER_0_58_139 VGND VGND VPWR VPWR sky130_fd_sc_hd__fill_1
XFILLER_0_58_128 VGND VGND VPWR VPWR sky130_fd_sc_hd__fill_1
XFILLER_0_104_15 VPWR VGND VPWR VGND sky130_ef_sc_hd__decap_12
XFILLER_0_39_342 VGND VGND VPWR VPWR sky130_fd_sc_hd__decap_8
XFILLER_0_66_161 VPWR VGND VPWR VGND sky130_ef_sc_hd__decap_12
XFILLER_0_54_301 VGND VGND VPWR VPWR sky130_fd_sc_hd__decap_4
XFILLER_0_13_57 VGND VGND VPWR VPWR sky130_fd_sc_hd__decap_4
XFILLER_0_109_241 VGND VGND VPWR VPWR sky130_fd_sc_hd__fill_1
XFILLER_0_13_68 VGND VGND VPWR VPWR sky130_fd_sc_hd__decap_3
XFILLER_0_109_296 VGND VGND VPWR VPWR sky130_fd_sc_hd__fill_2
XFILLER_0_89_39 VPWR VGND VPWR VGND sky130_ef_sc_hd__decap_12
XFILLER_0_42_529 VGND VGND VPWR VPWR sky130_fd_sc_hd__decap_3
XFILLER_0_23_721 VGND VGND VPWR VPWR sky130_fd_sc_hd__decap_6
XFILLER_0_1_125 VPWR VGND VPWR VGND sky130_ef_sc_hd__decap_12
XFILLER_0_2_637 VGND VGND VPWR VPWR sky130_fd_sc_hd__decap_6
XFILLER_0_22_253 VGND VGND VPWR VPWR sky130_fd_sc_hd__decap_4
XFILLER_0_50_573 VGND VGND VPWR VPWR sky130_fd_sc_hd__decap_6
XFILLER_0_50_595 VGND VGND VPWR VPWR sky130_fd_sc_hd__fill_1
X_4250_ sh5\[5\] net34 VGND VGND VPWR VPWR _1298_ sky130_fd_sc_hd__and2_2
XFILLER_0_10_459 VGND VGND VPWR VPWR sky130_fd_sc_hd__decap_3
XFILLER_0_1_169 VPWR VGND VPWR VGND sky130_ef_sc_hd__decap_12
XFILLER_0_89_220 VGND VGND VPWR VPWR sky130_fd_sc_hd__decap_4
X_7940_ _0737_ _0723_ _0774_ VGND VGND VPWR VPWR _0789_ sky130_fd_sc_hd__a21oi_2
XFILLER_0_77_404 VGND VGND VPWR VPWR sky130_fd_sc_hd__decap_4
X_7871_ sh10\[3\] sh11\[3\] sh12\[3\] VGND VGND VPWR VPWR _0721_ sky130_fd_sc_hd__o21ai_2
X_6822_ _3810_ _3765_ _3770_ VGND VGND VPWR VPWR _3811_ sky130_fd_sc_hd__nand3_1
XFILLER_0_9_225 VGND VGND VPWR VPWR sky130_fd_sc_hd__fill_2
XFILLER_0_92_429 VPWR VGND VPWR VGND sky130_ef_sc_hd__decap_12
XFILLER_0_92_418 VGND VGND VPWR VPWR sky130_fd_sc_hd__fill_2
XFILLER_0_73_610 VGND VGND VPWR VPWR sky130_fd_sc_hd__decap_6
X_6753_ _3739_ _3740_ _3741_ VGND VGND VPWR VPWR _3742_ sky130_fd_sc_hd__o21a_1
XFILLER_0_18_504 VGND VGND VPWR VPWR sky130_fd_sc_hd__decap_4
XFILLER_0_116_701 VPWR VGND VPWR VGND sky130_ef_sc_hd__decap_12
X_6684_ _3675_ _3671_ _3672_ VGND VGND VPWR VPWR _3678_ sky130_fd_sc_hd__nand3_2
XFILLER_0_70_85 VGND VGND VPWR VPWR sky130_fd_sc_hd__decap_6
X_5704_ _2716_ _2719_ _2720_ VGND VGND VPWR VPWR _2721_ sky130_fd_sc_hd__a21oi_2
XFILLER_0_45_345 VGND VGND VPWR VPWR sky130_fd_sc_hd__decap_8
X_8423_ _1243_ _1236_ _1241_ _1252_ VGND VGND VPWR VPWR _1253_ sky130_fd_sc_hd__a31o_1
XFILLER_0_116_734 VGND VGND VPWR VPWR sky130_fd_sc_hd__fill_1
XFILLER_0_115_222 VGND VGND VPWR VPWR sky130_fd_sc_hd__fill_2
X_5635_ _2649_ _2650_ _2652_ VGND VGND VPWR VPWR _2653_ sky130_fd_sc_hd__o21ai_2
XFILLER_0_85_3 VPWR VGND VPWR VGND sky130_ef_sc_hd__decap_12
X_8354_ sum5\[12\] s7\[12\] VGND VGND VPWR VPWR _1189_ sky130_fd_sc_hd__nor2_1
X_5566_ _2515_ _2526_ _2571_ VGND VGND VPWR VPWR _2585_ sky130_fd_sc_hd__a21oi_1
Xhold110 bit_sum2\[4\] VGND VGND VPWR VPWR net152 sky130_fd_sc_hd__dlygate4sd3_1
X_4517_ _1553_ _1556_ _1551_ VGND VGND VPWR VPWR _1561_ sky130_fd_sc_hd__a21o_1
Xhold132 final_sum\[15\] VGND VGND VPWR VPWR net174 sky130_fd_sc_hd__dlygate4sd3_1
Xhold121 sh5\[6\] VGND VGND VPWR VPWR net163 sky130_fd_sc_hd__dlygate4sd3_1
X_8285_ _1126_ _1127_ VGND VGND VPWR VPWR _1128_ sky130_fd_sc_hd__or2b_1
X_7305_ _4138_ VGND VGND VPWR VPWR _0324_ sky130_fd_sc_hd__inv_2
X_5497_ _2513_ _2507_ sh6\[0\] VGND VGND VPWR VPWR _2516_ sky130_fd_sc_hd__o21bai_2
Xhold143 sh10\[1\] VGND VGND VPWR VPWR net185 sky130_fd_sc_hd__dlygate4sd3_1
X_4448_ _1488_ _1487_ _1246_ VGND VGND VPWR VPWR _1493_ sky130_fd_sc_hd__o21ai_1
Xhold154 sh12\[5\] VGND VGND VPWR VPWR net196 sky130_fd_sc_hd__dlygate4sd3_1
Xhold176 sh8\[3\] VGND VGND VPWR VPWR net218 sky130_fd_sc_hd__dlygate4sd3_1
Xhold165 s2\[8\] VGND VGND VPWR VPWR net207 sky130_fd_sc_hd__dlygate4sd3_1
X_7236_ _4131_ VGND VGND VPWR VPWR _0262_ sky130_fd_sc_hd__inv_2
Xhold187 sh9\[5\] VGND VGND VPWR VPWR net229 sky130_fd_sc_hd__dlygate4sd3_1
Xhold198 sh11\[5\] VGND VGND VPWR VPWR net240 sky130_fd_sc_hd__dlygate4sd3_1
X_4379_ _1357_ _1364_ _1423_ _1234_ _1424_ VGND VGND VPWR VPWR _1425_ sky130_fd_sc_hd__o221ai_4
X_7167_ _4124_ VGND VGND VPWR VPWR _0200_ sky130_fd_sc_hd__inv_2
X_6118_ _3071_ _3072_ _3116_ _3119_ VGND VGND VPWR VPWR _3125_ sky130_fd_sc_hd__o211ai_4
X_7098_ _4036_ _4040_ _4041_ _4035_ _4046_ VGND VGND VPWR VPWR _4082_ sky130_fd_sc_hd__a32oi_2
XTAP_470 VGND VPWR sky130_fd_sc_hd__tapvpwrvgnd_1
XTAP_481 VGND VPWR sky130_fd_sc_hd__tapvpwrvgnd_1
XTAP_492 VGND VPWR sky130_fd_sc_hd__tapvpwrvgnd_1
X_6049_ _3054_ _3055_ _3056_ VGND VGND VPWR VPWR _3057_ sky130_fd_sc_hd__nand3_2
XFILLER_0_96_713 VGND VGND VPWR VPWR sky130_fd_sc_hd__fill_2
XTAP_1614 VGND VPWR sky130_fd_sc_hd__tapvpwrvgnd_1
XTAP_1603 VGND VPWR sky130_fd_sc_hd__tapvpwrvgnd_1
XFILLER_0_95_223 VGND VGND VPWR VPWR sky130_fd_sc_hd__fill_1
XTAP_1658 VGND VPWR sky130_fd_sc_hd__tapvpwrvgnd_1
XTAP_1636 VGND VPWR sky130_fd_sc_hd__tapvpwrvgnd_1
XTAP_1647 VGND VPWR sky130_fd_sc_hd__tapvpwrvgnd_1
XTAP_1625 VGND VPWR sky130_fd_sc_hd__tapvpwrvgnd_1
XTAP_1669 VGND VPWR sky130_fd_sc_hd__tapvpwrvgnd_1
XFILLER_0_48_161 VGND VGND VPWR VPWR sky130_fd_sc_hd__decap_8
XFILLER_0_49_673 VGND VGND VPWR VPWR sky130_fd_sc_hd__fill_2
XFILLER_0_119_561 VPWR VGND VPWR VGND sky130_ef_sc_hd__decap_12
XFILLER_0_36_323 VGND VGND VPWR VPWR sky130_fd_sc_hd__decap_3
XFILLER_0_36_334 VPWR VGND VPWR VGND sky130_ef_sc_hd__decap_12
XFILLER_0_106_222 VGND VGND VPWR VPWR sky130_fd_sc_hd__fill_1
XFILLER_0_64_687 VPWR VGND VPWR VGND sky130_ef_sc_hd__decap_12
XFILLER_0_91_484 VGND VGND VPWR VPWR sky130_fd_sc_hd__decap_3
XFILLER_0_24_529 VGND VGND VPWR VPWR sky130_fd_sc_hd__decap_3
XFILLER_0_121_225 VGND VGND VPWR VPWR sky130_fd_sc_hd__decap_4
XFILLER_0_51_348 VPWR VGND VPWR VGND sky130_ef_sc_hd__decap_12
XFILLER_0_20_713 VPWR VGND VPWR VGND sky130_ef_sc_hd__decap_12
XFILLER_0_102_461 VPWR VGND VPWR VGND sky130_ef_sc_hd__decap_12
XFILLER_0_115_69 VGND VGND VPWR VPWR sky130_fd_sc_hd__decap_6
XFILLER_0_55_643 VGND VGND VPWR VPWR sky130_fd_sc_hd__fill_2
XFILLER_0_27_345 VGND VGND VPWR VPWR sky130_fd_sc_hd__decap_3
XFILLER_0_55_665 VGND VGND VPWR VPWR sky130_fd_sc_hd__decap_6
XFILLER_0_54_197 VGND VGND VPWR VPWR sky130_fd_sc_hd__decap_8
XFILLER_0_40_77 VGND VGND VPWR VPWR sky130_fd_sc_hd__decap_6
X_5420_ _2440_ _2442_ _2393_ VGND VGND VPWR VPWR _2444_ sky130_fd_sc_hd__nand3_2
XFILLER_0_2_445 VPWR VGND VPWR VGND sky130_ef_sc_hd__decap_12
X_5351_ _2373_ _2375_ sh14\[2\] VGND VGND VPWR VPWR _2376_ sky130_fd_sc_hd__o21bai_4
X_4302_ _1345_ _1258_ _1348_ VGND VGND VPWR VPWR _1350_ sky130_fd_sc_hd__a21o_1
XFILLER_0_2_489 VPWR VGND VPWR VGND sky130_ef_sc_hd__decap_12
X_5282_ _2301_ _2305_ sh15\[2\] _2308_ VGND VGND VPWR VPWR _2309_ sky130_fd_sc_hd__o211ai_4
X_8070_ _0802_ _0787_ _0793_ VGND VGND VPWR VPWR _0918_ sky130_fd_sc_hd__a21boi_1
X_4233_ _1238_ _1223_ VGND VGND VPWR VPWR _1281_ sky130_fd_sc_hd__nand2_1
X_7021_ _3994_ _3999_ _4006_ VGND VGND VPWR VPWR _4007_ sky130_fd_sc_hd__a21o_1
XFILLER_0_49_86 VGND VGND VPWR VPWR sky130_fd_sc_hd__decap_4
XFILLER_0_49_97 VPWR VGND VPWR VGND sky130_ef_sc_hd__decap_12
XFILLER_0_65_30 VGND VGND VPWR VPWR sky130_fd_sc_hd__decap_6
XFILLER_0_4_77 VGND VGND VPWR VPWR sky130_fd_sc_hd__decap_6
X_7923_ sh2\[3\] VGND VGND VPWR VPWR _0772_ sky130_fd_sc_hd__buf_4
XFILLER_0_81_51 VGND VGND VPWR VPWR sky130_fd_sc_hd__decap_4
X_7854_ net277 s6\[9\] _0712_ VGND VGND VPWR VPWR _0049_ sky130_fd_sc_hd__a21o_1
XFILLER_0_92_215 VGND VGND VPWR VPWR sky130_fd_sc_hd__decap_6
XFILLER_0_77_278 VGND VGND VPWR VPWR sky130_fd_sc_hd__fill_2
X_7785_ carry2\[9\] net248 s4\[10\] VGND VGND VPWR VPWR _0678_ sky130_fd_sc_hd__a21o_1
X_6805_ _3777_ _3785_ _3792_ VGND VGND VPWR VPWR _3794_ sky130_fd_sc_hd__nand3_1
X_4997_ _2007_ _1978_ VGND VGND VPWR VPWR _2029_ sky130_fd_sc_hd__nand2_1
X_6736_ _3724_ _3722_ _3723_ VGND VGND VPWR VPWR _3726_ sky130_fd_sc_hd__nor3_1
XFILLER_0_45_120 VPWR VGND VPWR VGND sky130_ef_sc_hd__decap_12
XFILLER_0_46_643 VGND VGND VPWR VPWR sky130_fd_sc_hd__fill_1
XFILLER_0_45_153 VPWR VGND VPWR VGND sky130_ef_sc_hd__decap_12
X_6667_ sh13\[4\] _3451_ _3611_ VGND VGND VPWR VPWR _3661_ sky130_fd_sc_hd__a21o_1
XFILLER_0_18_389 VPWR VGND VPWR VGND sky130_ef_sc_hd__decap_12
XFILLER_0_33_337 VGND VGND VPWR VPWR sky130_fd_sc_hd__decap_8
X_8406_ _1232_ _1234_ _1235_ VGND VGND VPWR VPWR _1236_ sky130_fd_sc_hd__o21bai_1
XFILLER_0_116_586 VGND VGND VPWR VPWR sky130_fd_sc_hd__fill_2
X_6598_ _3538_ sh15\[4\] _3535_ VGND VGND VPWR VPWR _3594_ sky130_fd_sc_hd__a21oi_2
X_5618_ _2632_ _2633_ _2635_ VGND VGND VPWR VPWR _2636_ sky130_fd_sc_hd__nand3_4
XFILLER_0_33_348 VGND VGND VPWR VPWR sky130_fd_sc_hd__decap_4
XFILLER_0_103_225 VGND VGND VPWR VPWR sky130_fd_sc_hd__decap_4
X_8337_ _1170_ _1171_ _1173_ VGND VGND VPWR VPWR _1174_ sky130_fd_sc_hd__and3_1
X_5549_ _2477_ _2506_ _2553_ VGND VGND VPWR VPWR _2568_ sky130_fd_sc_hd__a21oi_2
X_8268_ _1078_ _1073_ _1105_ _1108_ _1111_ VGND VGND VPWR VPWR _1112_ sky130_fd_sc_hd__o2111ai_4
X_7219_ _4129_ VGND VGND VPWR VPWR _0247_ sky130_fd_sc_hd__inv_2
X_8199_ _1043_ _1044_ VGND VGND VPWR VPWR _1045_ sky130_fd_sc_hd__nand2_1
XFILLER_0_69_724 VGND VGND VPWR VPWR sky130_fd_sc_hd__decap_4
XTAP_1433 VGND VPWR sky130_fd_sc_hd__tapvpwrvgnd_1
XTAP_1422 VGND VPWR sky130_fd_sc_hd__tapvpwrvgnd_1
XTAP_1411 VGND VPWR sky130_fd_sc_hd__tapvpwrvgnd_1
XTAP_1400 VGND VPWR sky130_fd_sc_hd__tapvpwrvgnd_1
XTAP_1466 VGND VPWR sky130_fd_sc_hd__tapvpwrvgnd_1
XTAP_1455 VGND VPWR sky130_fd_sc_hd__tapvpwrvgnd_1
XTAP_1444 VGND VPWR sky130_fd_sc_hd__tapvpwrvgnd_1
XTAP_1499 VGND VPWR sky130_fd_sc_hd__tapvpwrvgnd_1
XTAP_1488 VGND VPWR sky130_fd_sc_hd__tapvpwrvgnd_1
XTAP_1477 VGND VPWR sky130_fd_sc_hd__tapvpwrvgnd_1
XFILLER_0_49_481 VPWR VGND VPWR VGND sky130_ef_sc_hd__decap_12
XFILLER_0_36_153 VGND VGND VPWR VPWR sky130_fd_sc_hd__fill_2
XFILLER_0_119_391 VGND VGND VPWR VPWR sky130_fd_sc_hd__fill_1
XFILLER_0_91_281 VGND VGND VPWR VPWR sky130_fd_sc_hd__fill_2
XFILLER_0_122_589 VGND VGND VPWR VPWR sky130_fd_sc_hd__fill_2
XFILLER_0_86_29 VPWR VGND VPWR VGND sky130_ef_sc_hd__decap_12
XFILLER_0_20_576 VPWR VGND VPWR VGND sky130_ef_sc_hd__decap_12
XFILLER_0_19_78 VPWR VGND VPWR VGND sky130_ef_sc_hd__decap_12
XFILLER_0_87_521 VGND VGND VPWR VPWR sky130_fd_sc_hd__decap_3
XFILLER_0_35_55 VGND VGND VPWR VPWR sky130_fd_sc_hd__fill_1
X_4920_ sh4\[7\] _1668_ VGND VGND VPWR VPWR _1954_ sky130_fd_sc_hd__nor2_2
XFILLER_0_59_223 VGND VGND VPWR VPWR sky130_fd_sc_hd__fill_1
X_4851_ _1867_ _1882_ _1885_ _1886_ VGND VGND VPWR VPWR _1887_ sky130_fd_sc_hd__o2bb2ai_2
XFILLER_0_87_598 VGND VGND VPWR VPWR sky130_fd_sc_hd__decap_8
XFILLER_0_87_587 VGND VGND VPWR VPWR sky130_fd_sc_hd__decap_8
XFILLER_0_59_267 VPWR VGND VPWR VGND sky130_ef_sc_hd__decap_12
XFILLER_0_117_317 VGND VGND VPWR VPWR sky130_fd_sc_hd__fill_1
XFILLER_0_74_237 VGND VGND VPWR VPWR sky130_fd_sc_hd__decap_4
X_4782_ _1677_ _1725_ _1808_ _1721_ _1818_ VGND VGND VPWR VPWR _1819_ sky130_fd_sc_hd__o2111ai_2
X_7570_ _4164_ VGND VGND VPWR VPWR _0563_ sky130_fd_sc_hd__inv_2
XFILLER_0_51_65 VPWR VGND VPWR VGND sky130_ef_sc_hd__decap_12
X_6521_ _3433_ _3487_ _3499_ _3502_ VGND VGND VPWR VPWR _3518_ sky130_fd_sc_hd__o211ai_2
XFILLER_0_70_410 VGND VGND VPWR VPWR sky130_fd_sc_hd__decap_8
X_6452_ _3448_ _3445_ _3446_ _3449_ VGND VGND VPWR VPWR _3450_ sky130_fd_sc_hd__o211a_2
XFILLER_0_3_721 VGND VGND VPWR VPWR sky130_fd_sc_hd__decap_6
XFILLER_0_15_337 VGND VGND VPWR VPWR sky130_fd_sc_hd__decap_6
XFILLER_0_15_348 VGND VGND VPWR VPWR sky130_fd_sc_hd__decap_3
XFILLER_0_42_123 VPWR VGND VPWR VGND sky130_ef_sc_hd__decap_12
X_5403_ _2106_ _2189_ _2374_ VGND VGND VPWR VPWR _2427_ sky130_fd_sc_hd__a21oi_1
XFILLER_0_101_729 VGND VGND VPWR VPWR sky130_fd_sc_hd__decap_6
X_6383_ _3379_ _3380_ _3381_ VGND VGND VPWR VPWR _3382_ sky130_fd_sc_hd__nand3_2
X_8122_ _0959_ _0954_ _0960_ VGND VGND VPWR VPWR _0969_ sky130_fd_sc_hd__o21ai_4
XFILLER_0_2_253 VPWR VGND VPWR VGND sky130_ef_sc_hd__decap_12
XFILLER_0_11_565 VPWR VGND VPWR VGND sky130_ef_sc_hd__decap_12
X_5334_ _2282_ VGND VGND VPWR VPWR _2360_ sky130_fd_sc_hd__inv_2
X_5265_ _2286_ _2288_ _2291_ VGND VGND VPWR VPWR _2292_ sky130_fd_sc_hd__nand3_4
X_8053_ _0886_ _0887_ _0830_ _0889_ VGND VGND VPWR VPWR _0901_ sky130_fd_sc_hd__o211a_1
X_7004_ _3982_ _3985_ _3989_ VGND VGND VPWR VPWR _3990_ sky130_fd_sc_hd__nand3_2
X_5196_ _2137_ _2150_ _2145_ _2215_ _2221_ VGND VGND VPWR VPWR _2224_ sky130_fd_sc_hd__o2111ai_4
XFILLER_0_48_3 VPWR VGND VPWR VGND sky130_ef_sc_hd__decap_12
XFILLER_0_92_50 VPWR VGND VPWR VGND sky130_ef_sc_hd__decap_12
X_7906_ _0741_ _0745_ _0754_ VGND VGND VPWR VPWR _0756_ sky130_fd_sc_hd__nand3_1
X_7837_ sum3\[10\] carry3\[9\] net342 VGND VGND VPWR VPWR _0704_ sky130_fd_sc_hd__a21o_1
XFILLER_0_108_328 VGND VGND VPWR VPWR sky130_fd_sc_hd__decap_8
X_7768_ carry4\[13\] sum4\[14\] VGND VGND VPWR VPWR _0668_ sky130_fd_sc_hd__and2_1
XFILLER_0_123_309 VPWR VGND VPWR VGND sky130_ef_sc_hd__decap_12
XFILLER_0_73_281 VGND VGND VPWR VPWR sky130_fd_sc_hd__decap_3
X_6719_ sh1\[1\] sh0\[1\] VGND VGND VPWR VPWR _3709_ sky130_fd_sc_hd__nor2_2
XFILLER_0_18_186 VGND VGND VPWR VPWR sky130_fd_sc_hd__decap_8
XFILLER_0_46_473 VGND VGND VPWR VPWR sky130_fd_sc_hd__decap_3
X_7699_ net273 sum1\[8\] _4213_ VGND VGND VPWR VPWR _0018_ sky130_fd_sc_hd__o21a_1
XFILLER_0_6_570 VPWR VGND VPWR VGND sky130_ef_sc_hd__decap_12
XFILLER_0_34_668 VPWR VGND VPWR VGND sky130_ef_sc_hd__decap_12
XFILLER_0_104_556 VPWR VGND VPWR VGND sky130_ef_sc_hd__decap_12
XFILLER_0_104_589 VGND VGND VPWR VPWR sky130_fd_sc_hd__fill_1
XFILLER_0_14_392 VGND VGND VPWR VPWR sky130_fd_sc_hd__fill_1
XFILLER_0_88_307 VGND VGND VPWR VPWR sky130_fd_sc_hd__fill_1
XFILLER_0_84_502 VGND VGND VPWR VPWR sky130_fd_sc_hd__fill_2
XTAP_1241 VGND VPWR sky130_fd_sc_hd__tapvpwrvgnd_1
XTAP_1230 VGND VPWR sky130_fd_sc_hd__tapvpwrvgnd_1
XFILLER_0_84_524 VGND VGND VPWR VPWR sky130_fd_sc_hd__decap_8
XTAP_1274 VGND VPWR sky130_fd_sc_hd__tapvpwrvgnd_1
XTAP_1263 VGND VPWR sky130_fd_sc_hd__tapvpwrvgnd_1
XTAP_1252 VGND VPWR sky130_fd_sc_hd__tapvpwrvgnd_1
XFILLER_0_112_15 VPWR VGND VPWR VGND sky130_ef_sc_hd__decap_12
XTAP_1296 VGND VPWR sky130_fd_sc_hd__tapvpwrvgnd_1
XTAP_1285 VGND VPWR sky130_fd_sc_hd__tapvpwrvgnd_1
XFILLER_0_56_259 VPWR VGND VPWR VGND sky130_ef_sc_hd__decap_12
XFILLER_0_52_421 VPWR VGND VPWR VGND sky130_ef_sc_hd__decap_12
XFILLER_0_114_309 VPWR VGND VPWR VGND sky130_ef_sc_hd__decap_12
XFILLER_0_107_350 VPWR VGND VPWR VGND sky130_ef_sc_hd__decap_12
XFILLER_0_4_518 VGND VGND VPWR VPWR sky130_fd_sc_hd__decap_4
XFILLER_0_24_156 VGND VGND VPWR VPWR sky130_fd_sc_hd__decap_4
XFILLER_0_122_375 VGND VGND VPWR VPWR sky130_fd_sc_hd__fill_2
XFILLER_0_0_713 VPWR VGND VPWR VGND sky130_ef_sc_hd__decap_12
XFILLER_0_20_384 VGND VGND VPWR VPWR sky130_fd_sc_hd__fill_1
X_5050_ _2046_ _2050_ _2077_ _2079_ VGND VGND VPWR VPWR _2080_ sky130_fd_sc_hd__a22oi_2
X_5952_ _2958_ _2960_ _2922_ VGND VGND VPWR VPWR _2961_ sky130_fd_sc_hd__o21bai_4
X_8740_ clknet_leaf_22_clk _0181_ _0491_ VGND VGND VPWR VPWR bit_sum7\[1\] sky130_fd_sc_hd__dfrtp_1
XFILLER_0_62_20 VGND VGND VPWR VPWR sky130_fd_sc_hd__decap_8
X_4903_ _1935_ _1936_ _1937_ VGND VGND VPWR VPWR _1938_ sky130_fd_sc_hd__a21oi_1
XFILLER_0_75_502 VGND VGND VPWR VPWR sky130_fd_sc_hd__fill_2
XFILLER_0_62_53 VGND VGND VPWR VPWR sky130_fd_sc_hd__decap_8
X_5883_ sh7\[6\] VGND VGND VPWR VPWR _2893_ sky130_fd_sc_hd__buf_4
X_8671_ clknet_leaf_36_clk _0173_ _0422_ VGND VGND VPWR VPWR bit_sum0\[2\] sky130_fd_sc_hd__dfrtp_1
X_4834_ _1783_ _1787_ VGND VGND VPWR VPWR _1870_ sky130_fd_sc_hd__nand2_2
X_7622_ _4169_ VGND VGND VPWR VPWR _0610_ sky130_fd_sc_hd__inv_2
XFILLER_0_7_301 VGND VGND VPWR VPWR sky130_fd_sc_hd__fill_1
XFILLER_0_117_158 VGND VGND VPWR VPWR sky130_fd_sc_hd__decap_8
X_4765_ _1789_ _1790_ _1801_ VGND VGND VPWR VPWR _1802_ sky130_fd_sc_hd__o21ai_1
X_7553_ _4162_ VGND VGND VPWR VPWR _0548_ sky130_fd_sc_hd__inv_2
X_6504_ _3338_ _3339_ _3451_ VGND VGND VPWR VPWR _3501_ sky130_fd_sc_hd__and3_1
XFILLER_0_55_281 VGND VGND VPWR VPWR sky130_fd_sc_hd__decap_4
XFILLER_0_7_367 VGND VGND VPWR VPWR sky130_fd_sc_hd__fill_1
X_4696_ _1724_ _1726_ _1730_ _1733_ VGND VGND VPWR VPWR _1734_ sky130_fd_sc_hd__o22ai_4
XFILLER_0_102_81 VGND VGND VPWR VPWR sky130_fd_sc_hd__decap_3
X_7484_ _4155_ VGND VGND VPWR VPWR _0486_ sky130_fd_sc_hd__inv_2
XFILLER_0_31_627 VPWR VGND VPWR VGND sky130_ef_sc_hd__decap_12
X_6435_ _3432_ _3426_ _3368_ _3427_ VGND VGND VPWR VPWR _3433_ sky130_fd_sc_hd__o211a_2
XFILLER_0_3_573 VPWR VGND VPWR VGND sky130_ef_sc_hd__decap_12
XFILLER_0_113_375 VPWR VGND VPWR VGND sky130_ef_sc_hd__decap_12
X_6366_ _3297_ _3298_ VGND VGND VPWR VPWR _3365_ sky130_fd_sc_hd__nor2_1
XFILLER_0_101_559 VGND VGND VPWR VPWR sky130_fd_sc_hd__fill_1
X_8105_ _0725_ _0721_ _0863_ _0951_ _0727_ VGND VGND VPWR VPWR _0952_ sky130_fd_sc_hd__o221a_1
X_5317_ _2072_ _2104_ _2189_ VGND VGND VPWR VPWR _2343_ sky130_fd_sc_hd__o21ai_1
X_6297_ _3296_ VGND VGND VPWR VPWR _3297_ sky130_fd_sc_hd__clkbuf_4
Xhold14 bit_sum4\[6\] VGND VGND VPWR VPWR net56 sky130_fd_sc_hd__dlygate4sd3_1
X_8036_ _0876_ _0882_ _0883_ VGND VGND VPWR VPWR _0884_ sky130_fd_sc_hd__a21o_1
X_5248_ _2272_ _2274_ _2271_ VGND VGND VPWR VPWR _2275_ sky130_fd_sc_hd__nor3b_1
Xhold47 bit_sum1\[1\] VGND VGND VPWR VPWR net89 sky130_fd_sc_hd__dlygate4sd3_1
Xhold36 bit_sum0\[4\] VGND VGND VPWR VPWR net78 sky130_fd_sc_hd__dlygate4sd3_1
Xhold25 bit_sum2\[8\] VGND VGND VPWR VPWR net67 sky130_fd_sc_hd__dlygate4sd3_1
X_5179_ _2052_ _2037_ VGND VGND VPWR VPWR _2207_ sky130_fd_sc_hd__and2_1
Xhold58 bit_sum0\[2\] VGND VGND VPWR VPWR net100 sky130_fd_sc_hd__dlygate4sd3_1
Xhold69 bit_sum2\[9\] VGND VGND VPWR VPWR net111 sky130_fd_sc_hd__dlygate4sd3_1
XFILLER_0_98_627 VGND VGND VPWR VPWR sky130_fd_sc_hd__fill_1
XFILLER_0_93_321 VGND VGND VPWR VPWR sky130_fd_sc_hd__decap_8
X_8869_ clknet_leaf_57_clk net339 _0620_ VGND VGND VPWR VPWR sh15\[1\] sky130_fd_sc_hd__dfrtp_4
XFILLER_0_81_505 VGND VGND VPWR VPWR sky130_fd_sc_hd__fill_1
XFILLER_0_108_147 VPWR VGND VPWR VGND sky130_ef_sc_hd__decap_12
XFILLER_0_61_251 VGND VGND VPWR VPWR sky130_fd_sc_hd__fill_1
XFILLER_0_61_295 VGND VGND VPWR VPWR sky130_fd_sc_hd__fill_1
XFILLER_0_107_15 VGND VGND VPWR VPWR sky130_fd_sc_hd__decap_4
XFILLER_0_84_321 VGND VGND VPWR VPWR sky130_fd_sc_hd__fill_1
XFILLER_0_8_109 VPWR VGND VPWR VGND sky130_ef_sc_hd__decap_12
XFILLER_0_123_69 VPWR VGND VPWR VGND sky130_ef_sc_hd__decap_12
XFILLER_0_84_365 VGND VGND VPWR VPWR sky130_fd_sc_hd__decap_8
XFILLER_0_84_343 VGND VGND VPWR VPWR sky130_fd_sc_hd__fill_1
XTAP_1082 VGND VPWR sky130_fd_sc_hd__tapvpwrvgnd_1
XTAP_1071 VGND VPWR sky130_fd_sc_hd__tapvpwrvgnd_1
XTAP_1060 VGND VPWR sky130_fd_sc_hd__tapvpwrvgnd_1
XTAP_1093 VGND VPWR sky130_fd_sc_hd__tapvpwrvgnd_1
XFILLER_0_32_67 VGND VGND VPWR VPWR sky130_fd_sc_hd__fill_1
XFILLER_0_32_89 VGND VGND VPWR VPWR sky130_fd_sc_hd__fill_1
XFILLER_0_4_304 VGND VGND VPWR VPWR sky130_fd_sc_hd__decap_4
XFILLER_0_37_292 VGND VGND VPWR VPWR sky130_fd_sc_hd__fill_2
XFILLER_0_114_128 VPWR VGND VPWR VGND sky130_ef_sc_hd__decap_12
XFILLER_0_106_3 VPWR VGND VPWR VGND sky130_ef_sc_hd__decap_12
X_4550_ _1584_ VGND VGND VPWR VPWR _1593_ sky130_fd_sc_hd__inv_2
XFILLER_0_80_560 VGND VGND VPWR VPWR sky130_fd_sc_hd__fill_1
XFILLER_0_52_251 VGND VGND VPWR VPWR sky130_fd_sc_hd__fill_1
XFILLER_0_123_673 VPWR VGND VPWR VGND sky130_ef_sc_hd__decap_12
X_4481_ _1504_ _1524_ _1525_ VGND VGND VPWR VPWR _1526_ sky130_fd_sc_hd__o21ai_1
X_6220_ _3170_ _3163_ _3216_ _3220_ VGND VGND VPWR VPWR _3225_ sky130_fd_sc_hd__o211a_1
X_6151_ _3156_ _3153_ VGND VGND VPWR VPWR _3157_ sky130_fd_sc_hd__nand2_2
XFILLER_0_110_345 VPWR VGND VPWR VGND sky130_ef_sc_hd__decap_12
XFILLER_0_21_671 VGND VGND VPWR VPWR sky130_fd_sc_hd__fill_1
XTAP_800 VGND VPWR sky130_fd_sc_hd__tapvpwrvgnd_1
X_5102_ _2044_ _2049_ _2038_ VGND VGND VPWR VPWR _2131_ sky130_fd_sc_hd__and3_1
XTAP_811 VGND VPWR sky130_fd_sc_hd__tapvpwrvgnd_1
XTAP_822 VGND VPWR sky130_fd_sc_hd__tapvpwrvgnd_1
XTAP_833 VGND VPWR sky130_fd_sc_hd__tapvpwrvgnd_1
XTAP_844 VGND VPWR sky130_fd_sc_hd__tapvpwrvgnd_1
X_6082_ _3088_ _3082_ _3079_ VGND VGND VPWR VPWR _3089_ sky130_fd_sc_hd__nand3_1
XTAP_855 VGND VPWR sky130_fd_sc_hd__tapvpwrvgnd_1
XTAP_877 VGND VPWR sky130_fd_sc_hd__tapvpwrvgnd_1
XTAP_866 VGND VPWR sky130_fd_sc_hd__tapvpwrvgnd_1
X_5033_ sh4\[2\] VGND VGND VPWR VPWR _2063_ sky130_fd_sc_hd__inv_2
XTAP_888 VGND VPWR sky130_fd_sc_hd__tapvpwrvgnd_1
XTAP_899 VGND VPWR sky130_fd_sc_hd__tapvpwrvgnd_1
XFILLER_0_79_137 VPWR VGND VPWR VGND sky130_ef_sc_hd__decap_12
XFILLER_0_73_63 VGND VGND VPWR VPWR sky130_fd_sc_hd__fill_1
XFILLER_0_73_96 VGND VGND VPWR VPWR sky130_fd_sc_hd__decap_6
X_6984_ _3967_ _3969_ sh6\[1\] VGND VGND VPWR VPWR _3970_ sky130_fd_sc_hd__o21bai_1
X_5935_ _2935_ VGND VGND VPWR VPWR _2944_ sky130_fd_sc_hd__inv_2
X_8723_ clknet_leaf_14_clk _0130_ _0474_ VGND VGND VPWR VPWR bit_sum5\[4\] sky130_fd_sc_hd__dfrtp_1
X_5866_ _2871_ _2874_ _2875_ VGND VGND VPWR VPWR _2876_ sky130_fd_sc_hd__and3_1
XFILLER_0_87_192 VGND VGND VPWR VPWR sky130_fd_sc_hd__decap_8
X_8654_ clknet_leaf_29_clk net138 _0405_ VGND VGND VPWR VPWR s6\[10\] sky130_fd_sc_hd__dfrtp_1
XFILLER_0_75_365 VGND VGND VPWR VPWR sky130_fd_sc_hd__decap_4
XFILLER_0_75_354 VGND VGND VPWR VPWR sky130_fd_sc_hd__fill_2
XFILLER_0_48_579 VGND VGND VPWR VPWR sky130_fd_sc_hd__fill_1
XFILLER_0_118_456 VGND VGND VPWR VPWR sky130_fd_sc_hd__fill_2
X_4817_ _1677_ _1838_ _1839_ VGND VGND VPWR VPWR _1853_ sky130_fd_sc_hd__o21ai_1
XFILLER_0_75_387 VGND VGND VPWR VPWR sky130_fd_sc_hd__decap_4
XFILLER_0_8_643 VGND VGND VPWR VPWR sky130_fd_sc_hd__fill_1
X_7605_ _4167_ VGND VGND VPWR VPWR _0595_ sky130_fd_sc_hd__inv_2
X_5797_ _2798_ _2801_ _2749_ VGND VGND VPWR VPWR _2812_ sky130_fd_sc_hd__o21ai_2
X_8585_ clknet_leaf_54_clk net384 _0336_ VGND VGND VPWR VPWR carry1\[8\] sky130_fd_sc_hd__dfrtp_1
X_4748_ _1776_ _1778_ _1779_ VGND VGND VPWR VPWR _1785_ sky130_fd_sc_hd__a21o_1
X_7536_ _4161_ VGND VGND VPWR VPWR _0532_ sky130_fd_sc_hd__inv_2
XFILLER_0_120_109 VPWR VGND VPWR VGND sky130_ef_sc_hd__decap_12
XFILLER_0_114_640 VGND VGND VPWR VPWR sky130_fd_sc_hd__decap_4
X_4679_ _1699_ _1711_ _1715_ _1716_ VGND VGND VPWR VPWR _1717_ sky130_fd_sc_hd__o2bb2ai_4
X_7467_ _4154_ VGND VGND VPWR VPWR _0470_ sky130_fd_sc_hd__inv_2
XFILLER_0_31_413 VGND VGND VPWR VPWR sky130_fd_sc_hd__decap_8
Xoutput15 net15 VGND VGND VPWR VPWR led[14] sky130_fd_sc_hd__clkbuf_4
XFILLER_0_114_695 VGND VGND VPWR VPWR sky130_fd_sc_hd__decap_4
XFILLER_0_98_82 VGND VGND VPWR VPWR sky130_fd_sc_hd__fill_2
X_6418_ _3416_ VGND VGND VPWR VPWR _0119_ sky130_fd_sc_hd__clkbuf_1
X_7398_ _4121_ VGND VGND VPWR VPWR _4147_ sky130_fd_sc_hd__clkbuf_8
XFILLER_0_12_660 VPWR VGND VPWR VGND sky130_ef_sc_hd__decap_12
X_6349_ _3330_ _3332_ _3341_ _3347_ VGND VGND VPWR VPWR _3348_ sky130_fd_sc_hd__o211a_1
X_8019_ _0730_ _0772_ VGND VGND VPWR VPWR _0867_ sky130_fd_sc_hd__and2_1
XFILLER_0_98_457 VPWR VGND VPWR VGND sky130_ef_sc_hd__decap_12
XFILLER_0_79_660 VPWR VGND VPWR VGND sky130_ef_sc_hd__decap_12
XFILLER_0_79_693 VGND VGND VPWR VPWR sky130_fd_sc_hd__decap_4
XFILLER_0_66_321 VGND VGND VPWR VPWR sky130_fd_sc_hd__decap_6
XFILLER_0_109_401 VGND VGND VPWR VPWR sky130_fd_sc_hd__decap_8
XPHY_143 VGND VGND VPWR VPWR sky130_fd_sc_hd__decap_3
XPHY_132 VGND VGND VPWR VPWR sky130_fd_sc_hd__decap_3
XPHY_121 VGND VGND VPWR VPWR sky130_fd_sc_hd__decap_3
XPHY_110 VGND VGND VPWR VPWR sky130_fd_sc_hd__decap_3
XFILLER_0_39_546 VGND VGND VPWR VPWR sky130_fd_sc_hd__fill_1
XFILLER_0_109_456 VPWR VGND VPWR VGND sky130_ef_sc_hd__decap_12
XFILLER_0_94_674 VGND VGND VPWR VPWR sky130_fd_sc_hd__decap_6
XFILLER_0_93_162 VGND VGND VPWR VPWR sky130_fd_sc_hd__decap_6
XPHY_176 VGND VGND VPWR VPWR sky130_fd_sc_hd__decap_3
XPHY_165 VGND VGND VPWR VPWR sky130_fd_sc_hd__decap_3
XPHY_154 VGND VGND VPWR VPWR sky130_fd_sc_hd__decap_3
XFILLER_0_66_387 VGND VGND VPWR VPWR sky130_fd_sc_hd__fill_2
Xclkbuf_leaf_51_clk clknet_3_4__leaf_clk VGND VGND VPWR VPWR clknet_leaf_51_clk sky130_fd_sc_hd__clkbuf_16
XPHY_198 VGND VGND VPWR VPWR sky130_fd_sc_hd__decap_3
XPHY_187 VGND VGND VPWR VPWR sky130_fd_sc_hd__decap_3
XFILLER_0_81_368 VPWR VGND VPWR VGND sky130_ef_sc_hd__decap_12
XFILLER_0_105_673 VPWR VGND VPWR VGND sky130_ef_sc_hd__decap_12
XFILLER_0_104_194 VGND VGND VPWR VPWR sky130_fd_sc_hd__fill_2
XFILLER_0_10_619 VGND VGND VPWR VPWR sky130_fd_sc_hd__fill_1
XFILLER_0_94_29 VGND VGND VPWR VPWR sky130_fd_sc_hd__decap_4
XFILLER_0_89_457 VGND VGND VPWR VPWR sky130_fd_sc_hd__fill_2
XPHY_1 VGND VGND VPWR VPWR sky130_fd_sc_hd__decap_3
XFILLER_0_43_55 VGND VGND VPWR VPWR sky130_fd_sc_hd__fill_1
XFILLER_0_9_429 VGND VGND VPWR VPWR sky130_fd_sc_hd__fill_1
X_5720_ _2735_ _2731_ VGND VGND VPWR VPWR _2736_ sky130_fd_sc_hd__nand2_2
XFILLER_0_85_685 VPWR VGND VPWR VGND sky130_ef_sc_hd__decap_12
Xclkbuf_leaf_42_clk clknet_3_5__leaf_clk VGND VGND VPWR VPWR clknet_leaf_42_clk sky130_fd_sc_hd__clkbuf_16
XFILLER_0_45_505 VGND VGND VPWR VPWR sky130_fd_sc_hd__fill_2
X_5651_ _2469_ _2467_ _2468_ _2618_ _2667_ VGND VGND VPWR VPWR _2668_ sky130_fd_sc_hd__o32a_2
X_4602_ sh5\[7\] VGND VGND VPWR VPWR _1641_ sky130_fd_sc_hd__clkbuf_4
X_8370_ _1202_ _1203_ VGND VGND VPWR VPWR _1204_ sky130_fd_sc_hd__nor2_1
X_5582_ _2544_ _2546_ _2598_ _2600_ VGND VGND VPWR VPWR _2601_ sky130_fd_sc_hd__a22oi_4
X_4533_ _1567_ _1570_ _1572_ VGND VGND VPWR VPWR _1577_ sky130_fd_sc_hd__a21o_1
X_7321_ _4136_ VGND VGND VPWR VPWR _4140_ sky130_fd_sc_hd__buf_4
Xhold303 s5\[5\] VGND VGND VPWR VPWR net345 sky130_fd_sc_hd__dlygate4sd3_1
XFILLER_0_4_189 VGND VGND VPWR VPWR sky130_fd_sc_hd__decap_6
XFILLER_0_13_446 VGND VGND VPWR VPWR sky130_fd_sc_hd__fill_2
Xhold314 sh8\[0\] VGND VGND VPWR VPWR net356 sky130_fd_sc_hd__dlygate4sd3_1
XFILLER_0_40_243 VGND VGND VPWR VPWR sky130_fd_sc_hd__fill_1
Xhold325 s0\[6\] VGND VGND VPWR VPWR net367 sky130_fd_sc_hd__dlygate4sd3_1
X_7252_ _4132_ VGND VGND VPWR VPWR _0277_ sky130_fd_sc_hd__inv_2
X_6203_ _3203_ _3201_ _3204_ VGND VGND VPWR VPWR _3208_ sky130_fd_sc_hd__a21oi_1
XFILLER_0_111_643 VPWR VGND VPWR VGND sky130_ef_sc_hd__decap_12
X_4464_ _1507_ _1508_ VGND VGND VPWR VPWR _1509_ sky130_fd_sc_hd__nor2_1
Xhold358 carry4\[7\] VGND VGND VPWR VPWR net400 sky130_fd_sc_hd__dlygate4sd3_1
XFILLER_0_7_55 VGND VGND VPWR VPWR sky130_fd_sc_hd__fill_1
Xhold369 sh6\[1\] VGND VGND VPWR VPWR net411 sky130_fd_sc_hd__dlygate4sd3_1
Xhold347 s1\[5\] VGND VGND VPWR VPWR net389 sky130_fd_sc_hd__dlygate4sd3_1
Xhold336 _0009_ VGND VGND VPWR VPWR net378 sky130_fd_sc_hd__dlygate4sd3_1
X_4395_ _1225_ _1228_ _1226_ VGND VGND VPWR VPWR _1441_ sky130_fd_sc_hd__o21ai_2
X_7183_ _4126_ VGND VGND VPWR VPWR _0214_ sky130_fd_sc_hd__inv_2
XFILLER_0_68_85 VGND VGND VPWR VPWR sky130_fd_sc_hd__decap_8
XFILLER_0_0_362 VGND VGND VPWR VPWR sky130_fd_sc_hd__fill_2
XFILLER_0_0_373 VGND VGND VPWR VPWR sky130_fd_sc_hd__fill_1
X_6134_ _2889_ _2936_ VGND VGND VPWR VPWR _3140_ sky130_fd_sc_hd__nor2_1
XTAP_630 VGND VPWR sky130_fd_sc_hd__tapvpwrvgnd_1
XTAP_641 VGND VPWR sky130_fd_sc_hd__tapvpwrvgnd_1
XTAP_652 VGND VPWR sky130_fd_sc_hd__tapvpwrvgnd_1
X_6065_ _3054_ _3055_ _3056_ _3058_ VGND VGND VPWR VPWR _3072_ sky130_fd_sc_hd__a31oi_4
XTAP_663 VGND VPWR sky130_fd_sc_hd__tapvpwrvgnd_1
XTAP_674 VGND VPWR sky130_fd_sc_hd__tapvpwrvgnd_1
XTAP_685 VGND VPWR sky130_fd_sc_hd__tapvpwrvgnd_1
X_5016_ _2038_ _2045_ VGND VGND VPWR VPWR _2046_ sky130_fd_sc_hd__nand2_1
XFILLER_0_30_3 VPWR VGND VPWR VGND sky130_ef_sc_hd__decap_12
XTAP_696 VGND VPWR sky130_fd_sc_hd__tapvpwrvgnd_1
XTAP_1807 VGND VPWR sky130_fd_sc_hd__tapvpwrvgnd_1
XTAP_1829 VGND VPWR sky130_fd_sc_hd__tapvpwrvgnd_1
XTAP_1818 VGND VPWR sky130_fd_sc_hd__tapvpwrvgnd_1
XFILLER_0_95_427 VPWR VGND VPWR VGND sky130_ef_sc_hd__decap_12
X_6967_ _3898_ _3891_ _3949_ _3951_ VGND VGND VPWR VPWR _3954_ sky130_fd_sc_hd__o211ai_4
XFILLER_0_119_721 VGND VGND VPWR VPWR sky130_fd_sc_hd__decap_4
X_5918_ sh7\[6\] sh8\[6\] VGND VGND VPWR VPWR _2927_ sky130_fd_sc_hd__nor2_1
X_8706_ clknet_leaf_0_clk _0115_ _0457_ VGND VGND VPWR VPWR bit_sum3\[7\] sky130_fd_sc_hd__dfrtp_1
Xclkbuf_leaf_33_clk clknet_3_4__leaf_clk VGND VGND VPWR VPWR clknet_leaf_33_clk sky130_fd_sc_hd__clkbuf_16
XFILLER_0_8_440 VGND VGND VPWR VPWR sky130_fd_sc_hd__fill_1
X_6898_ _3877_ _3749_ VGND VGND VPWR VPWR _3886_ sky130_fd_sc_hd__nand2_1
XFILLER_0_90_110 VGND VGND VPWR VPWR sky130_fd_sc_hd__decap_8
X_8637_ clknet_leaf_31_clk net58 _0388_ VGND VGND VPWR VPWR s4\[11\] sky130_fd_sc_hd__dfrtp_1
X_5849_ _2861_ _2771_ _2847_ VGND VGND VPWR VPWR _2862_ sky130_fd_sc_hd__nand3_1
XFILLER_0_118_275 VGND VGND VPWR VPWR sky130_fd_sc_hd__decap_8
X_8568_ clknet_leaf_37_clk net285 _0319_ VGND VGND VPWR VPWR sum2\[3\] sky130_fd_sc_hd__dfrtp_1
X_7519_ _4159_ VGND VGND VPWR VPWR _0517_ sky130_fd_sc_hd__inv_2
XFILLER_0_31_210 VPWR VGND VPWR VGND sky130_ef_sc_hd__decap_12
XFILLER_0_32_733 VGND VGND VPWR VPWR sky130_fd_sc_hd__fill_2
X_8499_ clknet_leaf_40_clk net82 _0250_ VGND VGND VPWR VPWR final_sum\[5\] sky130_fd_sc_hd__dfrtp_1
XFILLER_0_31_254 VGND VGND VPWR VPWR sky130_fd_sc_hd__decap_8
XFILLER_0_98_298 VGND VGND VPWR VPWR sky130_fd_sc_hd__decap_8
XFILLER_0_98_276 VPWR VGND VPWR VGND sky130_ef_sc_hd__decap_12
XFILLER_0_86_438 VGND VGND VPWR VPWR sky130_fd_sc_hd__decap_8
XFILLER_0_104_27 VGND VGND VPWR VPWR sky130_fd_sc_hd__fill_1
Xclkbuf_leaf_24_clk clknet_3_7__leaf_clk VGND VGND VPWR VPWR clknet_leaf_24_clk sky130_fd_sc_hd__clkbuf_16
XFILLER_0_82_622 VGND VGND VPWR VPWR sky130_fd_sc_hd__decap_8
XFILLER_0_66_173 VPWR VGND VPWR VGND sky130_ef_sc_hd__decap_12
XFILLER_0_120_15 VPWR VGND VPWR VGND sky130_ef_sc_hd__decap_12
XFILLER_0_112_407 VPWR VGND VPWR VGND sky130_ef_sc_hd__decap_12
XFILLER_0_10_427 VGND VGND VPWR VPWR sky130_fd_sc_hd__fill_1
XFILLER_0_1_137 VPWR VGND VPWR VGND sky130_ef_sc_hd__decap_12
XFILLER_0_120_451 VPWR VGND VPWR VGND sky130_ef_sc_hd__decap_12
XFILLER_0_120_495 VPWR VGND VPWR VGND sky130_ef_sc_hd__decap_12
X_7870_ net252 _0023_ VGND VGND VPWR VPWR _0073_ sky130_fd_sc_hd__nor2_1
X_6821_ _3781_ _3782_ _3762_ VGND VGND VPWR VPWR _3810_ sky130_fd_sc_hd__o21ai_1
XFILLER_0_77_449 VGND VGND VPWR VPWR sky130_fd_sc_hd__decap_4
Xclkbuf_leaf_15_clk clknet_3_6__leaf_clk VGND VGND VPWR VPWR clknet_leaf_15_clk sky130_fd_sc_hd__clkbuf_16
XFILLER_0_58_696 VGND VGND VPWR VPWR sky130_fd_sc_hd__decap_4
X_6752_ sh0\[1\] _3703_ sh6\[1\] VGND VGND VPWR VPWR _3741_ sky130_fd_sc_hd__o21ai_4
XFILLER_0_116_713 VGND VGND VPWR VPWR sky130_fd_sc_hd__fill_1
X_6683_ _3581_ _3601_ _3636_ _3637_ VGND VGND VPWR VPWR _3677_ sky130_fd_sc_hd__o211ai_2
X_5703_ _2521_ _2653_ _2661_ _2650_ VGND VGND VPWR VPWR _2720_ sky130_fd_sc_hd__o2bb2ai_2
XFILLER_0_45_335 VGND VGND VPWR VPWR sky130_fd_sc_hd__fill_1
X_8422_ _1250_ _1251_ VGND VGND VPWR VPWR _1252_ sky130_fd_sc_hd__nor2_1
XFILLER_0_5_410 VPWR VGND VPWR VGND sky130_ef_sc_hd__decap_12
X_5634_ _2597_ _2651_ _2596_ VGND VGND VPWR VPWR _2652_ sky130_fd_sc_hd__o21a_1
XFILLER_0_33_508 VGND VGND VPWR VPWR sky130_fd_sc_hd__decap_4
X_8353_ sum5\[12\] s7\[12\] VGND VGND VPWR VPWR _1188_ sky130_fd_sc_hd__and2_1
XFILLER_0_13_210 VPWR VGND VPWR VGND sky130_ef_sc_hd__decap_12
XFILLER_0_5_443 VGND VGND VPWR VPWR sky130_fd_sc_hd__decap_4
XFILLER_0_14_733 VGND VGND VPWR VPWR sky130_fd_sc_hd__fill_2
XFILLER_0_103_429 VGND VGND VPWR VPWR sky130_fd_sc_hd__fill_1
Xhold100 bit_sum6\[0\] VGND VGND VPWR VPWR net142 sky130_fd_sc_hd__dlygate4sd3_1
XFILLER_0_79_51 VGND VGND VPWR VPWR sky130_fd_sc_hd__decap_4
XFILLER_0_78_3 VPWR VGND VPWR VGND sky130_ef_sc_hd__decap_12
X_7304_ _4138_ VGND VGND VPWR VPWR _0323_ sky130_fd_sc_hd__inv_2
X_5565_ _2583_ _2578_ VGND VGND VPWR VPWR _2584_ sky130_fd_sc_hd__nand2_1
X_4516_ _1549_ _1550_ _1551_ _1553_ VGND VGND VPWR VPWR _1560_ sky130_fd_sc_hd__o211ai_4
Xhold133 sh1\[5\] VGND VGND VPWR VPWR net175 sky130_fd_sc_hd__dlygate4sd3_1
Xhold111 bit_sum5\[3\] VGND VGND VPWR VPWR net153 sky130_fd_sc_hd__dlygate4sd3_1
X_8284_ _1110_ _1114_ _1125_ VGND VGND VPWR VPWR _1127_ sky130_fd_sc_hd__a21o_1
X_5496_ _2507_ _2510_ _2512_ _2514_ VGND VGND VPWR VPWR _2515_ sky130_fd_sc_hd__o211ai_4
Xhold122 sh3\[0\] VGND VGND VPWR VPWR net164 sky130_fd_sc_hd__dlygate4sd3_1
Xhold144 sh13\[0\] VGND VGND VPWR VPWR net186 sky130_fd_sc_hd__dlygate4sd3_1
X_4447_ _1227_ _1299_ VGND VGND VPWR VPWR _1492_ sky130_fd_sc_hd__xor2_2
XFILLER_0_110_81 VGND VGND VPWR VPWR sky130_fd_sc_hd__decap_3
Xhold177 sh10\[5\] VGND VGND VPWR VPWR net219 sky130_fd_sc_hd__dlygate4sd3_1
Xhold155 sh10\[4\] VGND VGND VPWR VPWR net197 sky130_fd_sc_hd__dlygate4sd3_1
Xhold166 s4\[8\] VGND VGND VPWR VPWR net208 sky130_fd_sc_hd__dlygate4sd3_1
XFILLER_0_1_671 VGND VGND VPWR VPWR sky130_fd_sc_hd__fill_1
XFILLER_0_13_287 VGND VGND VPWR VPWR sky130_fd_sc_hd__fill_1
X_7235_ _4131_ VGND VGND VPWR VPWR _0261_ sky130_fd_sc_hd__inv_2
Xhold188 sh6\[7\] VGND VGND VPWR VPWR net230 sky130_fd_sc_hd__dlygate4sd3_1
X_7166_ _4124_ VGND VGND VPWR VPWR _0199_ sky130_fd_sc_hd__inv_2
Xhold199 s3\[8\] VGND VGND VPWR VPWR net241 sky130_fd_sc_hd__clkdlybuf4s25_1
XFILLER_0_0_181 VPWR VGND VPWR VGND sky130_ef_sc_hd__decap_12
X_4378_ _1232_ _1233_ sh2\[5\] VGND VGND VPWR VPWR _1424_ sky130_fd_sc_hd__o21bai_2
X_6117_ _3061_ _3062_ _3059_ _2978_ VGND VGND VPWR VPWR _3124_ sky130_fd_sc_hd__a31oi_1
XTAP_460 VGND VPWR sky130_fd_sc_hd__tapvpwrvgnd_1
X_7097_ _4018_ _4071_ _4072_ _4073_ _4075_ VGND VGND VPWR VPWR _4081_ sky130_fd_sc_hd__o311a_1
XTAP_471 VGND VPWR sky130_fd_sc_hd__tapvpwrvgnd_1
XTAP_482 VGND VPWR sky130_fd_sc_hd__tapvpwrvgnd_1
XTAP_493 VGND VPWR sky130_fd_sc_hd__tapvpwrvgnd_1
X_6048_ _3025_ _3029_ _3042_ _3043_ VGND VGND VPWR VPWR _3056_ sky130_fd_sc_hd__nand4_4
XTAP_1615 VGND VPWR sky130_fd_sc_hd__tapvpwrvgnd_1
XTAP_1604 VGND VPWR sky130_fd_sc_hd__tapvpwrvgnd_1
XTAP_1637 VGND VPWR sky130_fd_sc_hd__tapvpwrvgnd_1
XTAP_1648 VGND VPWR sky130_fd_sc_hd__tapvpwrvgnd_1
XTAP_1626 VGND VPWR sky130_fd_sc_hd__tapvpwrvgnd_1
XFILLER_0_95_257 VGND VGND VPWR VPWR sky130_fd_sc_hd__decap_3
XFILLER_0_68_449 VGND VGND VPWR VPWR sky130_fd_sc_hd__decap_3
X_7999_ _0836_ _0837_ _0828_ _0834_ VGND VGND VPWR VPWR _0848_ sky130_fd_sc_hd__o211ai_2
XTAP_1659 VGND VPWR sky130_fd_sc_hd__tapvpwrvgnd_1
XFILLER_0_119_573 VPWR VGND VPWR VGND sky130_ef_sc_hd__decap_12
XFILLER_0_48_195 VGND VGND VPWR VPWR sky130_fd_sc_hd__fill_1
XFILLER_0_36_346 VPWR VGND VPWR VGND sky130_ef_sc_hd__decap_12
XFILLER_0_36_368 VPWR VGND VPWR VGND sky130_ef_sc_hd__decap_12
XFILLER_0_106_256 VGND VGND VPWR VPWR sky130_fd_sc_hd__fill_2
XFILLER_0_64_699 VGND VGND VPWR VPWR sky130_fd_sc_hd__fill_1
XFILLER_0_106_278 VGND VGND VPWR VPWR sky130_fd_sc_hd__fill_2
XFILLER_0_121_237 VGND VGND VPWR VPWR sky130_fd_sc_hd__fill_2
XFILLER_0_20_725 VGND VGND VPWR VPWR sky130_fd_sc_hd__decap_8
XFILLER_0_102_473 VGND VGND VPWR VPWR sky130_fd_sc_hd__decap_3
XFILLER_0_115_15 VPWR VGND VPWR VGND sky130_ef_sc_hd__decap_12
XFILLER_0_99_585 VPWR VGND VPWR VGND sky130_ef_sc_hd__decap_12
XFILLER_0_86_246 VGND VGND VPWR VPWR sky130_fd_sc_hd__decap_6
XFILLER_0_74_419 VGND VGND VPWR VPWR sky130_fd_sc_hd__fill_1
XFILLER_0_24_68 VPWR VGND VPWR VGND sky130_ef_sc_hd__decap_12
XFILLER_0_39_162 VGND VGND VPWR VPWR sky130_fd_sc_hd__fill_1
XFILLER_0_82_430 VGND VGND VPWR VPWR sky130_fd_sc_hd__decap_4
XFILLER_0_27_335 VGND VGND VPWR VPWR sky130_fd_sc_hd__fill_1
XFILLER_0_39_173 VGND VGND VPWR VPWR sky130_fd_sc_hd__decap_4
XFILLER_0_113_727 VGND VGND VPWR VPWR sky130_fd_sc_hd__fill_1
XFILLER_0_2_402 VGND VGND VPWR VPWR sky130_fd_sc_hd__fill_2
XFILLER_0_2_457 VPWR VGND VPWR VGND sky130_ef_sc_hd__decap_12
X_5350_ _2106_ _2189_ VGND VGND VPWR VPWR _2375_ sky130_fd_sc_hd__nor2_1
X_4301_ _1257_ _1230_ _1345_ _1348_ VGND VGND VPWR VPWR _1349_ sky130_fd_sc_hd__o211a_1
XFILLER_0_10_213 VGND VGND VPWR VPWR sky130_fd_sc_hd__fill_1
X_5281_ _2294_ _2296_ _2298_ VGND VGND VPWR VPWR _2308_ sky130_fd_sc_hd__a21o_1
X_4232_ _1275_ _1277_ _1274_ _1279_ VGND VGND VPWR VPWR _1280_ sky130_fd_sc_hd__o22a_1
X_7020_ _3700_ _3702_ _3928_ _4004_ VGND VGND VPWR VPWR _4006_ sky130_fd_sc_hd__a31o_1
XFILLER_0_120_292 VGND VGND VPWR VPWR sky130_fd_sc_hd__fill_1
Xclkbuf_leaf_4_clk clknet_3_2__leaf_clk VGND VGND VPWR VPWR clknet_leaf_4_clk sky130_fd_sc_hd__clkbuf_16
X_7922_ _0730_ _0737_ _0734_ VGND VGND VPWR VPWR _0771_ sky130_fd_sc_hd__o21a_1
X_7853_ net277 s6\[9\] sum4\[9\] VGND VGND VPWR VPWR _0712_ sky130_fd_sc_hd__o21a_1
X_4996_ _1999_ _2009_ _2008_ VGND VGND VPWR VPWR _2028_ sky130_fd_sc_hd__o21a_1
X_7784_ carry2\[8\] net234 _0677_ VGND VGND VPWR VPWR _0029_ sky130_fd_sc_hd__o21a_1
XFILLER_0_58_460 VGND VGND VPWR VPWR sky130_fd_sc_hd__decap_8
X_6804_ _3777_ _3785_ _3792_ VGND VGND VPWR VPWR _3793_ sky130_fd_sc_hd__a21o_1
XFILLER_0_105_81 VGND VGND VPWR VPWR sky130_fd_sc_hd__fill_1
XFILLER_0_58_471 VGND VGND VPWR VPWR sky130_fd_sc_hd__decap_4
X_6735_ _3722_ _3723_ _3724_ VGND VGND VPWR VPWR _3725_ sky130_fd_sc_hd__o21a_1
XFILLER_0_46_622 VGND VGND VPWR VPWR sky130_fd_sc_hd__fill_1
XFILLER_0_85_290 VGND VGND VPWR VPWR sky130_fd_sc_hd__decap_4
XFILLER_0_45_132 VGND VGND VPWR VPWR sky130_fd_sc_hd__decap_8
X_6666_ _3603_ _3654_ _3659_ VGND VGND VPWR VPWR _3660_ sky130_fd_sc_hd__o21ai_2
XFILLER_0_18_379 VGND VGND VPWR VPWR sky130_fd_sc_hd__fill_2
XFILLER_0_45_165 VGND VGND VPWR VPWR sky130_fd_sc_hd__decap_3
XFILLER_0_46_699 VGND VGND VPWR VPWR sky130_fd_sc_hd__fill_1
X_8405_ sh3\[5\] VGND VGND VPWR VPWR _1235_ sky130_fd_sc_hd__clkbuf_4
XFILLER_0_103_204 VGND VGND VPWR VPWR sky130_fd_sc_hd__decap_4
X_6597_ _3591_ _3592_ VGND VGND VPWR VPWR _3593_ sky130_fd_sc_hd__nand2_2
X_5617_ _2618_ _2616_ _2634_ VGND VGND VPWR VPWR _2635_ sky130_fd_sc_hd__o21a_1
XFILLER_0_103_237 VPWR VGND VPWR VGND sky130_ef_sc_hd__decap_12
X_8336_ _1156_ _1157_ VGND VGND VPWR VPWR _1173_ sky130_fd_sc_hd__nand2_1
X_5548_ _2565_ _2566_ _2555_ VGND VGND VPWR VPWR _2567_ sky130_fd_sc_hd__nand3_2
XFILLER_0_41_360 VPWR VGND VPWR VGND sky130_ef_sc_hd__decap_12
X_8267_ _1018_ _1011_ _1070_ VGND VGND VPWR VPWR _1111_ sky130_fd_sc_hd__a21o_1
XFILLER_0_41_393 VGND VGND VPWR VPWR sky130_fd_sc_hd__fill_1
XFILLER_0_111_281 VGND VGND VPWR VPWR sky130_fd_sc_hd__fill_2
X_5479_ _2494_ _2492_ _2493_ _2496_ VGND VGND VPWR VPWR _2499_ sky130_fd_sc_hd__o22ai_2
X_7218_ _4129_ VGND VGND VPWR VPWR _0246_ sky130_fd_sc_hd__inv_2
X_8198_ _0989_ sh15\[3\] _1041_ _1039_ _0984_ VGND VGND VPWR VPWR _1044_ sky130_fd_sc_hd__a221o_1
X_7149_ net293 _4119_ VGND VGND VPWR VPWR _0059_ sky130_fd_sc_hd__xnor2_1
XTAP_290 VGND VPWR sky130_fd_sc_hd__tapvpwrvgnd_1
XFILLER_0_69_714 VGND VGND VPWR VPWR sky130_fd_sc_hd__fill_2
XFILLER_0_96_533 VGND VGND VPWR VPWR sky130_fd_sc_hd__decap_8
XTAP_1423 VGND VPWR sky130_fd_sc_hd__tapvpwrvgnd_1
XTAP_1412 VGND VPWR sky130_fd_sc_hd__tapvpwrvgnd_1
XTAP_1401 VGND VPWR sky130_fd_sc_hd__tapvpwrvgnd_1
XTAP_1456 VGND VPWR sky130_fd_sc_hd__tapvpwrvgnd_1
XTAP_1445 VGND VPWR sky130_fd_sc_hd__tapvpwrvgnd_1
XTAP_1434 VGND VPWR sky130_fd_sc_hd__tapvpwrvgnd_1
XFILLER_0_56_419 VGND VGND VPWR VPWR sky130_fd_sc_hd__fill_1
XTAP_1489 VGND VPWR sky130_fd_sc_hd__tapvpwrvgnd_1
XTAP_1467 VGND VPWR sky130_fd_sc_hd__tapvpwrvgnd_1
XTAP_1478 VGND VPWR sky130_fd_sc_hd__tapvpwrvgnd_1
XFILLER_0_83_249 VGND VGND VPWR VPWR sky130_fd_sc_hd__fill_2
XFILLER_0_49_493 VGND VGND VPWR VPWR sky130_fd_sc_hd__decap_8
XFILLER_0_91_260 VPWR VGND VPWR VGND sky130_ef_sc_hd__decap_12
XFILLER_0_64_485 VGND VGND VPWR VPWR sky130_fd_sc_hd__fill_1
XFILLER_0_101_39 VGND VGND VPWR VPWR sky130_fd_sc_hd__fill_2
XFILLER_0_10_15 VPWR VGND VPWR VGND sky130_ef_sc_hd__decap_12
XFILLER_0_51_179 VPWR VGND VPWR VGND sky130_ef_sc_hd__decap_12
XFILLER_0_20_511 VGND VGND VPWR VPWR sky130_fd_sc_hd__decap_8
XFILLER_0_19_35 VGND VGND VPWR VPWR sky130_fd_sc_hd__decap_8
XFILLER_0_19_57 VGND VGND VPWR VPWR sky130_fd_sc_hd__fill_1
XFILLER_0_87_500 VGND VGND VPWR VPWR sky130_fd_sc_hd__decap_4
Xclkbuf_3_7__f_clk clknet_0_clk VGND VGND VPWR VPWR clknet_3_7__leaf_clk sky130_fd_sc_hd__clkbuf_16
XFILLER_0_99_393 VGND VGND VPWR VPWR sky130_fd_sc_hd__fill_1
X_4850_ _1837_ _1845_ _1850_ _1851_ VGND VGND VPWR VPWR _1886_ sky130_fd_sc_hd__o211a_1
XFILLER_0_75_717 VGND VGND VPWR VPWR sky130_fd_sc_hd__fill_1
XFILLER_0_59_279 VGND VGND VPWR VPWR sky130_fd_sc_hd__fill_1
XFILLER_0_74_227 VGND VGND VPWR VPWR sky130_fd_sc_hd__decap_6
X_4781_ _1730_ _1809_ _1815_ _1817_ VGND VGND VPWR VPWR _1818_ sky130_fd_sc_hd__o211ai_2
X_6520_ _3516_ _3459_ _3443_ VGND VGND VPWR VPWR _3517_ sky130_fd_sc_hd__o21a_1
XFILLER_0_51_55 VGND VGND VPWR VPWR sky130_fd_sc_hd__fill_1
XFILLER_0_51_77 VGND VGND VPWR VPWR sky130_fd_sc_hd__fill_1
XFILLER_0_15_305 VPWR VGND VPWR VGND sky130_ef_sc_hd__decap_12
XFILLER_0_27_176 VPWR VGND VPWR VGND sky130_ef_sc_hd__decap_12
X_6451_ _3444_ _3445_ sh12\[4\] VGND VGND VPWR VPWR _3449_ sky130_fd_sc_hd__o21bai_1
XFILLER_0_42_135 VGND VGND VPWR VPWR sky130_fd_sc_hd__decap_4
XFILLER_0_113_535 VPWR VGND VPWR VGND sky130_ef_sc_hd__decap_12
XFILLER_0_70_477 VGND VGND VPWR VPWR sky130_fd_sc_hd__fill_1
X_6382_ _3378_ _3372_ _3375_ VGND VGND VPWR VPWR _3381_ sky130_fd_sc_hd__nand3_1
XFILLER_0_2_221 VPWR VGND VPWR VGND sky130_ef_sc_hd__decap_12
XFILLER_0_30_319 VPWR VGND VPWR VGND sky130_ef_sc_hd__decap_12
X_5402_ _2426_ VGND VGND VPWR VPWR _0159_ sky130_fd_sc_hd__clkbuf_1
XFILLER_0_2_265 VGND VGND VPWR VPWR sky130_fd_sc_hd__decap_8
XFILLER_0_23_393 VPWR VGND VPWR VGND sky130_ef_sc_hd__decap_12
X_5333_ _2285_ _2296_ VGND VGND VPWR VPWR _2359_ sky130_fd_sc_hd__nand2_1
X_8121_ _0884_ _0897_ _0900_ VGND VGND VPWR VPWR _0968_ sky130_fd_sc_hd__a21oi_2
XFILLER_0_50_190 VGND VGND VPWR VPWR sky130_fd_sc_hd__decap_6
XFILLER_0_76_41 VPWR VGND VPWR VGND sky130_ef_sc_hd__decap_12
XFILLER_0_11_577 VPWR VGND VPWR VGND sky130_ef_sc_hd__decap_12
X_5264_ _2278_ _2281_ _2290_ VGND VGND VPWR VPWR _2291_ sky130_fd_sc_hd__o21ai_2
X_8052_ _0832_ _0836_ _0818_ _0882_ _0876_ VGND VGND VPWR VPWR _0900_ sky130_fd_sc_hd__o2111a_1
XFILLER_0_76_85 VPWR VGND VPWR VGND sky130_ef_sc_hd__decap_12
X_5195_ _2215_ _2221_ _2222_ VGND VGND VPWR VPWR _2223_ sky130_fd_sc_hd__a21o_1
X_7003_ _3987_ _3988_ VGND VGND VPWR VPWR _3989_ sky130_fd_sc_hd__nor2_1
XFILLER_0_92_62 VGND VGND VPWR VPWR sky130_fd_sc_hd__decap_4
X_7905_ _0741_ _0745_ _0754_ VGND VGND VPWR VPWR _0755_ sky130_fd_sc_hd__a21o_1
XFILLER_0_93_503 VGND VGND VPWR VPWR sky130_fd_sc_hd__fill_1
XFILLER_0_78_566 VGND VGND VPWR VPWR sky130_fd_sc_hd__decap_4
X_7836_ sum3\[9\] net415 _0703_ VGND VGND VPWR VPWR _0039_ sky130_fd_sc_hd__o21a_1
XFILLER_0_93_525 VGND VGND VPWR VPWR sky130_fd_sc_hd__fill_2
X_4979_ _2010_ _2011_ VGND VGND VPWR VPWR _2012_ sky130_fd_sc_hd__nand2_1
XFILLER_0_93_558 VGND VGND VPWR VPWR sky130_fd_sc_hd__fill_2
X_7767_ _0666_ _0667_ VGND VGND VPWR VPWR _0093_ sky130_fd_sc_hd__nand2_1
XFILLER_0_46_452 VGND VGND VPWR VPWR sky130_fd_sc_hd__decap_4
XFILLER_0_116_340 VGND VGND VPWR VPWR sky130_fd_sc_hd__decap_8
X_6718_ _3707_ VGND VGND VPWR VPWR _3708_ sky130_fd_sc_hd__buf_4
X_7698_ net273 sum1\[8\] net241 VGND VGND VPWR VPWR _4213_ sky130_fd_sc_hd__a21o_1
X_6649_ _3638_ _3641_ _3643_ VGND VGND VPWR VPWR _3644_ sky130_fd_sc_hd__o21a_1
XFILLER_0_33_113 VGND VGND VPWR VPWR sky130_fd_sc_hd__decap_3
XFILLER_0_6_582 VGND VGND VPWR VPWR sky130_fd_sc_hd__decap_6
XFILLER_0_42_680 VPWR VGND VPWR VGND sky130_ef_sc_hd__decap_12
X_8319_ _1155_ _1156_ carry5\[8\] VGND VGND VPWR VPWR _1157_ sky130_fd_sc_hd__nand3b_2
XFILLER_0_96_341 VGND VGND VPWR VPWR sky130_fd_sc_hd__decap_4
XTAP_1231 VGND VPWR sky130_fd_sc_hd__tapvpwrvgnd_1
XTAP_1220 VGND VPWR sky130_fd_sc_hd__tapvpwrvgnd_1
XFILLER_0_69_566 VPWR VGND VPWR VGND sky130_ef_sc_hd__decap_12
XTAP_1275 VGND VPWR sky130_fd_sc_hd__tapvpwrvgnd_1
XTAP_1264 VGND VPWR sky130_fd_sc_hd__tapvpwrvgnd_1
XTAP_1253 VGND VPWR sky130_fd_sc_hd__tapvpwrvgnd_1
XTAP_1242 VGND VPWR sky130_fd_sc_hd__tapvpwrvgnd_1
XTAP_1297 VGND VPWR sky130_fd_sc_hd__tapvpwrvgnd_1
XTAP_1286 VGND VPWR sky130_fd_sc_hd__tapvpwrvgnd_1
XFILLER_0_112_27 VGND VGND VPWR VPWR sky130_fd_sc_hd__fill_1
XFILLER_0_25_625 VGND VGND VPWR VPWR sky130_fd_sc_hd__decap_3
XFILLER_0_107_362 VGND VGND VPWR VPWR sky130_fd_sc_hd__decap_4
XFILLER_0_25_636 VPWR VGND VPWR VGND sky130_ef_sc_hd__decap_12
XFILLER_0_122_365 VGND VGND VPWR VPWR sky130_fd_sc_hd__decap_3
XFILLER_0_122_343 VGND VGND VPWR VPWR sky130_fd_sc_hd__decap_6
XFILLER_0_0_725 VGND VGND VPWR VPWR sky130_fd_sc_hd__decap_3
XFILLER_0_20_363 VGND VGND VPWR VPWR sky130_fd_sc_hd__fill_1
XFILLER_0_46_55 VGND VGND VPWR VPWR sky130_fd_sc_hd__fill_1
X_5951_ _2936_ sh7\[6\] VGND VGND VPWR VPWR _2960_ sky130_fd_sc_hd__nor2_1
X_4902_ _1868_ _1885_ _1852_ VGND VGND VPWR VPWR _1937_ sky130_fd_sc_hd__o21ai_2
XFILLER_0_1_57 VPWR VGND VPWR VGND sky130_ef_sc_hd__decap_12
X_8670_ clknet_leaf_36_clk _0172_ _0421_ VGND VGND VPWR VPWR bit_sum0\[1\] sky130_fd_sc_hd__dfrtp_1
XFILLER_0_47_205 VGND VGND VPWR VPWR sky130_fd_sc_hd__decap_4
X_5882_ _2888_ _2891_ _2886_ VGND VGND VPWR VPWR _2892_ sky130_fd_sc_hd__a21oi_1
X_4833_ _1852_ _1857_ _1868_ VGND VGND VPWR VPWR _1869_ sky130_fd_sc_hd__a21oi_2
X_7621_ _4169_ VGND VGND VPWR VPWR _0609_ sky130_fd_sc_hd__inv_2
X_4764_ _1799_ _1800_ VGND VGND VPWR VPWR _1801_ sky130_fd_sc_hd__nand2_1
XFILLER_0_83_580 VGND VGND VPWR VPWR sky130_fd_sc_hd__fill_1
XFILLER_0_71_720 VGND VGND VPWR VPWR sky130_fd_sc_hd__decap_8
XFILLER_0_7_335 VGND VGND VPWR VPWR sky130_fd_sc_hd__fill_1
X_7552_ _4162_ VGND VGND VPWR VPWR _0547_ sky130_fd_sc_hd__inv_2
X_7483_ _4155_ VGND VGND VPWR VPWR _0485_ sky130_fd_sc_hd__inv_2
X_6503_ _3338_ _3339_ _3451_ VGND VGND VPWR VPWR _3500_ sky130_fd_sc_hd__a21oi_1
XFILLER_0_15_113 VPWR VGND VPWR VGND sky130_ef_sc_hd__decap_12
XFILLER_0_16_636 VGND VGND VPWR VPWR sky130_fd_sc_hd__decap_8
X_4695_ _1731_ _1732_ _1693_ VGND VGND VPWR VPWR _1733_ sky130_fd_sc_hd__a21boi_2
X_6434_ _3294_ _3326_ _3298_ VGND VGND VPWR VPWR _3432_ sky130_fd_sc_hd__o21ai_4
XFILLER_0_31_617 VGND VGND VPWR VPWR sky130_fd_sc_hd__decap_4
XFILLER_0_43_477 VGND VGND VPWR VPWR sky130_fd_sc_hd__decap_6
XFILLER_0_102_93 VGND VGND VPWR VPWR sky130_fd_sc_hd__decap_3
XFILLER_0_101_505 VPWR VGND VPWR VGND sky130_ef_sc_hd__decap_12
XFILLER_0_31_639 VGND VGND VPWR VPWR sky130_fd_sc_hd__decap_4
XFILLER_0_43_499 VGND VGND VPWR VPWR sky130_fd_sc_hd__decap_4
XFILLER_0_113_387 VGND VGND VPWR VPWR sky130_fd_sc_hd__decap_4
XFILLER_0_87_51 VGND VGND VPWR VPWR sky130_fd_sc_hd__decap_4
X_6365_ _3362_ _3363_ VGND VGND VPWR VPWR _3364_ sky130_fd_sc_hd__and2b_1
XFILLER_0_60_3 VGND VGND VPWR VPWR sky130_fd_sc_hd__decap_4
XFILLER_0_3_585 VPWR VGND VPWR VGND sky130_ef_sc_hd__decap_12
X_6296_ sh0\[4\] VGND VGND VPWR VPWR _3296_ sky130_fd_sc_hd__buf_4
X_8104_ sh4\[3\] _0750_ net35 VGND VGND VPWR VPWR _0951_ sky130_fd_sc_hd__o21a_1
X_5316_ _2340_ _2341_ _2318_ VGND VGND VPWR VPWR _2342_ sky130_fd_sc_hd__o21ai_4
XFILLER_0_11_396 VGND VGND VPWR VPWR sky130_fd_sc_hd__decap_8
X_5247_ _2044_ _2049_ _2269_ VGND VGND VPWR VPWR _2274_ sky130_fd_sc_hd__and3_1
X_8035_ _0821_ _0837_ VGND VGND VPWR VPWR _0883_ sky130_fd_sc_hd__nand2_1
Xhold26 bit_sum7\[5\] VGND VGND VPWR VPWR net68 sky130_fd_sc_hd__dlygate4sd3_1
Xhold37 bit_sum5\[4\] VGND VGND VPWR VPWR net79 sky130_fd_sc_hd__dlygate4sd3_1
Xhold15 bit_sum2\[6\] VGND VGND VPWR VPWR net57 sky130_fd_sc_hd__dlygate4sd3_1
Xhold59 s4\[13\] VGND VGND VPWR VPWR net101 sky130_fd_sc_hd__dlygate4sd3_1
X_5178_ _2052_ _2037_ VGND VGND VPWR VPWR _2206_ sky130_fd_sc_hd__nor2_1
Xhold48 sum4\[1\] VGND VGND VPWR VPWR net90 sky130_fd_sc_hd__dlygate4sd3_1
XFILLER_0_78_385 VGND VGND VPWR VPWR sky130_fd_sc_hd__fill_2
X_8868_ clknet_3_4__leaf_clk sh14\[0\] _0619_ VGND VGND VPWR VPWR sh15\[0\] sky130_fd_sc_hd__dfrtp_2
XFILLER_0_108_104 VGND VGND VPWR VPWR sky130_fd_sc_hd__decap_8
X_8799_ clknet_leaf_5_clk net233 _0550_ VGND VGND VPWR VPWR sh6\[3\] sky130_fd_sc_hd__dfrtp_2
X_7819_ carry2\[8\] sum2\[9\] VGND VGND VPWR VPWR _0695_ sky130_fd_sc_hd__xnor2_1
XFILLER_0_108_159 VGND VGND VPWR VPWR sky130_fd_sc_hd__decap_8
XFILLER_0_34_477 VGND VGND VPWR VPWR sky130_fd_sc_hd__fill_1
XFILLER_0_30_661 VPWR VGND VPWR VGND sky130_ef_sc_hd__decap_12
XFILLER_0_100_560 VPWR VGND VPWR VGND sky130_ef_sc_hd__decap_12
XFILLER_0_97_661 VGND VGND VPWR VPWR sky130_fd_sc_hd__decap_3
XFILLER_0_123_26 VGND VGND VPWR VPWR sky130_fd_sc_hd__fill_2
XFILLER_0_96_182 VGND VGND VPWR VPWR sky130_fd_sc_hd__fill_2
XFILLER_0_69_374 VGND VGND VPWR VPWR sky130_fd_sc_hd__fill_1
XTAP_1083 VGND VPWR sky130_fd_sc_hd__tapvpwrvgnd_1
XTAP_1072 VGND VPWR sky130_fd_sc_hd__tapvpwrvgnd_1
XTAP_1061 VGND VPWR sky130_fd_sc_hd__tapvpwrvgnd_1
XTAP_1050 VGND VPWR sky130_fd_sc_hd__tapvpwrvgnd_1
XFILLER_0_32_46 VGND VGND VPWR VPWR sky130_fd_sc_hd__decap_3
XFILLER_0_45_709 VGND VGND VPWR VPWR sky130_fd_sc_hd__decap_6
XTAP_1094 VGND VPWR sky130_fd_sc_hd__tapvpwrvgnd_1
XFILLER_0_44_219 VGND VGND VPWR VPWR sky130_fd_sc_hd__fill_1
XFILLER_0_108_671 VGND VGND VPWR VPWR sky130_fd_sc_hd__fill_1
XFILLER_0_114_118 VGND VGND VPWR VPWR sky130_fd_sc_hd__fill_1
XFILLER_0_123_652 VPWR VGND VPWR VGND sky130_ef_sc_hd__decap_12
X_4480_ _1524_ _1504_ _1509_ VGND VGND VPWR VPWR _1525_ sky130_fd_sc_hd__a21boi_2
XFILLER_0_25_488 VGND VGND VPWR VPWR sky130_fd_sc_hd__decap_3
XFILLER_0_123_685 VPWR VGND VPWR VGND sky130_ef_sc_hd__decap_12
XFILLER_0_122_195 VGND VGND VPWR VPWR sky130_fd_sc_hd__fill_1
XFILLER_0_110_357 VGND VGND VPWR VPWR sky130_fd_sc_hd__decap_6
X_6150_ _3146_ _3147_ _3142_ _3145_ VGND VGND VPWR VPWR _3156_ sky130_fd_sc_hd__o211ai_4
XFILLER_0_0_533 VPWR VGND VPWR VGND sky130_ef_sc_hd__decap_12
XTAP_801 VGND VPWR sky130_fd_sc_hd__tapvpwrvgnd_1
XFILLER_0_110_379 VGND VGND VPWR VPWR sky130_fd_sc_hd__fill_2
X_5101_ _2128_ _2120_ _2121_ VGND VGND VPWR VPWR _2130_ sky130_fd_sc_hd__and3b_2
XFILLER_0_20_193 VGND VGND VPWR VPWR sky130_fd_sc_hd__decap_3
XTAP_812 VGND VPWR sky130_fd_sc_hd__tapvpwrvgnd_1
XTAP_823 VGND VPWR sky130_fd_sc_hd__tapvpwrvgnd_1
XTAP_834 VGND VPWR sky130_fd_sc_hd__tapvpwrvgnd_1
X_6081_ _2926_ _3086_ _3087_ VGND VGND VPWR VPWR _3088_ sky130_fd_sc_hd__o21ai_2
XTAP_845 VGND VPWR sky130_fd_sc_hd__tapvpwrvgnd_1
XTAP_856 VGND VPWR sky130_fd_sc_hd__tapvpwrvgnd_1
XTAP_867 VGND VPWR sky130_fd_sc_hd__tapvpwrvgnd_1
X_5032_ _2060_ _2061_ _2051_ VGND VGND VPWR VPWR _2062_ sky130_fd_sc_hd__o21ai_1
XTAP_878 VGND VPWR sky130_fd_sc_hd__tapvpwrvgnd_1
XTAP_889 VGND VPWR sky130_fd_sc_hd__tapvpwrvgnd_1
XFILLER_0_79_105 VGND VGND VPWR VPWR sky130_fd_sc_hd__decap_6
XFILLER_0_79_149 VPWR VGND VPWR VGND sky130_ef_sc_hd__decap_12
X_6983_ _3717_ _3750_ VGND VGND VPWR VPWR _3969_ sky130_fd_sc_hd__nor2_1
X_5934_ _2935_ _2942_ VGND VGND VPWR VPWR _2943_ sky130_fd_sc_hd__nand2_1
X_8722_ clknet_leaf_13_clk _0129_ _0473_ VGND VGND VPWR VPWR bit_sum5\[3\] sky130_fd_sc_hd__dfrtp_1
XFILLER_0_48_514 VGND VGND VPWR VPWR sky130_fd_sc_hd__fill_2
XFILLER_0_118_402 VPWR VGND VPWR VGND sky130_ef_sc_hd__decap_12
X_5865_ sh2\[6\] VGND VGND VPWR VPWR _2875_ sky130_fd_sc_hd__clkbuf_4
X_8653_ clknet_leaf_15_clk net141 _0404_ VGND VGND VPWR VPWR s6\[9\] sky130_fd_sc_hd__dfrtp_2
XFILLER_0_8_611 VPWR VGND VPWR VGND sky130_ef_sc_hd__decap_12
X_4816_ _1837_ _1845_ _1850_ _1851_ VGND VGND VPWR VPWR _1852_ sky130_fd_sc_hd__o211ai_4
X_7604_ _4167_ VGND VGND VPWR VPWR _0594_ sky130_fd_sc_hd__inv_2
XFILLER_0_35_208 VPWR VGND VPWR VGND sky130_ef_sc_hd__decap_12
X_5796_ _2802_ _2807_ _2806_ VGND VGND VPWR VPWR _2811_ sky130_fd_sc_hd__nand3_2
X_8584_ clknet_leaf_54_clk net388 _0335_ VGND VGND VPWR VPWR carry1\[7\] sky130_fd_sc_hd__dfrtp_1
X_4747_ _1771_ _1768_ _1639_ _1772_ VGND VGND VPWR VPWR _1784_ sky130_fd_sc_hd__o22ai_4
XFILLER_0_71_561 VPWR VGND VPWR VGND sky130_ef_sc_hd__decap_12
X_7535_ _4161_ VGND VGND VPWR VPWR _0531_ sky130_fd_sc_hd__inv_2
XFILLER_0_8_699 VGND VGND VPWR VPWR sky130_fd_sc_hd__fill_1
XFILLER_0_16_455 VGND VGND VPWR VPWR sky130_fd_sc_hd__fill_1
X_4678_ _1700_ _1701_ _1684_ _1703_ VGND VGND VPWR VPWR _1716_ sky130_fd_sc_hd__o211a_4
X_7466_ _4154_ VGND VGND VPWR VPWR _0469_ sky130_fd_sc_hd__inv_2
X_7397_ _4146_ VGND VGND VPWR VPWR _0408_ sky130_fd_sc_hd__inv_2
X_6417_ _3413_ _3415_ VGND VGND VPWR VPWR _3416_ sky130_fd_sc_hd__and2b_1
XFILLER_0_31_469 VGND VGND VPWR VPWR sky130_fd_sc_hd__decap_6
Xoutput16 net16 VGND VGND VPWR VPWR led[15] sky130_fd_sc_hd__clkbuf_4
X_6348_ _3342_ _3345_ _3346_ VGND VGND VPWR VPWR _3347_ sky130_fd_sc_hd__nand3_4
XFILLER_0_12_672 VPWR VGND VPWR VGND sky130_ef_sc_hd__decap_12
XFILLER_0_11_193 VGND VGND VPWR VPWR sky130_fd_sc_hd__fill_2
X_6279_ _3279_ _3270_ _3276_ VGND VGND VPWR VPWR _3281_ sky130_fd_sc_hd__a21o_1
X_8018_ _0736_ _0772_ VGND VGND VPWR VPWR _0866_ sky130_fd_sc_hd__nor2_1
XFILLER_0_98_469 VGND VGND VPWR VPWR sky130_fd_sc_hd__decap_6
XFILLER_0_86_609 VPWR VGND VPWR VGND sky130_ef_sc_hd__decap_12
XFILLER_0_39_503 VGND VGND VPWR VPWR sky130_fd_sc_hd__fill_1
XPHY_100 VGND VGND VPWR VPWR sky130_fd_sc_hd__decap_3
XPHY_133 VGND VGND VPWR VPWR sky130_fd_sc_hd__decap_3
XPHY_122 VGND VGND VPWR VPWR sky130_fd_sc_hd__decap_3
XPHY_111 VGND VGND VPWR VPWR sky130_fd_sc_hd__decap_3
XFILLER_0_27_709 VGND VGND VPWR VPWR sky130_fd_sc_hd__decap_8
XFILLER_0_109_446 VGND VGND VPWR VPWR sky130_fd_sc_hd__fill_2
XPHY_166 VGND VGND VPWR VPWR sky130_fd_sc_hd__decap_3
XPHY_155 VGND VGND VPWR VPWR sky130_fd_sc_hd__decap_3
XPHY_144 VGND VGND VPWR VPWR sky130_fd_sc_hd__decap_3
XFILLER_0_109_468 VGND VGND VPWR VPWR sky130_fd_sc_hd__fill_2
XPHY_199 VGND VGND VPWR VPWR sky130_fd_sc_hd__decap_3
XPHY_188 VGND VGND VPWR VPWR sky130_fd_sc_hd__decap_3
XPHY_177 VGND VGND VPWR VPWR sky130_fd_sc_hd__decap_3
XFILLER_0_105_641 VGND VGND VPWR VPWR sky130_fd_sc_hd__decap_8
XFILLER_0_120_600 VPWR VGND VPWR VGND sky130_ef_sc_hd__decap_12
XFILLER_0_105_685 VPWR VGND VPWR VGND sky130_ef_sc_hd__decap_12
XFILLER_0_120_655 VPWR VGND VPWR VGND sky130_ef_sc_hd__decap_12
XFILLER_0_120_699 VGND VGND VPWR VPWR sky130_fd_sc_hd__fill_1
XFILLER_0_118_15 VPWR VGND VPWR VGND sky130_ef_sc_hd__decap_12
XFILLER_0_27_46 VGND VGND VPWR VPWR sky130_fd_sc_hd__fill_1
XFILLER_0_27_57 VGND VGND VPWR VPWR sky130_fd_sc_hd__fill_1
XFILLER_0_77_609 VGND VGND VPWR VPWR sky130_fd_sc_hd__decap_6
XFILLER_0_85_620 VGND VGND VPWR VPWR sky130_fd_sc_hd__decap_8
XPHY_2 VGND VGND VPWR VPWR sky130_fd_sc_hd__decap_3
XFILLER_0_57_344 VGND VGND VPWR VPWR sky130_fd_sc_hd__fill_1
XFILLER_0_43_89 VGND VGND VPWR VPWR sky130_fd_sc_hd__decap_4
XFILLER_0_85_697 VGND VGND VPWR VPWR sky130_fd_sc_hd__fill_1
XFILLER_0_84_141 VGND VGND VPWR VPWR sky130_fd_sc_hd__decap_4
Xclkbuf_0_clk clk VGND VGND VPWR VPWR clknet_0_clk sky130_fd_sc_hd__clkbuf_16
X_5650_ _2487_ _2490_ _2493_ VGND VGND VPWR VPWR _2667_ sky130_fd_sc_hd__o21a_1
X_4601_ _1636_ _1637_ _1639_ VGND VGND VPWR VPWR _1640_ sky130_fd_sc_hd__o21ai_2
XFILLER_0_72_336 VGND VGND VPWR VPWR sky130_fd_sc_hd__fill_1
XFILLER_0_115_449 VPWR VGND VPWR VGND sky130_ef_sc_hd__decap_12
XFILLER_0_115_427 VGND VGND VPWR VPWR sky130_fd_sc_hd__fill_1
XFILLER_0_72_369 VGND VGND VPWR VPWR sky130_fd_sc_hd__fill_1
XFILLER_0_53_561 VGND VGND VPWR VPWR sky130_fd_sc_hd__fill_1
X_5581_ _2597_ _2595_ _2596_ VGND VGND VPWR VPWR _2600_ sky130_fd_sc_hd__nand3_2
X_4532_ _1501_ _1525_ _1567_ _1570_ VGND VGND VPWR VPWR _1576_ sky130_fd_sc_hd__o211ai_4
XFILLER_0_25_285 VGND VGND VPWR VPWR sky130_fd_sc_hd__fill_1
X_7320_ _4139_ VGND VGND VPWR VPWR _0338_ sky130_fd_sc_hd__inv_2
X_4463_ _1245_ _1299_ _1506_ _1331_ VGND VGND VPWR VPWR _1508_ sky130_fd_sc_hd__a211oi_1
X_7251_ _4132_ VGND VGND VPWR VPWR _0276_ sky130_fd_sc_hd__inv_2
Xhold315 s6\[11\] VGND VGND VPWR VPWR net357 sky130_fd_sc_hd__dlygate4sd3_1
Xhold304 s6\[12\] VGND VGND VPWR VPWR net346 sky130_fd_sc_hd__dlygate4sd3_1
Xhold326 _0006_ VGND VGND VPWR VPWR net368 sky130_fd_sc_hd__dlygate4sd3_1
X_6202_ _3138_ _3197_ _3198_ _3199_ _3201_ VGND VGND VPWR VPWR _3207_ sky130_fd_sc_hd__o221a_1
XFILLER_0_111_655 VGND VGND VPWR VPWR sky130_fd_sc_hd__decap_6
XFILLER_0_110_121 VGND VGND VPWR VPWR sky130_fd_sc_hd__fill_1
Xhold337 s6\[13\] VGND VGND VPWR VPWR net379 sky130_fd_sc_hd__dlygate4sd3_1
Xhold359 _0048_ VGND VGND VPWR VPWR net401 sky130_fd_sc_hd__dlygate4sd3_1
Xhold348 _0005_ VGND VGND VPWR VPWR net390 sky130_fd_sc_hd__dlygate4sd3_1
X_4394_ _1242_ _1247_ VGND VGND VPWR VPWR _1440_ sky130_fd_sc_hd__nand2_1
X_7182_ _4126_ VGND VGND VPWR VPWR _0213_ sky130_fd_sc_hd__inv_2
XFILLER_0_40_299 VGND VGND VPWR VPWR sky130_fd_sc_hd__fill_1
X_6133_ _2878_ _2894_ net37 VGND VGND VPWR VPWR _3139_ sky130_fd_sc_hd__o21ai_2
XTAP_620 VGND VPWR sky130_fd_sc_hd__tapvpwrvgnd_1
XTAP_631 VGND VPWR sky130_fd_sc_hd__tapvpwrvgnd_1
XTAP_642 VGND VPWR sky130_fd_sc_hd__tapvpwrvgnd_1
X_6064_ _3045_ _3052_ VGND VGND VPWR VPWR _3071_ sky130_fd_sc_hd__nor2_1
XFILLER_0_84_41 VPWR VGND VPWR VGND sky130_ef_sc_hd__decap_12
XTAP_653 VGND VPWR sky130_fd_sc_hd__tapvpwrvgnd_1
XTAP_664 VGND VPWR sky130_fd_sc_hd__tapvpwrvgnd_1
XTAP_675 VGND VPWR sky130_fd_sc_hd__tapvpwrvgnd_1
XTAP_686 VGND VPWR sky130_fd_sc_hd__tapvpwrvgnd_1
X_5015_ _2039_ _2041_ _2044_ VGND VGND VPWR VPWR _2045_ sky130_fd_sc_hd__o21a_1
XTAP_697 VGND VPWR sky130_fd_sc_hd__tapvpwrvgnd_1
XFILLER_0_84_85 VPWR VGND VPWR VGND sky130_ef_sc_hd__decap_12
XFILLER_0_23_3 VPWR VGND VPWR VGND sky130_ef_sc_hd__decap_12
XFILLER_0_108_92 VPWR VGND VPWR VGND sky130_ef_sc_hd__decap_12
XTAP_1819 VGND VPWR sky130_fd_sc_hd__tapvpwrvgnd_1
XTAP_1808 VGND VPWR sky130_fd_sc_hd__tapvpwrvgnd_1
XFILLER_0_95_439 VGND VGND VPWR VPWR sky130_fd_sc_hd__fill_1
X_6966_ _3949_ _3951_ _3952_ VGND VGND VPWR VPWR _3953_ sky130_fd_sc_hd__a21o_1
X_5917_ _2925_ VGND VGND VPWR VPWR _2926_ sky130_fd_sc_hd__buf_4
XFILLER_0_76_653 VGND VGND VPWR VPWR sky130_fd_sc_hd__fill_1
XFILLER_0_76_631 VPWR VGND VPWR VGND sky130_ef_sc_hd__decap_12
X_8705_ clknet_leaf_0_clk _0114_ _0456_ VGND VGND VPWR VPWR bit_sum3\[6\] sky130_fd_sc_hd__dfrtp_1
XFILLER_0_76_697 VGND VGND VPWR VPWR sky130_fd_sc_hd__decap_3
XFILLER_0_76_664 VPWR VGND VPWR VGND sky130_ef_sc_hd__decap_12
X_6897_ _3869_ _3874_ _3855_ _3856_ VGND VGND VPWR VPWR _3885_ sky130_fd_sc_hd__o211ai_4
XFILLER_0_75_196 VGND VGND VPWR VPWR sky130_fd_sc_hd__fill_2
X_8636_ clknet_leaf_31_clk net56 _0387_ VGND VGND VPWR VPWR s4\[10\] sky130_fd_sc_hd__dfrtp_1
X_5848_ _2809_ _2813_ _2815_ _2860_ VGND VGND VPWR VPWR _2861_ sky130_fd_sc_hd__a211oi_1
XFILLER_0_90_133 VGND VGND VPWR VPWR sky130_fd_sc_hd__decap_6
X_5779_ _2788_ _2784_ _2787_ VGND VGND VPWR VPWR _2794_ sky130_fd_sc_hd__and3_1
XFILLER_0_32_701 VPWR VGND VPWR VGND sky130_ef_sc_hd__decap_12
X_8567_ clknet_leaf_37_clk _0062_ _0318_ VGND VGND VPWR VPWR sum2\[2\] sky130_fd_sc_hd__dfrtp_1
X_7518_ _4159_ VGND VGND VPWR VPWR _0516_ sky130_fd_sc_hd__inv_2
XFILLER_0_44_572 VGND VGND VPWR VPWR sky130_fd_sc_hd__fill_1
XFILLER_0_114_471 VGND VGND VPWR VPWR sky130_fd_sc_hd__decap_4
XFILLER_0_102_600 VPWR VGND VPWR VGND sky130_ef_sc_hd__decap_12
XFILLER_0_71_391 VGND VGND VPWR VPWR sky130_fd_sc_hd__fill_1
X_8498_ clknet_leaf_40_clk net66 _0249_ VGND VGND VPWR VPWR final_sum\[4\] sky130_fd_sc_hd__dfrtp_1
XFILLER_0_31_222 VGND VGND VPWR VPWR sky130_fd_sc_hd__fill_2
XFILLER_0_114_493 VGND VGND VPWR VPWR sky130_fd_sc_hd__fill_1
X_7449_ _4152_ VGND VGND VPWR VPWR _0454_ sky130_fd_sc_hd__inv_2
XFILLER_0_102_699 VGND VGND VPWR VPWR sky130_fd_sc_hd__fill_1
XFILLER_0_98_222 VPWR VGND VPWR VGND sky130_ef_sc_hd__decap_12
XFILLER_0_98_288 VGND VGND VPWR VPWR sky130_fd_sc_hd__fill_2
XFILLER_0_13_15 VPWR VGND VPWR VGND sky130_ef_sc_hd__decap_12
XFILLER_0_109_210 VPWR VGND VPWR VGND sky130_ef_sc_hd__decap_12
XFILLER_0_82_612 VGND VGND VPWR VPWR sky130_fd_sc_hd__decap_6
XFILLER_0_82_645 VPWR VGND VPWR VGND sky130_ef_sc_hd__decap_12
XFILLER_0_81_111 VGND VGND VPWR VPWR sky130_fd_sc_hd__fill_1
XFILLER_0_66_185 VGND VGND VPWR VPWR sky130_fd_sc_hd__decap_8
XFILLER_0_27_539 VGND VGND VPWR VPWR sky130_fd_sc_hd__fill_2
XFILLER_0_82_689 VGND VGND VPWR VPWR sky130_fd_sc_hd__decap_8
XFILLER_0_82_678 VGND VGND VPWR VPWR sky130_fd_sc_hd__decap_8
XFILLER_0_54_347 VPWR VGND VPWR VGND sky130_ef_sc_hd__decap_12
XFILLER_0_120_27 VGND VGND VPWR VPWR sky130_fd_sc_hd__fill_1
XFILLER_0_22_200 VGND VGND VPWR VPWR sky130_fd_sc_hd__decap_8
XFILLER_0_35_561 VGND VGND VPWR VPWR sky130_fd_sc_hd__fill_1
XFILLER_0_112_419 VGND VGND VPWR VPWR sky130_fd_sc_hd__fill_1
XFILLER_0_1_105 VGND VGND VPWR VPWR sky130_fd_sc_hd__decap_6
XFILLER_0_22_222 VGND VGND VPWR VPWR sky130_fd_sc_hd__decap_8
XFILLER_0_50_531 VGND VGND VPWR VPWR sky130_fd_sc_hd__fill_1
XFILLER_0_1_149 VPWR VGND VPWR VGND sky130_ef_sc_hd__decap_12
XFILLER_0_120_463 VGND VGND VPWR VPWR sky130_fd_sc_hd__decap_4
XFILLER_0_89_200 VGND VGND VPWR VPWR sky130_fd_sc_hd__decap_4
XFILLER_0_54_11 VGND VGND VPWR VPWR sky130_fd_sc_hd__fill_2
XFILLER_0_89_299 VGND VGND VPWR VPWR sky130_fd_sc_hd__decap_4
XFILLER_0_89_277 VGND VGND VPWR VPWR sky130_fd_sc_hd__decap_3
X_6820_ _3781_ _3782_ _3762_ _3771_ VGND VGND VPWR VPWR _3809_ sky130_fd_sc_hd__o211ai_1
XFILLER_0_9_205 VPWR VGND VPWR VGND sky130_ef_sc_hd__decap_12
XFILLER_0_70_21 VGND VGND VPWR VPWR sky130_fd_sc_hd__fill_1
XFILLER_0_57_152 VGND VGND VPWR VPWR sky130_fd_sc_hd__fill_1
X_6751_ _3703_ VGND VGND VPWR VPWR _3740_ sky130_fd_sc_hd__inv_2
X_6682_ _3671_ _3672_ _3675_ VGND VGND VPWR VPWR _3676_ sky130_fd_sc_hd__a21oi_1
XFILLER_0_57_196 VGND VGND VPWR VPWR sky130_fd_sc_hd__decap_3
X_5702_ _2717_ _2718_ sh15\[0\] VGND VGND VPWR VPWR _2719_ sky130_fd_sc_hd__nand3_2
X_8421_ _1248_ _1249_ _1245_ VGND VGND VPWR VPWR _1251_ sky130_fd_sc_hd__o21a_1
XFILLER_0_92_6 VPWR VGND VPWR VGND sky130_ef_sc_hd__decap_12
XFILLER_0_5_422 VGND VGND VPWR VPWR sky130_fd_sc_hd__fill_1
X_5633_ _2587_ _2593_ _2594_ VGND VGND VPWR VPWR _2651_ sky130_fd_sc_hd__a21oi_1
X_8352_ _1186_ _1187_ VGND VGND VPWR VPWR _0165_ sky130_fd_sc_hd__nor2_1
X_5564_ _2568_ _2564_ _2567_ _2582_ VGND VGND VPWR VPWR _2583_ sky130_fd_sc_hd__a31oi_1
XFILLER_0_14_701 VPWR VGND VPWR VGND sky130_ef_sc_hd__decap_12
XFILLER_0_26_572 VPWR VGND VPWR VGND sky130_ef_sc_hd__decap_12
X_4515_ _1544_ _1545_ sh14\[5\] VGND VGND VPWR VPWR _1559_ sky130_fd_sc_hd__o21bai_2
XFILLER_0_115_268 VPWR VGND VPWR VGND sky130_ef_sc_hd__decap_12
X_7303_ _4138_ VGND VGND VPWR VPWR _0322_ sky130_fd_sc_hd__inv_2
XFILLER_0_13_222 VGND VGND VPWR VPWR sky130_fd_sc_hd__fill_2
XFILLER_0_5_499 VGND VGND VPWR VPWR sky130_fd_sc_hd__fill_1
XFILLER_0_5_488 VGND VGND VPWR VPWR sky130_fd_sc_hd__fill_1
XFILLER_0_5_477 VGND VGND VPWR VPWR sky130_fd_sc_hd__decap_4
Xhold101 bit_sum0\[0\] VGND VGND VPWR VPWR net143 sky130_fd_sc_hd__dlygate4sd3_1
XFILLER_0_41_531 VGND VGND VPWR VPWR sky130_fd_sc_hd__fill_1
Xhold123 final_sum\[12\] VGND VGND VPWR VPWR net165 sky130_fd_sc_hd__dlygate4sd3_1
X_8283_ _1110_ _1114_ _1125_ VGND VGND VPWR VPWR _1126_ sky130_fd_sc_hd__and3_1
X_5495_ _2509_ _2513_ _2489_ VGND VGND VPWR VPWR _2514_ sky130_fd_sc_hd__o21ai_2
Xhold112 bit_sum2\[0\] VGND VGND VPWR VPWR net154 sky130_fd_sc_hd__dlygate4sd3_1
Xhold134 final_sum\[3\] VGND VGND VPWR VPWR net176 sky130_fd_sc_hd__dlygate4sd3_1
X_4446_ _1234_ _1486_ _1487_ _1488_ _1490_ VGND VGND VPWR VPWR _1491_ sky130_fd_sc_hd__o221ai_4
Xhold156 sh3\[5\] VGND VGND VPWR VPWR net198 sky130_fd_sc_hd__dlygate4sd3_1
X_7234_ _4131_ VGND VGND VPWR VPWR _0260_ sky130_fd_sc_hd__inv_2
Xhold145 sh2\[4\] VGND VGND VPWR VPWR net187 sky130_fd_sc_hd__dlygate4sd3_1
Xhold167 _0078_ VGND VGND VPWR VPWR net209 sky130_fd_sc_hd__dlygate4sd3_1
X_4377_ _1231_ _1239_ _1268_ VGND VGND VPWR VPWR _1423_ sky130_fd_sc_hd__o21ai_2
X_7165_ _4122_ VGND VGND VPWR VPWR _4124_ sky130_fd_sc_hd__buf_4
Xhold189 sh0\[3\] VGND VGND VPWR VPWR net231 sky130_fd_sc_hd__dlygate4sd3_1
Xhold178 s4\[4\] VGND VGND VPWR VPWR net220 sky130_fd_sc_hd__buf_1
X_6116_ _3120_ _3122_ _2868_ VGND VGND VPWR VPWR _3123_ sky130_fd_sc_hd__o21ai_2
XFILLER_0_0_193 VGND VGND VPWR VPWR sky130_fd_sc_hd__decap_3
XTAP_450 VGND VPWR sky130_fd_sc_hd__tapvpwrvgnd_1
X_7096_ _4073_ _4074_ _4075_ VGND VGND VPWR VPWR _4080_ sky130_fd_sc_hd__a21oi_1
XTAP_461 VGND VPWR sky130_fd_sc_hd__tapvpwrvgnd_1
XTAP_472 VGND VPWR sky130_fd_sc_hd__tapvpwrvgnd_1
XTAP_483 VGND VPWR sky130_fd_sc_hd__tapvpwrvgnd_1
XTAP_494 VGND VPWR sky130_fd_sc_hd__tapvpwrvgnd_1
X_6047_ _2969_ _2971_ _2972_ _2967_ _3046_ VGND VGND VPWR VPWR _3055_ sky130_fd_sc_hd__a32oi_4
XTAP_1605 VGND VPWR sky130_fd_sc_hd__tapvpwrvgnd_1
XTAP_1638 VGND VPWR sky130_fd_sc_hd__tapvpwrvgnd_1
XTAP_1649 VGND VPWR sky130_fd_sc_hd__tapvpwrvgnd_1
XTAP_1627 VGND VPWR sky130_fd_sc_hd__tapvpwrvgnd_1
XTAP_1616 VGND VPWR sky130_fd_sc_hd__tapvpwrvgnd_1
XFILLER_0_95_225 VPWR VGND VPWR VGND sky130_ef_sc_hd__decap_12
X_7998_ _0828_ _0833_ _0834_ VGND VGND VPWR VPWR _0847_ sky130_fd_sc_hd__a21o_1
X_6949_ _3930_ _3933_ _3935_ VGND VGND VPWR VPWR _3936_ sky130_fd_sc_hd__o21a_1
XFILLER_0_48_141 VGND VGND VPWR VPWR sky130_fd_sc_hd__decap_6
XFILLER_0_63_111 VGND VGND VPWR VPWR sky130_fd_sc_hd__fill_1
XFILLER_0_119_585 VGND VGND VPWR VPWR sky130_fd_sc_hd__decap_8
XFILLER_0_63_144 VGND VGND VPWR VPWR sky130_fd_sc_hd__decap_8
XFILLER_0_8_271 VGND VGND VPWR VPWR sky130_fd_sc_hd__decap_8
XFILLER_0_17_550 VGND VGND VPWR VPWR sky130_fd_sc_hd__fill_2
XFILLER_0_36_358 VGND VGND VPWR VPWR sky130_fd_sc_hd__decap_6
X_8619_ clknet_leaf_55_clk net111 _0370_ VGND VGND VPWR VPWR s2\[11\] sky130_fd_sc_hd__dfrtp_1
XFILLER_0_17_561 VPWR VGND VPWR VGND sky130_ef_sc_hd__decap_12
XFILLER_0_17_583 VGND VGND VPWR VPWR sky130_fd_sc_hd__decap_4
XFILLER_0_121_205 VPWR VGND VPWR VGND sky130_ef_sc_hd__decap_12
XFILLER_0_32_520 VPWR VGND VPWR VGND sky130_ef_sc_hd__decap_12
XFILLER_0_115_27 VPWR VGND VPWR VGND sky130_ef_sc_hd__decap_12
XFILLER_0_99_597 VGND VGND VPWR VPWR sky130_fd_sc_hd__fill_2
XFILLER_0_67_472 VPWR VGND VPWR VGND sky130_ef_sc_hd__decap_12
XFILLER_0_55_634 VGND VGND VPWR VPWR sky130_fd_sc_hd__fill_1
XFILLER_0_54_111 VPWR VGND VPWR VGND sky130_ef_sc_hd__decap_12
XFILLER_0_7_709 VPWR VGND VPWR VGND sky130_ef_sc_hd__decap_12
XFILLER_0_54_133 VGND VGND VPWR VPWR sky130_fd_sc_hd__decap_6
XFILLER_0_27_369 VGND VGND VPWR VPWR sky130_fd_sc_hd__decap_6
XFILLER_0_42_317 VGND VGND VPWR VPWR sky130_fd_sc_hd__fill_2
X_4300_ _1335_ _1346_ _1334_ _1347_ VGND VGND VPWR VPWR _1348_ sky130_fd_sc_hd__o22ai_2
XFILLER_0_2_469 VGND VGND VPWR VPWR sky130_fd_sc_hd__decap_6
X_5280_ _2299_ _2306_ sh15\[2\] VGND VGND VPWR VPWR _2307_ sky130_fd_sc_hd__o21bai_2
XFILLER_0_49_55 VGND VGND VPWR VPWR sky130_fd_sc_hd__fill_1
X_4231_ _1277_ _1278_ VGND VGND VPWR VPWR _1279_ sky130_fd_sc_hd__nor2_1
XFILLER_0_49_66 VGND VGND VPWR VPWR sky130_fd_sc_hd__decap_6
X_7921_ _0767_ _0768_ _0769_ VGND VGND VPWR VPWR _0770_ sky130_fd_sc_hd__nand3_1
XFILLER_0_78_715 VPWR VGND VPWR VGND sky130_ef_sc_hd__decap_12
XFILLER_0_77_225 VGND VGND VPWR VPWR sky130_fd_sc_hd__fill_2
X_7852_ net400 s6\[8\] _0711_ VGND VGND VPWR VPWR _0048_ sky130_fd_sc_hd__a21o_1
X_4995_ _2003_ _2001_ _2000_ VGND VGND VPWR VPWR _2027_ sky130_fd_sc_hd__a21boi_1
XFILLER_0_93_729 VGND VGND VPWR VPWR sky130_fd_sc_hd__decap_6
X_7783_ carry2\[8\] net234 net194 VGND VGND VPWR VPWR _0677_ sky130_fd_sc_hd__a21o_1
X_6803_ _3790_ _3791_ VGND VGND VPWR VPWR _3792_ sky130_fd_sc_hd__nor2_2
XFILLER_0_46_601 VGND VGND VPWR VPWR sky130_fd_sc_hd__fill_1
XFILLER_0_92_228 VGND VGND VPWR VPWR sky130_fd_sc_hd__fill_1
X_6734_ sh6\[1\] VGND VGND VPWR VPWR _3724_ sky130_fd_sc_hd__clkbuf_4
XFILLER_0_18_347 VGND VGND VPWR VPWR sky130_fd_sc_hd__decap_8
XFILLER_0_46_645 VPWR VGND VPWR VGND sky130_ef_sc_hd__decap_12
X_8404_ _1233_ VGND VGND VPWR VPWR _1234_ sky130_fd_sc_hd__buf_4
XFILLER_0_90_3 VPWR VGND VPWR VGND sky130_ef_sc_hd__decap_12
X_6665_ _3623_ _3608_ _3617_ VGND VGND VPWR VPWR _3659_ sky130_fd_sc_hd__o21ai_1
XFILLER_0_60_103 VPWR VGND VPWR VGND sky130_ef_sc_hd__decap_12
XFILLER_0_121_81 VPWR VGND VPWR VGND sky130_ef_sc_hd__decap_12
XFILLER_0_116_566 VPWR VGND VPWR VGND sky130_ef_sc_hd__decap_12
X_6596_ _3525_ _3529_ _3584_ _3589_ VGND VGND VPWR VPWR _3592_ sky130_fd_sc_hd__nand4_1
X_5616_ _2618_ _2619_ _2493_ VGND VGND VPWR VPWR _2634_ sky130_fd_sc_hd__o21bai_1
XFILLER_0_103_249 VPWR VGND VPWR VGND sky130_ef_sc_hd__decap_12
X_8335_ _1170_ _1171_ _1158_ VGND VGND VPWR VPWR _1172_ sky130_fd_sc_hd__a21oi_1
X_5547_ _2479_ sh3\[0\] VGND VGND VPWR VPWR _2566_ sky130_fd_sc_hd__or2_1
X_8266_ _1077_ _1074_ _1109_ VGND VGND VPWR VPWR _1110_ sky130_fd_sc_hd__o21ai_2
X_5478_ _2492_ _2494_ _2496_ _2493_ _2497_ VGND VGND VPWR VPWR _2498_ sky130_fd_sc_hd__o221a_1
XFILLER_0_41_372 VPWR VGND VPWR VGND sky130_ef_sc_hd__decap_12
X_4429_ _1470_ _1474_ _1262_ VGND VGND VPWR VPWR _1475_ sky130_fd_sc_hd__o21ai_2
X_7217_ _4129_ VGND VGND VPWR VPWR _0245_ sky130_fd_sc_hd__inv_2
X_8197_ _0990_ _0991_ _1042_ VGND VGND VPWR VPWR _1043_ sky130_fd_sc_hd__a21o_1
X_7148_ s0\[9\] s1\[9\] VGND VGND VPWR VPWR _4119_ sky130_fd_sc_hd__xnor2_1
XTAP_280 VGND VPWR sky130_fd_sc_hd__tapvpwrvgnd_1
XTAP_291 VGND VPWR sky130_fd_sc_hd__tapvpwrvgnd_1
X_7079_ _4063_ _4013_ _4011_ VGND VGND VPWR VPWR _4064_ sky130_fd_sc_hd__o21ai_1
XTAP_1424 VGND VPWR sky130_fd_sc_hd__tapvpwrvgnd_1
XTAP_1413 VGND VPWR sky130_fd_sc_hd__tapvpwrvgnd_1
XTAP_1402 VGND VPWR sky130_fd_sc_hd__tapvpwrvgnd_1
XTAP_1457 VGND VPWR sky130_fd_sc_hd__tapvpwrvgnd_1
XTAP_1446 VGND VPWR sky130_fd_sc_hd__tapvpwrvgnd_1
XTAP_1435 VGND VPWR sky130_fd_sc_hd__tapvpwrvgnd_1
Xfanout40 sh3\[7\] VGND VGND VPWR VPWR net40 sky130_fd_sc_hd__buf_4
XTAP_1468 VGND VPWR sky130_fd_sc_hd__tapvpwrvgnd_1
XTAP_1479 VGND VPWR sky130_fd_sc_hd__tapvpwrvgnd_1
XFILLER_0_119_393 VGND VGND VPWR VPWR sky130_fd_sc_hd__decap_8
XFILLER_0_91_272 VGND VGND VPWR VPWR sky130_fd_sc_hd__decap_8
XFILLER_0_64_475 VGND VGND VPWR VPWR sky130_fd_sc_hd__fill_1
XFILLER_0_52_637 VGND VGND VPWR VPWR sky130_fd_sc_hd__decap_6
XFILLER_0_51_103 VGND VGND VPWR VPWR sky130_fd_sc_hd__decap_8
XFILLER_0_10_27 VGND VGND VPWR VPWR sky130_fd_sc_hd__fill_1
XFILLER_0_51_125 VGND VGND VPWR VPWR sky130_fd_sc_hd__decap_8
XFILLER_0_122_525 VGND VGND VPWR VPWR sky130_fd_sc_hd__fill_2
XFILLER_0_51_169 VGND VGND VPWR VPWR sky130_fd_sc_hd__decap_6
XFILLER_0_20_589 VGND VGND VPWR VPWR sky130_fd_sc_hd__decap_4
XFILLER_0_35_57 VGND VGND VPWR VPWR sky130_fd_sc_hd__decap_3
XFILLER_0_99_383 VGND VGND VPWR VPWR sky130_fd_sc_hd__fill_1
XFILLER_0_75_729 VGND VGND VPWR VPWR sky130_fd_sc_hd__decap_6
X_4780_ _1789_ _1790_ _1816_ VGND VGND VPWR VPWR _1817_ sky130_fd_sc_hd__o21ai_2
XFILLER_0_27_111 VGND VGND VPWR VPWR sky130_fd_sc_hd__fill_1
XFILLER_0_27_144 VGND VGND VPWR VPWR sky130_fd_sc_hd__decap_6
XFILLER_0_28_645 VGND VGND VPWR VPWR sky130_fd_sc_hd__decap_8
XFILLER_0_28_656 VPWR VGND VPWR VGND sky130_ef_sc_hd__decap_12
XFILLER_0_15_317 VGND VGND VPWR VPWR sky130_fd_sc_hd__decap_4
XFILLER_0_43_604 VGND VGND VPWR VPWR sky130_fd_sc_hd__decap_8
XFILLER_0_43_615 VGND VGND VPWR VPWR sky130_fd_sc_hd__fill_1
XFILLER_0_113_503 VGND VGND VPWR VPWR sky130_fd_sc_hd__fill_1
X_6450_ net33 sh9\[4\] sh12\[4\] VGND VGND VPWR VPWR _3448_ sky130_fd_sc_hd__o21ai_1
XFILLER_0_70_434 VGND VGND VPWR VPWR sky130_fd_sc_hd__fill_1
XFILLER_0_55_497 VGND VGND VPWR VPWR sky130_fd_sc_hd__decap_6
XFILLER_0_27_188 VPWR VGND VPWR VGND sky130_ef_sc_hd__decap_12
XFILLER_0_113_547 VPWR VGND VPWR VGND sky130_ef_sc_hd__decap_12
X_6381_ _3347_ _3341_ _3350_ VGND VGND VPWR VPWR _3380_ sky130_fd_sc_hd__a21boi_2
XFILLER_0_30_309 VGND VGND VPWR VPWR sky130_fd_sc_hd__decap_3
X_5401_ _2421_ _2425_ VGND VGND VPWR VPWR _2426_ sky130_fd_sc_hd__and2_1
XFILLER_0_51_670 VGND VGND VPWR VPWR sky130_fd_sc_hd__fill_2
XFILLER_0_11_534 VGND VGND VPWR VPWR sky130_fd_sc_hd__decap_4
XFILLER_0_2_233 VPWR VGND VPWR VGND sky130_ef_sc_hd__decap_12
XFILLER_0_23_361 VPWR VGND VPWR VGND sky130_ef_sc_hd__decap_12
X_5332_ _2317_ _2347_ _2348_ VGND VGND VPWR VPWR _2358_ sky130_fd_sc_hd__and3_1
X_8120_ _0927_ _0963_ _0966_ VGND VGND VPWR VPWR _0967_ sky130_fd_sc_hd__nand3_4
XFILLER_0_100_219 VGND VGND VPWR VPWR sky130_fd_sc_hd__decap_6
X_5263_ _2270_ _2271_ _2289_ _2273_ VGND VGND VPWR VPWR _2290_ sky130_fd_sc_hd__a31o_1
X_8051_ _0876_ _0882_ _0883_ VGND VGND VPWR VPWR _0899_ sky130_fd_sc_hd__a21oi_2
XFILLER_0_76_53 VPWR VGND VPWR VGND sky130_ef_sc_hd__decap_12
X_5194_ _2152_ _2146_ VGND VGND VPWR VPWR _2222_ sky130_fd_sc_hd__nand2_1
X_7002_ _3701_ _3702_ _3769_ _3909_ VGND VGND VPWR VPWR _3988_ sky130_fd_sc_hd__and4_1
XFILLER_0_76_97 VPWR VGND VPWR VGND sky130_ef_sc_hd__decap_12
XFILLER_0_78_512 VPWR VGND VPWR VGND sky130_ef_sc_hd__decap_12
XFILLER_0_92_85 VGND VGND VPWR VPWR sky130_fd_sc_hd__decap_8
X_7904_ _0749_ _0751_ _0748_ _0753_ VGND VGND VPWR VPWR _0754_ sky130_fd_sc_hd__o22a_1
XFILLER_0_78_589 VPWR VGND VPWR VGND sky130_ef_sc_hd__decap_12
X_7835_ sum3\[9\] carry3\[8\] net333 VGND VGND VPWR VPWR _0703_ sky130_fd_sc_hd__a21o_1
XFILLER_0_19_623 VGND VGND VPWR VPWR sky130_fd_sc_hd__decap_8
X_4978_ _2008_ _1978_ _2007_ VGND VGND VPWR VPWR _2011_ sky130_fd_sc_hd__nand3_1
X_7766_ net264 _0664_ _0665_ VGND VGND VPWR VPWR _0667_ sky130_fd_sc_hd__or3_1
XFILLER_0_58_291 VPWR VGND VPWR VGND sky130_ef_sc_hd__decap_12
XFILLER_0_58_280 VGND VGND VPWR VPWR sky130_fd_sc_hd__decap_4
X_6717_ sh1\[1\] sh0\[1\] VGND VGND VPWR VPWR _3707_ sky130_fd_sc_hd__and2_1
XFILLER_0_34_626 VGND VGND VPWR VPWR sky130_fd_sc_hd__fill_2
X_7697_ carry1\[6\] net385 _4212_ VGND VGND VPWR VPWR _0017_ sky130_fd_sc_hd__o21a_1
X_6648_ _3642_ _3638_ _3591_ VGND VGND VPWR VPWR _3643_ sky130_fd_sc_hd__o21ai_1
XFILLER_0_33_158 VGND VGND VPWR VPWR sky130_fd_sc_hd__decap_8
XFILLER_0_33_169 VGND VGND VPWR VPWR sky130_fd_sc_hd__decap_8
X_6579_ _3307_ _3377_ _3451_ VGND VGND VPWR VPWR _3575_ sky130_fd_sc_hd__o21a_1
X_8318_ sum5\[9\] s7\[9\] VGND VGND VPWR VPWR _1156_ sky130_fd_sc_hd__nand2_1
XFILLER_0_14_372 VPWR VGND VPWR VGND sky130_ef_sc_hd__decap_12
XFILLER_0_42_692 VGND VGND VPWR VPWR sky130_fd_sc_hd__decap_8
X_8249_ _1041_ _1092_ _1093_ VGND VGND VPWR VPWR _1094_ sky130_fd_sc_hd__a21oi_1
XTAP_1232 VGND VPWR sky130_fd_sc_hd__tapvpwrvgnd_1
XTAP_1221 VGND VPWR sky130_fd_sc_hd__tapvpwrvgnd_1
XTAP_1210 VGND VPWR sky130_fd_sc_hd__tapvpwrvgnd_1
XFILLER_0_57_729 VGND VGND VPWR VPWR sky130_fd_sc_hd__decap_6
XTAP_1265 VGND VPWR sky130_fd_sc_hd__tapvpwrvgnd_1
XTAP_1254 VGND VPWR sky130_fd_sc_hd__tapvpwrvgnd_1
XTAP_1243 VGND VPWR sky130_fd_sc_hd__tapvpwrvgnd_1
XTAP_1298 VGND VPWR sky130_fd_sc_hd__tapvpwrvgnd_1
XTAP_1287 VGND VPWR sky130_fd_sc_hd__tapvpwrvgnd_1
XTAP_1276 VGND VPWR sky130_fd_sc_hd__tapvpwrvgnd_1
XFILLER_0_107_330 VGND VGND VPWR VPWR sky130_fd_sc_hd__fill_1
XFILLER_0_21_15 VGND VGND VPWR VPWR sky130_fd_sc_hd__decap_6
XFILLER_0_25_604 VPWR VGND VPWR VGND sky130_ef_sc_hd__decap_12
XFILLER_0_80_732 VGND VGND VPWR VPWR sky130_fd_sc_hd__decap_3
XFILLER_0_25_648 VPWR VGND VPWR VGND sky130_ef_sc_hd__decap_12
XFILLER_0_12_309 VGND VGND VPWR VPWR sky130_fd_sc_hd__decap_8
XFILLER_0_40_607 VGND VGND VPWR VPWR sky130_fd_sc_hd__fill_1
XFILLER_0_40_629 VPWR VGND VPWR VGND sky130_ef_sc_hd__decap_12
XFILLER_0_46_45 VGND VGND VPWR VPWR sky130_fd_sc_hd__decap_6
X_5950_ _2936_ _2893_ _2922_ VGND VGND VPWR VPWR _2959_ sky130_fd_sc_hd__o21ai_2
XFILLER_0_87_320 VGND VGND VPWR VPWR sky130_fd_sc_hd__fill_1
X_4901_ _1934_ _1927_ _1930_ VGND VGND VPWR VPWR _1936_ sky130_fd_sc_hd__a21o_1
XFILLER_0_1_69 VPWR VGND VPWR VGND sky130_ef_sc_hd__decap_12
X_5881_ _2889_ _2890_ _2880_ VGND VGND VPWR VPWR _2891_ sky130_fd_sc_hd__a21o_1
XFILLER_0_87_386 VGND VGND VPWR VPWR sky130_fd_sc_hd__decap_6
X_7620_ _4121_ VGND VGND VPWR VPWR _4169_ sky130_fd_sc_hd__buf_8
X_4832_ _1860_ _1864_ _1867_ VGND VGND VPWR VPWR _1868_ sky130_fd_sc_hd__o21ai_2
XFILLER_0_75_559 VGND VGND VPWR VPWR sky130_fd_sc_hd__fill_1
XFILLER_0_75_548 VGND VGND VPWR VPWR sky130_fd_sc_hd__fill_2
X_7551_ _4162_ VGND VGND VPWR VPWR _0546_ sky130_fd_sc_hd__inv_2
X_4763_ _1662_ sh12\[7\] _1797_ _1798_ VGND VGND VPWR VPWR _1800_ sky130_fd_sc_hd__a211o_1
XFILLER_0_55_261 VPWR VGND VPWR VGND sky130_ef_sc_hd__decap_12
XFILLER_0_28_464 VGND VGND VPWR VPWR sky130_fd_sc_hd__fill_1
XFILLER_0_43_401 VGND VGND VPWR VPWR sky130_fd_sc_hd__decap_8
X_4694_ _1704_ _1710_ _1714_ VGND VGND VPWR VPWR _1732_ sky130_fd_sc_hd__a21o_1
X_7482_ _4155_ VGND VGND VPWR VPWR _0484_ sky130_fd_sc_hd__inv_2
X_6502_ _3491_ _3495_ _3498_ VGND VGND VPWR VPWR _3499_ sky130_fd_sc_hd__nand3_2
XFILLER_0_15_125 VPWR VGND VPWR VGND sky130_ef_sc_hd__decap_12
XFILLER_0_113_322 VGND VGND VPWR VPWR sky130_fd_sc_hd__fill_1
X_6433_ _3427_ _3430_ _3368_ VGND VGND VPWR VPWR _3431_ sky130_fd_sc_hd__a21oi_2
XFILLER_0_70_253 VGND VGND VPWR VPWR sky130_fd_sc_hd__decap_4
XFILLER_0_15_169 VPWR VGND VPWR VGND sky130_ef_sc_hd__decap_12
XFILLER_0_11_81 VPWR VGND VPWR VGND sky130_ef_sc_hd__decap_12
XFILLER_0_113_399 VGND VGND VPWR VPWR sky130_fd_sc_hd__decap_4
XFILLER_0_101_517 VPWR VGND VPWR VGND sky130_ef_sc_hd__decap_12
X_6364_ _3356_ _3361_ _3359_ VGND VGND VPWR VPWR _3363_ sky130_fd_sc_hd__nand3_1
XFILLER_0_3_597 VPWR VGND VPWR VGND sky130_ef_sc_hd__decap_12
XFILLER_0_30_139 VGND VGND VPWR VPWR sky130_fd_sc_hd__fill_1
X_6295_ _3294_ VGND VGND VPWR VPWR _3295_ sky130_fd_sc_hd__clkbuf_4
X_8103_ _0947_ _0948_ _0949_ VGND VGND VPWR VPWR _0950_ sky130_fd_sc_hd__o21ai_4
X_5315_ _2333_ _2337_ _2329_ VGND VGND VPWR VPWR _2341_ sky130_fd_sc_hd__a21oi_2
X_8034_ _0877_ _0878_ _0880_ _0881_ VGND VGND VPWR VPWR _0882_ sky130_fd_sc_hd__o211ai_4
X_5246_ _2270_ _2271_ _2272_ VGND VGND VPWR VPWR _2273_ sky130_fd_sc_hd__a21boi_2
Xhold38 bit_sum7\[8\] VGND VGND VPWR VPWR net80 sky130_fd_sc_hd__dlygate4sd3_1
Xhold16 bit_sum4\[7\] VGND VGND VPWR VPWR net58 sky130_fd_sc_hd__dlygate4sd3_1
Xhold27 bit_sum2\[7\] VGND VGND VPWR VPWR net69 sky130_fd_sc_hd__dlygate4sd3_1
X_5177_ _2203_ _2204_ _2072_ VGND VGND VPWR VPWR _2205_ sky130_fd_sc_hd__o21ba_1
Xhold49 bit_sum0\[3\] VGND VGND VPWR VPWR net91 sky130_fd_sc_hd__dlygate4sd3_1
XFILLER_0_97_128 VGND VGND VPWR VPWR sky130_fd_sc_hd__fill_1
X_8867_ clknet_leaf_16_clk net211 _0618_ VGND VGND VPWR VPWR sh14\[7\] sky130_fd_sc_hd__dfrtp_4
XFILLER_0_78_397 VGND VGND VPWR VPWR sky130_fd_sc_hd__decap_3
XFILLER_0_39_729 VGND VGND VPWR VPWR sky130_fd_sc_hd__decap_6
XFILLER_0_109_639 VGND VGND VPWR VPWR sky130_fd_sc_hd__fill_1
X_7818_ net208 _0694_ VGND VGND VPWR VPWR _0078_ sky130_fd_sc_hd__xnor2_1
X_8798_ clknet_leaf_64_clk net38 _0549_ VGND VGND VPWR VPWR sh6\[2\] sky130_fd_sc_hd__dfrtp_4
XFILLER_0_81_529 VGND VGND VPWR VPWR sky130_fd_sc_hd__fill_1
X_7749_ carry4\[9\] sum4\[10\] VGND VGND VPWR VPWR _0653_ sky130_fd_sc_hd__nor2_1
XFILLER_0_19_453 VGND VGND VPWR VPWR sky130_fd_sc_hd__fill_1
XFILLER_0_117_683 VPWR VGND VPWR VGND sky130_ef_sc_hd__decap_12
XFILLER_0_61_264 VGND VGND VPWR VPWR sky130_fd_sc_hd__fill_1
XFILLER_0_15_670 VGND VGND VPWR VPWR sky130_fd_sc_hd__fill_2
XFILLER_0_22_629 VGND VGND VPWR VPWR sky130_fd_sc_hd__decap_3
XFILLER_0_30_640 VGND VGND VPWR VPWR sky130_fd_sc_hd__fill_1
XFILLER_0_30_673 VPWR VGND VPWR VGND sky130_ef_sc_hd__decap_12
XFILLER_0_100_572 VPWR VGND VPWR VGND sky130_ef_sc_hd__decap_12
XFILLER_0_107_28 VGND VGND VPWR VPWR sky130_fd_sc_hd__decap_6
XFILLER_0_16_15 VPWR VGND VPWR VGND sky130_ef_sc_hd__decap_12
XFILLER_0_69_397 VGND VGND VPWR VPWR sky130_fd_sc_hd__fill_1
XTAP_1040 VGND VPWR sky130_fd_sc_hd__tapvpwrvgnd_1
XTAP_1073 VGND VPWR sky130_fd_sc_hd__tapvpwrvgnd_1
XTAP_1062 VGND VPWR sky130_fd_sc_hd__tapvpwrvgnd_1
XTAP_1051 VGND VPWR sky130_fd_sc_hd__tapvpwrvgnd_1
XTAP_1095 VGND VPWR sky130_fd_sc_hd__tapvpwrvgnd_1
XTAP_1084 VGND VPWR sky130_fd_sc_hd__tapvpwrvgnd_1
XFILLER_0_44_209 VGND VGND VPWR VPWR sky130_fd_sc_hd__fill_1
XFILLER_0_108_661 VGND VGND VPWR VPWR sky130_fd_sc_hd__fill_1
XFILLER_0_65_592 VGND VGND VPWR VPWR sky130_fd_sc_hd__decap_4
XFILLER_0_53_732 VGND VGND VPWR VPWR sky130_fd_sc_hd__decap_3
XFILLER_0_123_620 VPWR VGND VPWR VGND sky130_ef_sc_hd__decap_12
XFILLER_0_52_253 VPWR VGND VPWR VGND sky130_ef_sc_hd__decap_12
XFILLER_0_123_664 VGND VGND VPWR VPWR sky130_fd_sc_hd__decap_8
XFILLER_0_12_117 VGND VGND VPWR VPWR sky130_fd_sc_hd__decap_4
XFILLER_0_12_106 VGND VGND VPWR VPWR sky130_fd_sc_hd__decap_3
XFILLER_0_123_697 VGND VGND VPWR VPWR sky130_fd_sc_hd__decap_3
XFILLER_0_122_141 VPWR VGND VPWR VGND sky130_ef_sc_hd__decap_12
XFILLER_0_12_128 VPWR VGND VPWR VGND sky130_ef_sc_hd__decap_12
XFILLER_0_0_501 VGND VGND VPWR VPWR sky130_fd_sc_hd__decap_3
XFILLER_0_40_459 VGND VGND VPWR VPWR sky130_fd_sc_hd__fill_1
XFILLER_0_0_545 VPWR VGND VPWR VGND sky130_ef_sc_hd__decap_12
XFILLER_0_21_673 VPWR VGND VPWR VGND sky130_ef_sc_hd__decap_12
X_6080_ _2926_ _2927_ _3033_ VGND VGND VPWR VPWR _3087_ sky130_fd_sc_hd__o21ai_1
XFILLER_0_0_589 VPWR VGND VPWR VGND sky130_ef_sc_hd__decap_12
X_5100_ _2120_ _2121_ _2128_ VGND VGND VPWR VPWR _2129_ sky130_fd_sc_hd__a21boi_4
XTAP_802 VGND VPWR sky130_fd_sc_hd__tapvpwrvgnd_1
XTAP_813 VGND VPWR sky130_fd_sc_hd__tapvpwrvgnd_1
XTAP_824 VGND VPWR sky130_fd_sc_hd__tapvpwrvgnd_1
XTAP_835 VGND VPWR sky130_fd_sc_hd__tapvpwrvgnd_1
X_5031_ sh0\[2\] VGND VGND VPWR VPWR _2061_ sky130_fd_sc_hd__clkbuf_4
XTAP_846 VGND VPWR sky130_fd_sc_hd__tapvpwrvgnd_1
XTAP_857 VGND VPWR sky130_fd_sc_hd__tapvpwrvgnd_1
XTAP_868 VGND VPWR sky130_fd_sc_hd__tapvpwrvgnd_1
XTAP_879 VGND VPWR sky130_fd_sc_hd__tapvpwrvgnd_1
XFILLER_0_73_54 VGND VGND VPWR VPWR sky130_fd_sc_hd__fill_2
X_8721_ clknet_leaf_14_clk _0128_ _0472_ VGND VGND VPWR VPWR bit_sum5\[2\] sky130_fd_sc_hd__dfrtp_1
X_6982_ sh1\[1\] sh5\[1\] sh6\[1\] VGND VGND VPWR VPWR _3968_ sky130_fd_sc_hd__o21ai_4
X_5933_ _2940_ _2941_ VGND VGND VPWR VPWR _2942_ sky130_fd_sc_hd__nand2_1
XFILLER_0_88_695 VGND VGND VPWR VPWR sky130_fd_sc_hd__decap_4
XFILLER_0_118_414 VGND VGND VPWR VPWR sky130_fd_sc_hd__decap_6
X_5864_ _2872_ _2873_ VGND VGND VPWR VPWR _2874_ sky130_fd_sc_hd__nand2_2
X_8652_ clknet_leaf_29_clk net146 _0403_ VGND VGND VPWR VPWR s6\[8\] sky130_fd_sc_hd__dfrtp_1
XFILLER_0_75_345 VGND VGND VPWR VPWR sky130_fd_sc_hd__decap_4
XFILLER_0_75_334 VGND VGND VPWR VPWR sky130_fd_sc_hd__fill_2
XFILLER_0_48_559 VGND VGND VPWR VPWR sky130_fd_sc_hd__decap_8
XFILLER_0_118_436 VPWR VGND VPWR VGND sky130_ef_sc_hd__decap_12
X_4815_ _1784_ _1780_ _1786_ VGND VGND VPWR VPWR _1851_ sky130_fd_sc_hd__o21ai_4
X_7603_ _4167_ VGND VGND VPWR VPWR _0593_ sky130_fd_sc_hd__inv_2
XFILLER_0_8_645 VPWR VGND VPWR VGND sky130_ef_sc_hd__decap_12
XFILLER_0_8_623 VPWR VGND VPWR VGND sky130_ef_sc_hd__decap_12
XFILLER_0_7_111 VGND VGND VPWR VPWR sky130_fd_sc_hd__fill_1
X_8583_ clknet_leaf_35_clk net368 _0334_ VGND VGND VPWR VPWR carry1\[6\] sky130_fd_sc_hd__dfrtp_1
X_7534_ _4161_ VGND VGND VPWR VPWR _0530_ sky130_fd_sc_hd__inv_2
XFILLER_0_16_412 VGND VGND VPWR VPWR sky130_fd_sc_hd__decap_4
X_5795_ _2726_ _2804_ _2757_ VGND VGND VPWR VPWR _2810_ sky130_fd_sc_hd__o21a_1
X_4746_ _1769_ _1773_ _1780_ _1782_ VGND VGND VPWR VPWR _1783_ sky130_fd_sc_hd__o22ai_4
XFILLER_0_113_93 VGND VGND VPWR VPWR sky130_fd_sc_hd__decap_4
XFILLER_0_105_108 VGND VGND VPWR VPWR sky130_fd_sc_hd__fill_1
XFILLER_0_43_231 VGND VGND VPWR VPWR sky130_fd_sc_hd__decap_8
XFILLER_0_114_653 VGND VGND VPWR VPWR sky130_fd_sc_hd__fill_1
X_4677_ _1710_ _1714_ VGND VGND VPWR VPWR _1715_ sky130_fd_sc_hd__nand2_1
X_7465_ _4147_ VGND VGND VPWR VPWR _4154_ sky130_fd_sc_hd__buf_4
XFILLER_0_113_141 VGND VGND VPWR VPWR sky130_fd_sc_hd__fill_1
X_7396_ _4146_ VGND VGND VPWR VPWR _0407_ sky130_fd_sc_hd__inv_2
X_6416_ _3414_ _3412_ VGND VGND VPWR VPWR _3415_ sky130_fd_sc_hd__nand2_1
XFILLER_0_3_361 VPWR VGND VPWR VGND sky130_ef_sc_hd__decap_12
X_6347_ _3295_ _3297_ _3329_ VGND VGND VPWR VPWR _3346_ sky130_fd_sc_hd__a21oi_1
Xoutput17 net17 VGND VGND VPWR VPWR led[1] sky130_fd_sc_hd__clkbuf_4
XFILLER_0_101_358 VGND VGND VPWR VPWR sky130_fd_sc_hd__decap_4
XFILLER_0_12_684 VPWR VGND VPWR VGND sky130_ef_sc_hd__decap_12
X_6278_ _3278_ _3280_ VGND VGND VPWR VPWR _0143_ sky130_fd_sc_hd__nor2_2
X_8017_ _0863_ _0864_ _0748_ VGND VGND VPWR VPWR _0865_ sky130_fd_sc_hd__o21ba_1
X_5229_ _2110_ _2253_ _2254_ _2255_ VGND VGND VPWR VPWR _2256_ sky130_fd_sc_hd__a22oi_4
XFILLER_0_79_684 VGND VGND VPWR VPWR sky130_fd_sc_hd__decap_6
XFILLER_0_79_673 VGND VGND VPWR VPWR sky130_fd_sc_hd__decap_8
XFILLER_0_39_526 VPWR VGND VPWR VGND sky130_ef_sc_hd__decap_12
XFILLER_0_109_414 VPWR VGND VPWR VGND sky130_ef_sc_hd__decap_12
XFILLER_0_94_643 VGND VGND VPWR VPWR sky130_fd_sc_hd__fill_1
XPHY_134 VGND VGND VPWR VPWR sky130_fd_sc_hd__decap_3
XPHY_123 VGND VGND VPWR VPWR sky130_fd_sc_hd__decap_3
XPHY_112 VGND VGND VPWR VPWR sky130_fd_sc_hd__decap_3
XFILLER_0_39_559 VGND VGND VPWR VPWR sky130_fd_sc_hd__fill_1
XPHY_101 VGND VGND VPWR VPWR sky130_fd_sc_hd__decap_3
XPHY_167 VGND VGND VPWR VPWR sky130_fd_sc_hd__decap_3
XPHY_156 VGND VGND VPWR VPWR sky130_fd_sc_hd__decap_3
XPHY_145 VGND VGND VPWR VPWR sky130_fd_sc_hd__decap_3
XPHY_189 VGND VGND VPWR VPWR sky130_fd_sc_hd__decap_3
XPHY_178 VGND VGND VPWR VPWR sky130_fd_sc_hd__decap_3
XFILLER_0_81_348 VGND VGND VPWR VPWR sky130_fd_sc_hd__decap_8
XFILLER_0_81_337 VGND VGND VPWR VPWR sky130_fd_sc_hd__decap_4
XFILLER_0_81_315 VPWR VGND VPWR VGND sky130_ef_sc_hd__decap_12
XFILLER_0_35_721 VGND VGND VPWR VPWR sky130_fd_sc_hd__decap_6
XFILLER_0_35_732 VGND VGND VPWR VPWR sky130_fd_sc_hd__decap_3
XFILLER_0_47_581 VPWR VGND VPWR VGND sky130_ef_sc_hd__decap_12
XFILLER_0_117_480 VGND VGND VPWR VPWR sky130_fd_sc_hd__decap_4
XFILLER_0_34_242 VGND VGND VPWR VPWR sky130_fd_sc_hd__decap_8
XFILLER_0_105_653 VPWR VGND VPWR VGND sky130_ef_sc_hd__decap_12
XFILLER_0_22_404 VPWR VGND VPWR VGND sky130_ef_sc_hd__decap_12
XFILLER_0_34_264 VGND VGND VPWR VPWR sky130_fd_sc_hd__decap_8
XFILLER_0_120_612 VPWR VGND VPWR VGND sky130_ef_sc_hd__decap_12
XFILLER_0_105_697 VGND VGND VPWR VPWR sky130_fd_sc_hd__decap_8
XFILLER_0_104_141 VGND VGND VPWR VPWR sky130_fd_sc_hd__decap_3
XFILLER_0_120_667 VPWR VGND VPWR VGND sky130_ef_sc_hd__decap_12
XFILLER_0_118_27 VGND VGND VPWR VPWR sky130_fd_sc_hd__fill_1
XFILLER_0_76_109 VPWR VGND VPWR VGND sky130_ef_sc_hd__decap_12
XPHY_3 VGND VGND VPWR VPWR sky130_fd_sc_hd__decap_3
XFILLER_0_85_654 VGND VGND VPWR VPWR sky130_fd_sc_hd__decap_3
XFILLER_0_57_334 VGND VGND VPWR VPWR sky130_fd_sc_hd__fill_2
XFILLER_0_43_57 VPWR VGND VPWR VGND sky130_ef_sc_hd__decap_12
X_4600_ _1638_ VGND VGND VPWR VPWR _1639_ sky130_fd_sc_hd__buf_4
XFILLER_0_111_3 VGND VGND VPWR VPWR sky130_fd_sc_hd__decap_8
XFILLER_0_5_615 VGND VGND VPWR VPWR sky130_fd_sc_hd__fill_1
X_5580_ _2544_ _2546_ _2598_ VGND VGND VPWR VPWR _2599_ sky130_fd_sc_hd__and3_1
X_4531_ _1277_ _1506_ _1331_ VGND VGND VPWR VPWR _1575_ sky130_fd_sc_hd__o21ai_4
XFILLER_0_13_426 VGND VGND VPWR VPWR sky130_fd_sc_hd__fill_1
XFILLER_0_123_461 VPWR VGND VPWR VGND sky130_ef_sc_hd__decap_12
X_4462_ _1277_ _1506_ _1331_ VGND VGND VPWR VPWR _1507_ sky130_fd_sc_hd__o21a_1
X_7250_ _4132_ VGND VGND VPWR VPWR _0275_ sky130_fd_sc_hd__inv_2
Xhold316 _0041_ VGND VGND VPWR VPWR net358 sky130_fd_sc_hd__dlygate4sd3_1
Xhold305 sh7\[1\] VGND VGND VPWR VPWR net347 sky130_fd_sc_hd__dlygate4sd3_1
X_6201_ _3193_ _3194_ _3196_ _3202_ _3205_ VGND VGND VPWR VPWR _3206_ sky130_fd_sc_hd__o2111ai_4
Xhold338 _0043_ VGND VGND VPWR VPWR net380 sky130_fd_sc_hd__dlygate4sd3_1
XFILLER_0_7_57 VPWR VGND VPWR VGND sky130_ef_sc_hd__decap_12
Xhold327 sum1\[9\] VGND VGND VPWR VPWR net369 sky130_fd_sc_hd__dlygate4sd3_1
Xhold349 sum1\[4\] VGND VGND VPWR VPWR net391 sky130_fd_sc_hd__dlygate4sd3_1
X_4393_ _1436_ _1437_ _1434_ _1438_ VGND VGND VPWR VPWR _1439_ sky130_fd_sc_hd__o211ai_4
X_7181_ _4126_ VGND VGND VPWR VPWR _0212_ sky130_fd_sc_hd__inv_2
X_6132_ _2878_ _2894_ VGND VGND VPWR VPWR _3138_ sky130_fd_sc_hd__and2_4
XTAP_621 VGND VPWR sky130_fd_sc_hd__tapvpwrvgnd_1
XTAP_610 VGND VPWR sky130_fd_sc_hd__tapvpwrvgnd_1
XTAP_632 VGND VPWR sky130_fd_sc_hd__tapvpwrvgnd_1
XTAP_643 VGND VPWR sky130_fd_sc_hd__tapvpwrvgnd_1
X_6063_ _3070_ VGND VGND VPWR VPWR _0138_ sky130_fd_sc_hd__clkbuf_1
XTAP_654 VGND VPWR sky130_fd_sc_hd__tapvpwrvgnd_1
XTAP_665 VGND VPWR sky130_fd_sc_hd__tapvpwrvgnd_1
XTAP_676 VGND VPWR sky130_fd_sc_hd__tapvpwrvgnd_1
XFILLER_0_84_53 VPWR VGND VPWR VGND sky130_ef_sc_hd__decap_12
X_5014_ _2042_ _2039_ _2043_ VGND VGND VPWR VPWR _2044_ sky130_fd_sc_hd__o21ai_4
XTAP_687 VGND VPWR sky130_fd_sc_hd__tapvpwrvgnd_1
XTAP_698 VGND VPWR sky130_fd_sc_hd__tapvpwrvgnd_1
XFILLER_0_84_97 VPWR VGND VPWR VGND sky130_ef_sc_hd__decap_12
XFILLER_0_16_3 VPWR VGND VPWR VGND sky130_ef_sc_hd__decap_12
XTAP_1809 VGND VPWR sky130_fd_sc_hd__tapvpwrvgnd_1
X_6965_ _3880_ _3899_ VGND VGND VPWR VPWR _3952_ sky130_fd_sc_hd__nand2_1
X_5916_ sh7\[6\] sh8\[6\] VGND VGND VPWR VPWR _2925_ sky130_fd_sc_hd__and2_1
XFILLER_0_76_643 VGND VGND VPWR VPWR sky130_fd_sc_hd__fill_1
X_8704_ clknet_leaf_0_clk _0113_ _0455_ VGND VGND VPWR VPWR bit_sum3\[5\] sky130_fd_sc_hd__dfrtp_1
XFILLER_0_118_200 VPWR VGND VPWR VGND sky130_ef_sc_hd__decap_12
XFILLER_0_91_602 VPWR VGND VPWR VGND sky130_ef_sc_hd__decap_12
XFILLER_0_76_676 VGND VGND VPWR VPWR sky130_fd_sc_hd__decap_3
X_8635_ clknet_leaf_32_clk net117 _0386_ VGND VGND VPWR VPWR s4\[9\] sky130_fd_sc_hd__dfrtp_1
X_6896_ _3876_ _3878_ _3883_ VGND VGND VPWR VPWR _3884_ sky130_fd_sc_hd__o21bai_2
XFILLER_0_75_186 VGND VGND VPWR VPWR sky130_fd_sc_hd__decap_4
XFILLER_0_63_337 VGND VGND VPWR VPWR sky130_fd_sc_hd__decap_8
XFILLER_0_17_721 VGND VGND VPWR VPWR sky130_fd_sc_hd__decap_6
XFILLER_0_17_732 VGND VGND VPWR VPWR sky130_fd_sc_hd__decap_3
X_5847_ _2761_ _2765_ _2766_ VGND VGND VPWR VPWR _2860_ sky130_fd_sc_hd__a21oi_1
XFILLER_0_36_529 VGND VGND VPWR VPWR sky130_fd_sc_hd__decap_3
XFILLER_0_90_145 VGND VGND VPWR VPWR sky130_fd_sc_hd__fill_1
XFILLER_0_63_348 VPWR VGND VPWR VGND sky130_ef_sc_hd__decap_12
X_5778_ _2789_ _2792_ VGND VGND VPWR VPWR _2793_ sky130_fd_sc_hd__nand2_2
X_8566_ clknet_leaf_37_clk net65 _0317_ VGND VGND VPWR VPWR sum2\[1\] sky130_fd_sc_hd__dfrtp_1
X_4729_ _1765_ _1766_ VGND VGND VPWR VPWR _0182_ sky130_fd_sc_hd__nor2_1
X_8497_ clknet_leaf_40_clk net107 _0248_ VGND VGND VPWR VPWR final_sum\[3\] sky130_fd_sc_hd__dfrtp_1
X_7517_ _4159_ VGND VGND VPWR VPWR _0515_ sky130_fd_sc_hd__inv_2
XFILLER_0_16_253 VGND VGND VPWR VPWR sky130_fd_sc_hd__fill_1
XFILLER_0_32_713 VPWR VGND VPWR VGND sky130_ef_sc_hd__decap_12
XFILLER_0_44_584 VGND VGND VPWR VPWR sky130_fd_sc_hd__decap_4
XFILLER_0_102_612 VPWR VGND VPWR VGND sky130_ef_sc_hd__decap_12
X_7448_ _4152_ VGND VGND VPWR VPWR _0453_ sky130_fd_sc_hd__inv_2
XFILLER_0_16_286 VGND VGND VPWR VPWR sky130_fd_sc_hd__fill_2
XFILLER_0_102_645 VPWR VGND VPWR VGND sky130_ef_sc_hd__decap_12
XFILLER_0_101_111 VGND VGND VPWR VPWR sky130_fd_sc_hd__fill_1
XFILLER_0_4_681 VPWR VGND VPWR VGND sky130_ef_sc_hd__decap_12
XFILLER_0_31_278 VGND VGND VPWR VPWR sky130_fd_sc_hd__fill_2
X_7379_ _4145_ VGND VGND VPWR VPWR _0391_ sky130_fd_sc_hd__inv_2
XFILLER_0_98_245 VGND VGND VPWR VPWR sky130_fd_sc_hd__decap_6
XFILLER_0_98_234 VGND VGND VPWR VPWR sky130_fd_sc_hd__decap_4
XFILLER_0_109_222 VGND VGND VPWR VPWR sky130_fd_sc_hd__fill_2
XFILLER_0_104_29 VGND VGND VPWR VPWR sky130_fd_sc_hd__decap_3
XFILLER_0_13_27 VPWR VGND VPWR VGND sky130_ef_sc_hd__decap_12
XFILLER_0_82_657 VPWR VGND VPWR VGND sky130_ef_sc_hd__decap_12
XFILLER_0_54_359 VGND VGND VPWR VPWR sky130_fd_sc_hd__decap_4
XFILLER_0_81_167 VGND VGND VPWR VPWR sky130_fd_sc_hd__fill_1
XFILLER_0_10_418 VGND VGND VPWR VPWR sky130_fd_sc_hd__fill_2
XFILLER_0_54_23 VGND VGND VPWR VPWR sky130_fd_sc_hd__decap_4
XFILLER_0_49_109 VGND VGND VPWR VPWR sky130_fd_sc_hd__decap_3
XFILLER_0_58_643 VGND VGND VPWR VPWR sky130_fd_sc_hd__fill_1
X_6750_ sh0\[1\] VGND VGND VPWR VPWR _3739_ sky130_fd_sc_hd__inv_2
XFILLER_0_9_217 VGND VGND VPWR VPWR sky130_fd_sc_hd__decap_6
X_5701_ _2713_ _2714_ _2711_ _2708_ VGND VGND VPWR VPWR _2718_ sky130_fd_sc_hd__o211ai_2
X_6681_ _3673_ _3674_ _3635_ VGND VGND VPWR VPWR _3675_ sky130_fd_sc_hd__o21ai_2
X_8420_ _1245_ _1248_ _1249_ VGND VGND VPWR VPWR _1250_ sky130_fd_sc_hd__nor3_1
X_5632_ _2644_ _2648_ net453 VGND VGND VPWR VPWR _2650_ sky130_fd_sc_hd__and3_1
XFILLER_0_45_359 VGND VGND VPWR VPWR sky130_fd_sc_hd__decap_6
XFILLER_0_115_247 VGND VGND VPWR VPWR sky130_fd_sc_hd__decap_8
XFILLER_0_115_225 VGND VGND VPWR VPWR sky130_fd_sc_hd__decap_8
X_8351_ _1174_ _1176_ _1185_ VGND VGND VPWR VPWR _1187_ sky130_fd_sc_hd__o21a_1
XFILLER_0_14_713 VPWR VGND VPWR VGND sky130_ef_sc_hd__decap_12
X_5563_ _2559_ _2560_ _2562_ VGND VGND VPWR VPWR _2582_ sky130_fd_sc_hd__o21ai_1
XFILLER_0_26_562 VGND VGND VPWR VPWR sky130_fd_sc_hd__decap_3
XFILLER_0_26_584 VGND VGND VPWR VPWR sky130_fd_sc_hd__decap_4
X_4514_ _1546_ _1548_ _1554_ _1557_ VGND VGND VPWR VPWR _1558_ sky130_fd_sc_hd__o22ai_4
X_7302_ _4138_ VGND VGND VPWR VPWR _0321_ sky130_fd_sc_hd__inv_2
Xhold124 sh13\[5\] VGND VGND VPWR VPWR net166 sky130_fd_sc_hd__dlygate4sd3_1
Xhold113 bit_sum6\[6\] VGND VGND VPWR VPWR net155 sky130_fd_sc_hd__dlygate4sd3_1
X_8282_ _1103_ _1107_ _1104_ VGND VGND VPWR VPWR _1125_ sky130_fd_sc_hd__o21ba_1
XFILLER_0_13_256 VGND VGND VPWR VPWR sky130_fd_sc_hd__decap_3
X_5494_ _2479_ sh2\[0\] VGND VGND VPWR VPWR _2513_ sky130_fd_sc_hd__and2_2
Xhold102 sh1\[2\] VGND VGND VPWR VPWR net144 sky130_fd_sc_hd__dlygate4sd3_1
Xhold135 final_sum\[1\] VGND VGND VPWR VPWR net177 sky130_fd_sc_hd__dlygate4sd3_1
X_4445_ _1487_ _1489_ _1246_ VGND VGND VPWR VPWR _1490_ sky130_fd_sc_hd__o21bai_2
Xhold157 sh11\[7\] VGND VGND VPWR VPWR net199 sky130_fd_sc_hd__dlygate4sd3_1
X_7233_ _4131_ VGND VGND VPWR VPWR _0259_ sky130_fd_sc_hd__inv_2
Xhold146 sh11\[4\] VGND VGND VPWR VPWR net188 sky130_fd_sc_hd__dlygate4sd3_1
Xhold168 s3\[7\] VGND VGND VPWR VPWR net210 sky130_fd_sc_hd__dlygate4sd3_1
X_4376_ _1234_ _1419_ _1420_ _1421_ VGND VGND VPWR VPWR _1422_ sky130_fd_sc_hd__o211ai_4
X_7164_ _4123_ VGND VGND VPWR VPWR _0198_ sky130_fd_sc_hd__inv_2
Xhold179 _0074_ VGND VGND VPWR VPWR net221 sky130_fd_sc_hd__dlygate4sd3_1
XFILLER_0_1_673 VPWR VGND VPWR VGND sky130_ef_sc_hd__decap_12
X_6115_ _3116_ _3119_ _3121_ VGND VGND VPWR VPWR _3122_ sky130_fd_sc_hd__a21oi_1
XFILLER_0_95_63 VGND VGND VPWR VPWR sky130_fd_sc_hd__decap_3
XTAP_451 VGND VPWR sky130_fd_sc_hd__tapvpwrvgnd_1
XTAP_440 VGND VPWR sky130_fd_sc_hd__tapvpwrvgnd_1
XFILLER_0_119_81 VPWR VGND VPWR VGND sky130_ef_sc_hd__decap_12
X_7095_ _4069_ _4070_ _4076_ _4078_ VGND VGND VPWR VPWR _4079_ sky130_fd_sc_hd__o211ai_4
XTAP_462 VGND VPWR sky130_fd_sc_hd__tapvpwrvgnd_1
XTAP_473 VGND VPWR sky130_fd_sc_hd__tapvpwrvgnd_1
XTAP_484 VGND VPWR sky130_fd_sc_hd__tapvpwrvgnd_1
X_6046_ _3050_ _3053_ _3044_ VGND VGND VPWR VPWR _3054_ sky130_fd_sc_hd__o21ai_2
XTAP_495 VGND VPWR sky130_fd_sc_hd__tapvpwrvgnd_1
XTAP_1606 VGND VPWR sky130_fd_sc_hd__tapvpwrvgnd_1
XFILLER_0_68_407 VGND VGND VPWR VPWR sky130_fd_sc_hd__fill_2
XTAP_1628 VGND VPWR sky130_fd_sc_hd__tapvpwrvgnd_1
XTAP_1639 VGND VPWR sky130_fd_sc_hd__tapvpwrvgnd_1
XTAP_1617 VGND VPWR sky130_fd_sc_hd__tapvpwrvgnd_1
XFILLER_0_95_237 VGND VGND VPWR VPWR sky130_fd_sc_hd__decap_6
X_7997_ _0835_ _0838_ _0845_ VGND VGND VPWR VPWR _0846_ sky130_fd_sc_hd__o21ai_2
X_6948_ _3930_ _3934_ _3931_ VGND VGND VPWR VPWR _3935_ sky130_fd_sc_hd__o21bai_1
XFILLER_0_119_542 VPWR VGND VPWR VGND sky130_ef_sc_hd__decap_12
X_6879_ _3866_ _3864_ _3862_ VGND VGND VPWR VPWR _3867_ sky130_fd_sc_hd__a21o_1
XFILLER_0_36_315 VGND VGND VPWR VPWR sky130_fd_sc_hd__fill_1
XFILLER_0_49_698 VGND VGND VPWR VPWR sky130_fd_sc_hd__fill_1
XFILLER_0_107_726 VGND VGND VPWR VPWR sky130_fd_sc_hd__fill_2
XFILLER_0_106_214 VGND VGND VPWR VPWR sky130_fd_sc_hd__decap_8
XFILLER_0_8_250 VGND VGND VPWR VPWR sky130_fd_sc_hd__fill_2
X_8618_ clknet_leaf_56_clk net67 _0369_ VGND VGND VPWR VPWR s2\[10\] sky130_fd_sc_hd__dfrtp_1
XFILLER_0_91_498 VGND VGND VPWR VPWR sky130_fd_sc_hd__decap_3
XFILLER_0_91_476 VGND VGND VPWR VPWR sky130_fd_sc_hd__decap_8
X_8549_ clknet_leaf_31_clk net262 _0300_ VGND VGND VPWR VPWR carry2\[11\] sky130_fd_sc_hd__dfrtp_1
XFILLER_0_121_217 VGND VGND VPWR VPWR sky130_fd_sc_hd__decap_6
XFILLER_0_32_587 VGND VGND VPWR VPWR sky130_fd_sc_hd__fill_1
XFILLER_0_5_3 VPWR VGND VPWR VGND sky130_ef_sc_hd__decap_12
XFILLER_0_87_705 VGND VGND VPWR VPWR sky130_fd_sc_hd__decap_3
XFILLER_0_24_15 VPWR VGND VPWR VGND sky130_ef_sc_hd__decap_12
XFILLER_0_115_39 VPWR VGND VPWR VGND sky130_ef_sc_hd__decap_12
XFILLER_0_94_270 VGND VGND VPWR VPWR sky130_fd_sc_hd__fill_2
XFILLER_0_82_421 VGND VGND VPWR VPWR sky130_fd_sc_hd__fill_1
XFILLER_0_82_410 VGND VGND VPWR VPWR sky130_fd_sc_hd__fill_1
XFILLER_0_67_484 VPWR VGND VPWR VGND sky130_ef_sc_hd__decap_12
XFILLER_0_6_209 VPWR VGND VPWR VGND sky130_ef_sc_hd__decap_12
XFILLER_0_27_337 VGND VGND VPWR VPWR sky130_fd_sc_hd__decap_8
XFILLER_0_54_189 VGND VGND VPWR VPWR sky130_fd_sc_hd__decap_6
XFILLER_0_23_521 VGND VGND VPWR VPWR sky130_fd_sc_hd__fill_2
XFILLER_0_2_415 VGND VGND VPWR VPWR sky130_fd_sc_hd__decap_4
XFILLER_0_105_291 VPWR VGND VPWR VGND sky130_ef_sc_hd__decap_12
XFILLER_0_11_727 VGND VGND VPWR VPWR sky130_fd_sc_hd__fill_1
XFILLER_0_23_587 VPWR VGND VPWR VGND sky130_ef_sc_hd__decap_12
XFILLER_0_120_272 VGND VGND VPWR VPWR sky130_fd_sc_hd__decap_6
X_4230_ net34 net32 VGND VGND VPWR VPWR _1278_ sky130_fd_sc_hd__nor2_1
XFILLER_0_10_248 VGND VGND VPWR VPWR sky130_fd_sc_hd__decap_4
XFILLER_0_10_237 VGND VGND VPWR VPWR sky130_fd_sc_hd__decap_3
X_7920_ _0748_ _0762_ VGND VGND VPWR VPWR _0769_ sky130_fd_sc_hd__nand2_1
XFILLER_0_78_727 VGND VGND VPWR VPWR sky130_fd_sc_hd__decap_8
X_7851_ carry4\[7\] s6\[8\] net258 VGND VGND VPWR VPWR _0711_ sky130_fd_sc_hd__o21a_1
X_6802_ _3766_ _3763_ _3789_ _3788_ _3769_ VGND VGND VPWR VPWR _3791_ sky130_fd_sc_hd__o221a_1
X_4994_ _1993_ _2019_ _2020_ VGND VGND VPWR VPWR _2026_ sky130_fd_sc_hd__a21o_1
X_7782_ carry2\[7\] net287 _0676_ VGND VGND VPWR VPWR _0028_ sky130_fd_sc_hd__o21a_1
X_6733_ sh5\[1\] sh7\[1\] VGND VGND VPWR VPWR _3723_ sky130_fd_sc_hd__and2_2
X_6664_ _3612_ _3611_ _3657_ VGND VGND VPWR VPWR _3658_ sky130_fd_sc_hd__o21ai_4
XFILLER_0_46_657 VPWR VGND VPWR VGND sky130_ef_sc_hd__decap_12
X_8403_ sh1\[5\] sh0\[5\] VGND VGND VPWR VPWR _1233_ sky130_fd_sc_hd__and2_1
X_5615_ _2629_ _2622_ _2627_ _2623_ VGND VGND VPWR VPWR _2633_ sky130_fd_sc_hd__o211ai_4
XFILLER_0_116_578 VGND VGND VPWR VPWR sky130_fd_sc_hd__decap_8
XFILLER_0_83_3 VPWR VGND VPWR VGND sky130_ef_sc_hd__decap_12
X_6595_ _3584_ _3589_ _3590_ VGND VGND VPWR VPWR _3591_ sky130_fd_sc_hd__a21o_1
XFILLER_0_60_115 VGND VGND VPWR VPWR sky130_fd_sc_hd__decap_6
XFILLER_0_14_510 VGND VGND VPWR VPWR sky130_fd_sc_hd__fill_1
XFILLER_0_121_93 VPWR VGND VPWR VGND sky130_ef_sc_hd__decap_12
X_8334_ _1168_ _1169_ carry5\[9\] VGND VGND VPWR VPWR _1171_ sky130_fd_sc_hd__o21bai_1
X_5546_ _2479_ _2482_ VGND VGND VPWR VPWR _2565_ sky130_fd_sc_hd__nand2_1
X_8265_ _1105_ _1108_ VGND VGND VPWR VPWR _1109_ sky130_fd_sc_hd__nand2_1
X_5477_ _2483_ _2486_ _2487_ VGND VGND VPWR VPWR _2497_ sky130_fd_sc_hd__a21o_1
XFILLER_0_14_587 VGND VGND VPWR VPWR sky130_fd_sc_hd__fill_1
XFILLER_0_41_384 VGND VGND VPWR VPWR sky130_fd_sc_hd__decap_8
X_7216_ _4129_ VGND VGND VPWR VPWR _0244_ sky130_fd_sc_hd__inv_2
XFILLER_0_111_261 VPWR VGND VPWR VGND sky130_ef_sc_hd__decap_12
X_4428_ _1471_ _1472_ _1473_ VGND VGND VPWR VPWR _1474_ sky130_fd_sc_hd__a21oi_2
X_8196_ _1039_ _1041_ VGND VGND VPWR VPWR _1042_ sky130_fd_sc_hd__nand2_1
X_4359_ _1312_ _1275_ _1313_ _1314_ VGND VGND VPWR VPWR _1406_ sky130_fd_sc_hd__a211o_1
X_7147_ net207 _4118_ VGND VGND VPWR VPWR _0058_ sky130_fd_sc_hd__xnor2_1
XTAP_281 VGND VPWR sky130_fd_sc_hd__tapvpwrvgnd_1
XTAP_270 VGND VPWR sky130_fd_sc_hd__tapvpwrvgnd_1
XTAP_292 VGND VPWR sky130_fd_sc_hd__tapvpwrvgnd_1
X_7078_ _3955_ _3959_ _4010_ VGND VGND VPWR VPWR _4063_ sky130_fd_sc_hd__o21ai_2
X_6029_ sh8\[6\] sh9\[6\] VGND VGND VPWR VPWR _3037_ sky130_fd_sc_hd__nand2_1
XTAP_1414 VGND VPWR sky130_fd_sc_hd__tapvpwrvgnd_1
XTAP_1403 VGND VPWR sky130_fd_sc_hd__tapvpwrvgnd_1
XTAP_1447 VGND VPWR sky130_fd_sc_hd__tapvpwrvgnd_1
XTAP_1436 VGND VPWR sky130_fd_sc_hd__tapvpwrvgnd_1
XTAP_1425 VGND VPWR sky130_fd_sc_hd__tapvpwrvgnd_1
XTAP_1469 VGND VPWR sky130_fd_sc_hd__tapvpwrvgnd_1
XTAP_1458 VGND VPWR sky130_fd_sc_hd__tapvpwrvgnd_1
XFILLER_0_83_229 VGND VGND VPWR VPWR sky130_fd_sc_hd__fill_2
Xfanout30 sh11\[0\] VGND VGND VPWR VPWR net30 sky130_fd_sc_hd__clkbuf_4
XFILLER_0_37_613 VGND VGND VPWR VPWR sky130_fd_sc_hd__decap_3
XFILLER_0_119_361 VPWR VGND VPWR VGND sky130_ef_sc_hd__decap_12
Xfanout41 sh1\[7\] VGND VGND VPWR VPWR net41 sky130_fd_sc_hd__clkbuf_4
XFILLER_0_64_421 VGND VGND VPWR VPWR sky130_fd_sc_hd__decap_4
XFILLER_0_36_134 VGND VGND VPWR VPWR sky130_fd_sc_hd__decap_6
XFILLER_0_91_240 VGND VGND VPWR VPWR sky130_fd_sc_hd__fill_1
XFILLER_0_9_581 VGND VGND VPWR VPWR sky130_fd_sc_hd__fill_2
XFILLER_0_51_159 VGND VGND VPWR VPWR sky130_fd_sc_hd__fill_1
XFILLER_0_32_362 VGND VGND VPWR VPWR sky130_fd_sc_hd__fill_2
XFILLER_0_102_294 VPWR VGND VPWR VGND sky130_ef_sc_hd__decap_12
XFILLER_0_19_15 VPWR VGND VPWR VGND sky130_ef_sc_hd__decap_12
XFILLER_0_87_513 VGND VGND VPWR VPWR sky130_fd_sc_hd__decap_8
XFILLER_0_67_281 VGND VGND VPWR VPWR sky130_fd_sc_hd__decap_4
XFILLER_0_28_668 VPWR VGND VPWR VGND sky130_ef_sc_hd__decap_12
XFILLER_0_51_57 VGND VGND VPWR VPWR sky130_fd_sc_hd__fill_1
XFILLER_0_82_251 VGND VGND VPWR VPWR sky130_fd_sc_hd__fill_1
XFILLER_0_27_167 VGND VGND VPWR VPWR sky130_fd_sc_hd__fill_1
X_6380_ _3372_ _3375_ _3378_ VGND VGND VPWR VPWR _3379_ sky130_fd_sc_hd__a21o_1
X_5400_ _2422_ _2423_ _2365_ _2424_ VGND VGND VPWR VPWR _2425_ sky130_fd_sc_hd__o211ai_2
XFILLER_0_113_559 VGND VGND VPWR VPWR sky130_fd_sc_hd__fill_1
XFILLER_0_51_693 VGND VGND VPWR VPWR sky130_fd_sc_hd__decap_4
XFILLER_0_2_245 VGND VGND VPWR VPWR sky130_fd_sc_hd__decap_6
XFILLER_0_23_373 VGND VGND VPWR VPWR sky130_fd_sc_hd__decap_3
X_5331_ _2350_ _2351_ _2352_ _2282_ VGND VGND VPWR VPWR _2357_ sky130_fd_sc_hd__a31o_1
X_8050_ _0884_ _0885_ _0897_ VGND VGND VPWR VPWR _0898_ sky130_fd_sc_hd__nand3_1
X_7001_ _3986_ VGND VGND VPWR VPWR _3987_ sky130_fd_sc_hd__inv_2
X_5262_ _2269_ _2045_ _2272_ VGND VGND VPWR VPWR _2289_ sky130_fd_sc_hd__o21ai_2
XFILLER_0_76_65 VPWR VGND VPWR VGND sky130_ef_sc_hd__decap_12
X_5193_ _2216_ _2217_ _2219_ _2220_ VGND VGND VPWR VPWR _2221_ sky130_fd_sc_hd__o211ai_4
XFILLER_0_78_524 VGND VGND VPWR VPWR sky130_fd_sc_hd__decap_8
X_7903_ _0751_ _0752_ VGND VGND VPWR VPWR _0753_ sky130_fd_sc_hd__nor2_1
XFILLER_0_93_505 VPWR VGND VPWR VGND sky130_ef_sc_hd__decap_12
X_7834_ sum3\[8\] net295 _0702_ VGND VGND VPWR VPWR _0038_ sky130_fd_sc_hd__o21a_1
X_7765_ _0664_ _0665_ net264 VGND VGND VPWR VPWR _0666_ sky130_fd_sc_hd__o21ai_1
XFILLER_0_18_101 VPWR VGND VPWR VGND sky130_ef_sc_hd__decap_12
X_4977_ _1999_ _2009_ VGND VGND VPWR VPWR _2010_ sky130_fd_sc_hd__nor2_1
X_6716_ _3700_ _3702_ _3704_ VGND VGND VPWR VPWR _3706_ sky130_fd_sc_hd__a21oi_1
XFILLER_0_73_251 VPWR VGND VPWR VGND sky130_ef_sc_hd__decap_12
XFILLER_0_18_156 VGND VGND VPWR VPWR sky130_fd_sc_hd__decap_6
XFILLER_0_46_465 VGND VGND VPWR VPWR sky130_fd_sc_hd__decap_8
X_7696_ carry1\[6\] sum1\[7\] net210 VGND VGND VPWR VPWR _4212_ sky130_fd_sc_hd__a21o_1
X_6647_ _3636_ _3637_ _3639_ VGND VGND VPWR VPWR _3642_ sky130_fd_sc_hd__a21boi_1
XFILLER_0_61_446 VGND VGND VPWR VPWR sky130_fd_sc_hd__fill_2
XFILLER_0_6_540 VGND VGND VPWR VPWR sky130_fd_sc_hd__decap_4
XFILLER_0_33_137 VGND VGND VPWR VPWR sky130_fd_sc_hd__decap_6
X_6578_ _3571_ _3572_ _3573_ VGND VGND VPWR VPWR _3574_ sky130_fd_sc_hd__nand3_2
XFILLER_0_104_548 VGND VGND VPWR VPWR sky130_fd_sc_hd__fill_1
X_8317_ sum5\[9\] s7\[9\] VGND VGND VPWR VPWR _1155_ sky130_fd_sc_hd__nor2_1
XFILLER_0_14_384 VGND VGND VPWR VPWR sky130_fd_sc_hd__decap_8
X_5529_ net30 VGND VGND VPWR VPWR _2548_ sky130_fd_sc_hd__inv_2
XFILLER_0_41_181 VPWR VGND VPWR VGND sky130_ef_sc_hd__decap_12
X_8248_ _1041_ _1087_ _1091_ VGND VGND VPWR VPWR _1093_ sky130_fd_sc_hd__and3b_1
X_8179_ _0939_ _0940_ _1016_ _0937_ _0944_ VGND VGND VPWR VPWR _1025_ sky130_fd_sc_hd__a32oi_2
XFILLER_0_96_365 VGND VGND VPWR VPWR sky130_fd_sc_hd__decap_4
XTAP_1222 VGND VPWR sky130_fd_sc_hd__tapvpwrvgnd_1
XTAP_1200 VGND VPWR sky130_fd_sc_hd__tapvpwrvgnd_1
XTAP_1211 VGND VPWR sky130_fd_sc_hd__tapvpwrvgnd_1
XFILLER_0_69_557 VGND VGND VPWR VPWR sky130_fd_sc_hd__decap_3
XTAP_1266 VGND VPWR sky130_fd_sc_hd__tapvpwrvgnd_1
XTAP_1255 VGND VPWR sky130_fd_sc_hd__tapvpwrvgnd_1
XTAP_1244 VGND VPWR sky130_fd_sc_hd__tapvpwrvgnd_1
XTAP_1233 VGND VPWR sky130_fd_sc_hd__tapvpwrvgnd_1
XTAP_1299 VGND VPWR sky130_fd_sc_hd__tapvpwrvgnd_1
XTAP_1288 VGND VPWR sky130_fd_sc_hd__tapvpwrvgnd_1
XTAP_1277 VGND VPWR sky130_fd_sc_hd__tapvpwrvgnd_1
XFILLER_0_49_281 VGND VGND VPWR VPWR sky130_fd_sc_hd__decap_4
XFILLER_0_112_29 VPWR VGND VPWR VGND sky130_ef_sc_hd__decap_12
XFILLER_0_64_251 VGND VGND VPWR VPWR sky130_fd_sc_hd__fill_1
XFILLER_0_110_518 VGND VGND VPWR VPWR sky130_fd_sc_hd__fill_1
XFILLER_0_32_192 VGND VGND VPWR VPWR sky130_fd_sc_hd__decap_4
XFILLER_0_20_398 VPWR VGND VPWR VGND sky130_ef_sc_hd__decap_12
XFILLER_0_87_310 VGND VGND VPWR VPWR sky130_fd_sc_hd__decap_3
XFILLER_0_1_15 VPWR VGND VPWR VGND sky130_ef_sc_hd__decap_12
X_4900_ _1927_ _1930_ _1934_ VGND VGND VPWR VPWR _1935_ sky130_fd_sc_hd__nand3_1
X_5880_ sh0\[6\] VGND VGND VPWR VPWR _2890_ sky130_fd_sc_hd__clkbuf_4
XFILLER_0_87_332 VGND VGND VPWR VPWR sky130_fd_sc_hd__fill_1
X_4831_ _1865_ _1860_ _1866_ VGND VGND VPWR VPWR _1867_ sky130_fd_sc_hd__o21ai_4
XFILLER_0_62_67 VGND VGND VPWR VPWR sky130_fd_sc_hd__fill_2
X_4762_ _1797_ _1798_ _1720_ VGND VGND VPWR VPWR _1799_ sky130_fd_sc_hd__o21ai_1
X_7550_ _4162_ VGND VGND VPWR VPWR _0545_ sky130_fd_sc_hd__inv_2
XFILLER_0_7_337 VPWR VGND VPWR VGND sky130_ef_sc_hd__decap_12
XFILLER_0_16_616 VGND VGND VPWR VPWR sky130_fd_sc_hd__decap_6
X_4693_ _1704_ _1710_ _1714_ VGND VGND VPWR VPWR _1731_ sky130_fd_sc_hd__nand3_1
X_7481_ _4155_ VGND VGND VPWR VPWR _0483_ sky130_fd_sc_hd__inv_2
X_6501_ _3335_ _3496_ _3497_ VGND VGND VPWR VPWR _3498_ sky130_fd_sc_hd__o21ai_2
XFILLER_0_102_73 VGND VGND VPWR VPWR sky130_fd_sc_hd__decap_8
XFILLER_0_102_62 VGND VGND VPWR VPWR sky130_fd_sc_hd__fill_1
X_6432_ _3428_ _3429_ VGND VGND VPWR VPWR _3430_ sky130_fd_sc_hd__nand2_1
XFILLER_0_3_510 VPWR VGND VPWR VGND sky130_ef_sc_hd__decap_12
XFILLER_0_15_137 VGND VGND VPWR VPWR sky130_fd_sc_hd__decap_6
XFILLER_0_43_446 VGND VGND VPWR VPWR sky130_fd_sc_hd__fill_2
XFILLER_0_113_334 VGND VGND VPWR VPWR sky130_fd_sc_hd__fill_2
XFILLER_0_11_93 VPWR VGND VPWR VGND sky130_ef_sc_hd__decap_12
XFILLER_0_24_660 VPWR VGND VPWR VGND sky130_ef_sc_hd__decap_12
XFILLER_0_101_529 VGND VGND VPWR VPWR sky130_fd_sc_hd__fill_1
X_6363_ _3356_ _3359_ _3361_ VGND VGND VPWR VPWR _3362_ sky130_fd_sc_hd__a21oi_1
X_8102_ _0877_ _0878_ _0928_ _0873_ VGND VGND VPWR VPWR _0949_ sky130_fd_sc_hd__o22a_2
X_6294_ sh1\[4\] VGND VGND VPWR VPWR _3294_ sky130_fd_sc_hd__clkbuf_4
X_5314_ _2323_ _2326_ _2329_ _2333_ VGND VGND VPWR VPWR _2340_ sky130_fd_sc_hd__o211a_1
X_8033_ _0868_ _0872_ _0814_ VGND VGND VPWR VPWR _0881_ sky130_fd_sc_hd__a21o_1
X_5245_ _2104_ _2189_ _2190_ VGND VGND VPWR VPWR _2272_ sky130_fd_sc_hd__a21bo_1
Xhold28 bit_sum7\[6\] VGND VGND VPWR VPWR net70 sky130_fd_sc_hd__dlygate4sd3_1
Xhold17 s5\[14\] VGND VGND VPWR VPWR net59 sky130_fd_sc_hd__dlygate4sd3_1
XFILLER_0_46_3 VPWR VGND VPWR VGND sky130_ef_sc_hd__decap_12
Xhold39 sum4\[2\] VGND VGND VPWR VPWR net81 sky130_fd_sc_hd__dlygate4sd3_1
X_5176_ _2057_ _2071_ VGND VGND VPWR VPWR _2204_ sky130_fd_sc_hd__nor2_1
XFILLER_0_97_107 VGND VGND VPWR VPWR sky130_fd_sc_hd__decap_4
X_8866_ clknet_leaf_3_clk net160 _0617_ VGND VGND VPWR VPWR sh14\[6\] sky130_fd_sc_hd__dfrtp_4
XFILLER_0_78_365 VPWR VGND VPWR VGND sky130_ef_sc_hd__decap_12
XFILLER_0_66_538 VPWR VGND VPWR VGND sky130_ef_sc_hd__decap_12
XFILLER_0_66_505 VGND VGND VPWR VPWR sky130_fd_sc_hd__decap_4
Xclkbuf_leaf_63_clk clknet_3_0__leaf_clk VGND VGND VPWR VPWR clknet_leaf_63_clk sky130_fd_sc_hd__clkbuf_16
X_7817_ carry2\[7\] sum2\[8\] VGND VGND VPWR VPWR _0694_ sky130_fd_sc_hd__xnor2_1
X_8797_ clknet_leaf_61_clk net409 _0548_ VGND VGND VPWR VPWR sh6\[1\] sky130_fd_sc_hd__dfrtp_4
XFILLER_0_108_139 VGND VGND VPWR VPWR sky130_fd_sc_hd__fill_1
X_7748_ carry4\[9\] sum4\[10\] VGND VGND VPWR VPWR _0652_ sky130_fd_sc_hd__and2_1
XFILLER_0_46_251 VGND VGND VPWR VPWR sky130_fd_sc_hd__fill_1
X_7679_ sum3\[13\] carry3\[12\] VGND VGND VPWR VPWR _4202_ sky130_fd_sc_hd__and2_1
XFILLER_0_123_109 VGND VGND VPWR VPWR sky130_fd_sc_hd__decap_3
XFILLER_0_117_695 VPWR VGND VPWR VGND sky130_ef_sc_hd__decap_12
XFILLER_0_116_161 VPWR VGND VPWR VGND sky130_ef_sc_hd__decap_12
XFILLER_0_21_107 VGND VGND VPWR VPWR sky130_fd_sc_hd__decap_4
XFILLER_0_104_378 VGND VGND VPWR VPWR sky130_fd_sc_hd__decap_3
XFILLER_0_104_356 VGND VGND VPWR VPWR sky130_fd_sc_hd__fill_2
XFILLER_0_30_685 VPWR VGND VPWR VGND sky130_ef_sc_hd__decap_12
XFILLER_0_100_584 VGND VGND VPWR VPWR sky130_fd_sc_hd__decap_4
XFILLER_0_16_27 VGND VGND VPWR VPWR sky130_fd_sc_hd__fill_1
XFILLER_0_97_685 VPWR VGND VPWR VGND sky130_ef_sc_hd__decap_12
XTAP_1030 VGND VPWR sky130_fd_sc_hd__tapvpwrvgnd_1
XFILLER_0_57_505 VGND VGND VPWR VPWR sky130_fd_sc_hd__decap_8
Xclkbuf_leaf_54_clk clknet_3_1__leaf_clk VGND VGND VPWR VPWR clknet_leaf_54_clk sky130_fd_sc_hd__clkbuf_16
XFILLER_0_96_195 VGND VGND VPWR VPWR sky130_fd_sc_hd__fill_1
XTAP_1074 VGND VPWR sky130_fd_sc_hd__tapvpwrvgnd_1
XTAP_1063 VGND VPWR sky130_fd_sc_hd__tapvpwrvgnd_1
XTAP_1052 VGND VPWR sky130_fd_sc_hd__tapvpwrvgnd_1
XTAP_1041 VGND VPWR sky130_fd_sc_hd__tapvpwrvgnd_1
XFILLER_0_32_15 VPWR VGND VPWR VGND sky130_ef_sc_hd__decap_12
XFILLER_0_32_37 VGND VGND VPWR VPWR sky130_fd_sc_hd__decap_3
XTAP_1096 VGND VPWR sky130_fd_sc_hd__tapvpwrvgnd_1
XTAP_1085 VGND VPWR sky130_fd_sc_hd__tapvpwrvgnd_1
XFILLER_0_25_435 VPWR VGND VPWR VGND sky130_ef_sc_hd__decap_12
XFILLER_0_37_284 VGND VGND VPWR VPWR sky130_fd_sc_hd__decap_8
XFILLER_0_123_632 VPWR VGND VPWR VGND sky130_ef_sc_hd__decap_12
XFILLER_0_107_194 VGND VGND VPWR VPWR sky130_fd_sc_hd__decap_8
XFILLER_0_52_265 VPWR VGND VPWR VGND sky130_ef_sc_hd__decap_12
XFILLER_0_122_153 VPWR VGND VPWR VGND sky130_ef_sc_hd__decap_12
XFILLER_0_40_438 VGND VGND VPWR VPWR sky130_fd_sc_hd__decap_4
XFILLER_0_122_197 VPWR VGND VPWR VGND sky130_ef_sc_hd__decap_12
XFILLER_0_0_557 VGND VGND VPWR VPWR sky130_fd_sc_hd__decap_3
XFILLER_0_21_685 VPWR VGND VPWR VGND sky130_ef_sc_hd__decap_12
XTAP_803 VGND VPWR sky130_fd_sc_hd__tapvpwrvgnd_1
XTAP_814 VGND VPWR sky130_fd_sc_hd__tapvpwrvgnd_1
XTAP_825 VGND VPWR sky130_fd_sc_hd__tapvpwrvgnd_1
X_5030_ _2052_ VGND VGND VPWR VPWR _2060_ sky130_fd_sc_hd__buf_4
XTAP_836 VGND VPWR sky130_fd_sc_hd__tapvpwrvgnd_1
XTAP_847 VGND VPWR sky130_fd_sc_hd__tapvpwrvgnd_1
XTAP_858 VGND VPWR sky130_fd_sc_hd__tapvpwrvgnd_1
XTAP_869 VGND VPWR sky130_fd_sc_hd__tapvpwrvgnd_1
XFILLER_0_73_22 VPWR VGND VPWR VGND sky130_ef_sc_hd__decap_12
X_6981_ sh1\[1\] sh5\[1\] VGND VGND VPWR VPWR _3967_ sky130_fd_sc_hd__and2_1
X_5932_ _2873_ _2874_ _2938_ _2939_ VGND VGND VPWR VPWR _2941_ sky130_fd_sc_hd__nand4_1
X_8720_ clknet_leaf_14_clk _0127_ _0471_ VGND VGND VPWR VPWR bit_sum5\[1\] sky130_fd_sc_hd__dfrtp_1
XFILLER_0_75_302 VGND VGND VPWR VPWR sky130_fd_sc_hd__fill_1
Xclkbuf_leaf_45_clk clknet_3_5__leaf_clk VGND VGND VPWR VPWR clknet_leaf_45_clk sky130_fd_sc_hd__clkbuf_16
X_8651_ clknet_leaf_16_clk net71 _0402_ VGND VGND VPWR VPWR s6\[7\] sky130_fd_sc_hd__dfrtp_1
X_5863_ sh10\[6\] sh11\[6\] VGND VGND VPWR VPWR _2873_ sky130_fd_sc_hd__nand2_1
XFILLER_0_118_448 VGND VGND VPWR VPWR sky130_fd_sc_hd__decap_8
X_4814_ _1847_ _1844_ _1848_ _1849_ VGND VGND VPWR VPWR _1850_ sky130_fd_sc_hd__o2bb2ai_4
X_7602_ _4167_ VGND VGND VPWR VPWR _0592_ sky130_fd_sc_hd__inv_2
XFILLER_0_90_305 VGND VGND VPWR VPWR sky130_fd_sc_hd__decap_3
XFILLER_0_63_519 VGND VGND VPWR VPWR sky130_fd_sc_hd__fill_1
XFILLER_0_8_635 VGND VGND VPWR VPWR sky130_fd_sc_hd__decap_8
X_5794_ _2803_ _2805_ _2808_ VGND VGND VPWR VPWR _2809_ sky130_fd_sc_hd__nand3_4
X_8582_ clknet_leaf_35_clk net390 _0333_ VGND VGND VPWR VPWR carry1\[5\] sky130_fd_sc_hd__dfrtp_1
X_4745_ _1781_ _1775_ _1779_ _1776_ VGND VGND VPWR VPWR _1782_ sky130_fd_sc_hd__o211a_1
X_7533_ _4161_ VGND VGND VPWR VPWR _0529_ sky130_fd_sc_hd__inv_2
XFILLER_0_8_657 VPWR VGND VPWR VGND sky130_ef_sc_hd__decap_12
XFILLER_0_22_70 VGND VGND VPWR VPWR sky130_fd_sc_hd__fill_1
XFILLER_0_28_284 VGND VGND VPWR VPWR sky130_fd_sc_hd__decap_3
XFILLER_0_44_733 VGND VGND VPWR VPWR sky130_fd_sc_hd__fill_2
XFILLER_0_83_390 VGND VGND VPWR VPWR sky130_fd_sc_hd__fill_2
XFILLER_0_7_167 VGND VGND VPWR VPWR sky130_fd_sc_hd__fill_1
X_4676_ _1695_ _1713_ _1698_ VGND VGND VPWR VPWR _1714_ sky130_fd_sc_hd__o21ai_4
X_7464_ _4153_ VGND VGND VPWR VPWR _0468_ sky130_fd_sc_hd__inv_2
XFILLER_0_43_276 VGND VGND VPWR VPWR sky130_fd_sc_hd__decap_4
XFILLER_0_98_85 VGND VGND VPWR VPWR sky130_fd_sc_hd__decap_8
X_7395_ _4146_ VGND VGND VPWR VPWR _0406_ sky130_fd_sc_hd__inv_2
X_6415_ _3404_ _3405_ VGND VGND VPWR VPWR _3414_ sky130_fd_sc_hd__and2_1
XFILLER_0_101_337 VGND VGND VPWR VPWR sky130_fd_sc_hd__decap_8
X_6346_ _3343_ _3344_ _3327_ VGND VGND VPWR VPWR _3345_ sky130_fd_sc_hd__nand3_1
XFILLER_0_3_373 VPWR VGND VPWR VGND sky130_ef_sc_hd__decap_12
Xoutput18 net18 VGND VGND VPWR VPWR led[2] sky130_fd_sc_hd__clkbuf_4
XFILLER_0_12_696 VGND VGND VPWR VPWR sky130_fd_sc_hd__decap_4
XFILLER_0_11_173 VGND VGND VPWR VPWR sky130_fd_sc_hd__fill_2
X_6277_ _3279_ _3270_ _3276_ VGND VGND VPWR VPWR _3280_ sky130_fd_sc_hd__a21oi_1
X_8016_ _0740_ _0750_ VGND VGND VPWR VPWR _0864_ sky130_fd_sc_hd__nor2_1
X_5228_ sh9\[2\] VGND VGND VPWR VPWR _2255_ sky130_fd_sc_hd__inv_2
X_5159_ _2180_ _2182_ VGND VGND VPWR VPWR _2187_ sky130_fd_sc_hd__nand2_1
XFILLER_0_39_505 VPWR VGND VPWR VGND sky130_ef_sc_hd__decap_12
Xclkbuf_leaf_36_clk clknet_3_5__leaf_clk VGND VGND VPWR VPWR clknet_leaf_36_clk sky130_fd_sc_hd__clkbuf_16
X_8849_ clknet_leaf_11_clk net240 _0600_ VGND VGND VPWR VPWR sh12\[5\] sky130_fd_sc_hd__dfrtp_4
XFILLER_0_78_195 VGND VGND VPWR VPWR sky130_fd_sc_hd__fill_1
XPHY_124 VGND VGND VPWR VPWR sky130_fd_sc_hd__decap_3
XPHY_113 VGND VGND VPWR VPWR sky130_fd_sc_hd__decap_3
XFILLER_0_39_538 VGND VGND VPWR VPWR sky130_fd_sc_hd__decap_8
XPHY_102 VGND VGND VPWR VPWR sky130_fd_sc_hd__decap_3
XFILLER_0_109_426 VPWR VGND VPWR VGND sky130_ef_sc_hd__decap_12
XPHY_157 VGND VGND VPWR VPWR sky130_fd_sc_hd__decap_3
XPHY_146 VGND VGND VPWR VPWR sky130_fd_sc_hd__decap_3
XPHY_135 VGND VGND VPWR VPWR sky130_fd_sc_hd__decap_3
XPHY_179 VGND VGND VPWR VPWR sky130_fd_sc_hd__decap_3
XPHY_168 VGND VGND VPWR VPWR sky130_fd_sc_hd__decap_3
XFILLER_0_81_327 VGND VGND VPWR VPWR sky130_fd_sc_hd__decap_4
XFILLER_0_47_593 VGND VGND VPWR VPWR sky130_fd_sc_hd__fill_2
XFILLER_0_74_390 VGND VGND VPWR VPWR sky130_fd_sc_hd__decap_3
XFILLER_0_62_530 VGND VGND VPWR VPWR sky130_fd_sc_hd__fill_2
XFILLER_0_19_295 VPWR VGND VPWR VGND sky130_ef_sc_hd__decap_12
XFILLER_0_105_621 VGND VGND VPWR VPWR sky130_fd_sc_hd__decap_6
XFILLER_0_22_416 VGND VGND VPWR VPWR sky130_fd_sc_hd__decap_4
XFILLER_0_105_665 VGND VGND VPWR VPWR sky130_fd_sc_hd__fill_1
XFILLER_0_104_164 VGND VGND VPWR VPWR sky130_fd_sc_hd__fill_2
XFILLER_0_104_131 VGND VGND VPWR VPWR sky130_fd_sc_hd__decap_8
XFILLER_0_22_449 VGND VGND VPWR VPWR sky130_fd_sc_hd__decap_4
XFILLER_0_120_624 VGND VGND VPWR VPWR sky130_fd_sc_hd__decap_4
XFILLER_0_104_197 VPWR VGND VPWR VGND sky130_ef_sc_hd__decap_12
XFILLER_0_120_679 VPWR VGND VPWR VGND sky130_ef_sc_hd__decap_12
XFILLER_0_100_381 VGND VGND VPWR VPWR sky130_fd_sc_hd__fill_1
XFILLER_0_89_405 VGND VGND VPWR VPWR sky130_fd_sc_hd__fill_2
XFILLER_0_89_449 VGND VGND VPWR VPWR sky130_fd_sc_hd__decap_8
Xclkbuf_leaf_27_clk clknet_3_7__leaf_clk VGND VGND VPWR VPWR clknet_leaf_27_clk sky130_fd_sc_hd__clkbuf_16
XFILLER_0_84_121 VPWR VGND VPWR VGND sky130_ef_sc_hd__decap_12
XFILLER_0_69_184 VPWR VGND VPWR VGND sky130_ef_sc_hd__decap_12
XPHY_4 VGND VGND VPWR VPWR sky130_fd_sc_hd__decap_3
XFILLER_0_43_69 VGND VGND VPWR VPWR sky130_fd_sc_hd__decap_8
X_4530_ _1571_ _1573_ _1507_ VGND VGND VPWR VPWR _1574_ sky130_fd_sc_hd__o21ai_1
XFILLER_0_104_3 VPWR VGND VPWR VGND sky130_ef_sc_hd__decap_12
XFILLER_0_25_254 VGND VGND VPWR VPWR sky130_fd_sc_hd__fill_1
X_4461_ _1245_ _1299_ _1384_ VGND VGND VPWR VPWR _1506_ sky130_fd_sc_hd__o21a_2
Xhold317 sh15\[4\] VGND VGND VPWR VPWR net359 sky130_fd_sc_hd__buf_1
XFILLER_0_68_11 VGND VGND VPWR VPWR sky130_fd_sc_hd__fill_1
XFILLER_0_40_213 VPWR VGND VPWR VGND sky130_ef_sc_hd__decap_12
Xhold306 s0\[2\] VGND VGND VPWR VPWR net348 sky130_fd_sc_hd__dlygate4sd3_1
XFILLER_0_123_473 VGND VGND VPWR VPWR sky130_fd_sc_hd__decap_3
X_6200_ _3203_ _3201_ _3204_ VGND VGND VPWR VPWR _3205_ sky130_fd_sc_hd__a21o_2
X_7180_ _4126_ VGND VGND VPWR VPWR _0211_ sky130_fd_sc_hd__inv_2
Xhold339 carry3\[4\] VGND VGND VPWR VPWR net381 sky130_fd_sc_hd__dlygate4sd3_1
Xhold328 _0019_ VGND VGND VPWR VPWR net370 sky130_fd_sc_hd__dlygate4sd3_1
XFILLER_0_7_69 VPWR VGND VPWR VGND sky130_ef_sc_hd__decap_12
XFILLER_0_0_321 VGND VGND VPWR VPWR sky130_fd_sc_hd__decap_8
XFILLER_0_111_668 VGND VGND VPWR VPWR sky130_fd_sc_hd__decap_4
X_4392_ _1422_ _1425_ _1428_ VGND VGND VPWR VPWR _1438_ sky130_fd_sc_hd__a21o_1
X_6131_ _2878_ _2879_ _2911_ VGND VGND VPWR VPWR _3137_ sky130_fd_sc_hd__o21a_2
XFILLER_0_0_354 VGND VGND VPWR VPWR sky130_fd_sc_hd__decap_8
XTAP_600 VGND VPWR sky130_fd_sc_hd__tapvpwrvgnd_1
XFILLER_0_110_178 VGND VGND VPWR VPWR sky130_fd_sc_hd__fill_1
XFILLER_0_0_365 VGND VGND VPWR VPWR sky130_fd_sc_hd__decap_8
XTAP_622 VGND VPWR sky130_fd_sc_hd__tapvpwrvgnd_1
XTAP_611 VGND VPWR sky130_fd_sc_hd__tapvpwrvgnd_1
XTAP_633 VGND VPWR sky130_fd_sc_hd__tapvpwrvgnd_1
X_6062_ _3068_ _3069_ VGND VGND VPWR VPWR _3070_ sky130_fd_sc_hd__and2_1
XTAP_644 VGND VPWR sky130_fd_sc_hd__tapvpwrvgnd_1
XTAP_655 VGND VPWR sky130_fd_sc_hd__tapvpwrvgnd_1
XTAP_666 VGND VPWR sky130_fd_sc_hd__tapvpwrvgnd_1
XTAP_677 VGND VPWR sky130_fd_sc_hd__tapvpwrvgnd_1
XFILLER_0_84_65 VPWR VGND VPWR VGND sky130_ef_sc_hd__decap_12
X_5013_ sh12\[2\] VGND VGND VPWR VPWR _2043_ sky130_fd_sc_hd__inv_2
XTAP_688 VGND VPWR sky130_fd_sc_hd__tapvpwrvgnd_1
XTAP_699 VGND VPWR sky130_fd_sc_hd__tapvpwrvgnd_1
Xclkbuf_leaf_18_clk clknet_3_6__leaf_clk VGND VGND VPWR VPWR clknet_leaf_18_clk sky130_fd_sc_hd__clkbuf_16
X_6964_ _3950_ _3872_ _3943_ _3947_ VGND VGND VPWR VPWR _3951_ sky130_fd_sc_hd__o211ai_4
X_5915_ _2893_ _2922_ _2923_ VGND VGND VPWR VPWR _2924_ sky130_fd_sc_hd__o21ai_4
X_6895_ _3881_ _3872_ _3882_ VGND VGND VPWR VPWR _3883_ sky130_fd_sc_hd__o21ai_1
X_8703_ clknet_leaf_56_clk _0112_ _0454_ VGND VGND VPWR VPWR bit_sum3\[4\] sky130_fd_sc_hd__dfrtp_1
XFILLER_0_118_212 VGND VGND VPWR VPWR sky130_fd_sc_hd__fill_1
X_8634_ clknet_leaf_32_clk net132 _0385_ VGND VGND VPWR VPWR s4\[8\] sky130_fd_sc_hd__dfrtp_1
X_5846_ _2851_ _2771_ _2858_ VGND VGND VPWR VPWR _2859_ sky130_fd_sc_hd__a21oi_1
XFILLER_0_48_368 VPWR VGND VPWR VGND sky130_ef_sc_hd__decap_12
XFILLER_0_118_256 VGND VGND VPWR VPWR sky130_fd_sc_hd__fill_1
XFILLER_0_91_614 VGND VGND VPWR VPWR sky130_fd_sc_hd__fill_2
XFILLER_0_75_165 VGND VGND VPWR VPWR sky130_fd_sc_hd__decap_3
XFILLER_0_63_316 VGND VGND VPWR VPWR sky130_fd_sc_hd__fill_1
XFILLER_0_63_305 VGND VGND VPWR VPWR sky130_fd_sc_hd__decap_8
XFILLER_0_56_390 VGND VGND VPWR VPWR sky130_fd_sc_hd__fill_1
X_5777_ _2790_ _2791_ VGND VGND VPWR VPWR _2792_ sky130_fd_sc_hd__nor2_1
X_8565_ clknet_leaf_37_clk net115 _0316_ VGND VGND VPWR VPWR sum2\[0\] sky130_fd_sc_hd__dfrtp_1
X_7516_ _4159_ VGND VGND VPWR VPWR _0514_ sky130_fd_sc_hd__inv_2
X_4728_ _1764_ _1754_ _1757_ VGND VGND VPWR VPWR _1766_ sky130_fd_sc_hd__and3_1
XFILLER_0_32_725 VGND VGND VPWR VPWR sky130_fd_sc_hd__decap_8
X_8496_ clknet_leaf_40_clk net131 _0247_ VGND VGND VPWR VPWR final_sum\[2\] sky130_fd_sc_hd__dfrtp_1
X_4659_ sh5\[7\] sh7\[7\] net31 VGND VGND VPWR VPWR _1697_ sky130_fd_sc_hd__o21ai_2
XFILLER_0_71_393 VPWR VGND VPWR VGND sky130_ef_sc_hd__decap_12
X_7447_ _4152_ VGND VGND VPWR VPWR _0452_ sky130_fd_sc_hd__inv_2
XFILLER_0_102_624 VGND VGND VPWR VPWR sky130_fd_sc_hd__decap_6
XFILLER_0_4_693 VGND VGND VPWR VPWR sky130_fd_sc_hd__decap_6
XFILLER_0_3_181 VPWR VGND VPWR VGND sky130_ef_sc_hd__decap_12
XFILLER_0_102_657 VPWR VGND VPWR VGND sky130_ef_sc_hd__decap_12
XFILLER_0_101_145 VGND VGND VPWR VPWR sky130_fd_sc_hd__fill_1
X_7378_ _4145_ VGND VGND VPWR VPWR _0390_ sky130_fd_sc_hd__inv_2
XFILLER_0_12_471 VGND VGND VPWR VPWR sky130_fd_sc_hd__fill_2
XFILLER_0_101_167 VGND VGND VPWR VPWR sky130_fd_sc_hd__fill_1
X_6329_ _3296_ _3326_ VGND VGND VPWR VPWR _3328_ sky130_fd_sc_hd__and2_2
XFILLER_0_98_257 VGND VGND VPWR VPWR sky130_fd_sc_hd__fill_1
XFILLER_0_86_419 VGND VGND VPWR VPWR sky130_fd_sc_hd__fill_1
XFILLER_0_13_39 VPWR VGND VPWR VGND sky130_ef_sc_hd__decap_12
XFILLER_0_109_245 VGND VGND VPWR VPWR sky130_fd_sc_hd__decap_4
XFILLER_0_81_113 VPWR VGND VPWR VGND sky130_ef_sc_hd__decap_12
XFILLER_0_82_669 VGND VGND VPWR VPWR sky130_fd_sc_hd__decap_4
XFILLER_0_120_29 VPWR VGND VPWR VGND sky130_ef_sc_hd__decap_12
XFILLER_0_105_462 VGND VGND VPWR VPWR sky130_fd_sc_hd__decap_3
XFILLER_0_50_533 VPWR VGND VPWR VGND sky130_ef_sc_hd__decap_12
XFILLER_0_89_246 VPWR VGND VPWR VGND sky130_ef_sc_hd__decap_12
XFILLER_0_77_408 VGND VGND VPWR VPWR sky130_fd_sc_hd__fill_1
X_5700_ _2708_ _2710_ _2711_ VGND VGND VPWR VPWR _2717_ sky130_fd_sc_hd__a21o_1
X_6680_ _3629_ _3631_ _3633_ VGND VGND VPWR VPWR _3674_ sky130_fd_sc_hd__a21oi_1
XFILLER_0_18_519 VPWR VGND VPWR VGND sky130_ef_sc_hd__decap_12
XFILLER_0_73_669 VGND VGND VPWR VPWR sky130_fd_sc_hd__decap_3
X_5631_ _2644_ _2648_ net453 VGND VGND VPWR VPWR _2649_ sky130_fd_sc_hd__a21oi_1
X_8350_ _1174_ _1176_ _1185_ VGND VGND VPWR VPWR _1186_ sky130_fd_sc_hd__nor3_1
X_5562_ _2558_ _2570_ _2571_ _2575_ _2580_ VGND VGND VPWR VPWR _2581_ sky130_fd_sc_hd__o221a_2
X_4513_ _1553_ _1556_ _1551_ VGND VGND VPWR VPWR _1557_ sky130_fd_sc_hd__a21oi_4
X_8281_ _1096_ _1046_ _1123_ _1119_ VGND VGND VPWR VPWR _1124_ sky130_fd_sc_hd__o211ai_2
X_7301_ _4138_ VGND VGND VPWR VPWR _0320_ sky130_fd_sc_hd__inv_2
XFILLER_0_53_393 VGND VGND VPWR VPWR sky130_fd_sc_hd__decap_6
XFILLER_0_14_725 VGND VGND VPWR VPWR sky130_fd_sc_hd__decap_8
XFILLER_0_26_596 VGND VGND VPWR VPWR sky130_fd_sc_hd__decap_8
XFILLER_0_123_281 VPWR VGND VPWR VGND sky130_ef_sc_hd__decap_12
Xhold114 sh3\[7\] VGND VGND VPWR VPWR net156 sky130_fd_sc_hd__dlygate4sd3_1
Xhold103 bit_sum7\[7\] VGND VGND VPWR VPWR net145 sky130_fd_sc_hd__dlygate4sd3_1
Xhold125 sh1\[4\] VGND VGND VPWR VPWR net167 sky130_fd_sc_hd__dlygate4sd3_1
X_7232_ _4125_ VGND VGND VPWR VPWR _4131_ sky130_fd_sc_hd__buf_4
X_5493_ _2484_ _2477_ _2511_ VGND VGND VPWR VPWR _2512_ sky130_fd_sc_hd__a21oi_2
XFILLER_0_41_555 VGND VGND VPWR VPWR sky130_fd_sc_hd__decap_4
X_4444_ _1237_ _1247_ VGND VGND VPWR VPWR _1489_ sky130_fd_sc_hd__nor2_1
Xclkbuf_leaf_7_clk clknet_3_2__leaf_clk VGND VGND VPWR VPWR clknet_leaf_7_clk sky130_fd_sc_hd__clkbuf_16
Xhold147 sh1\[6\] VGND VGND VPWR VPWR net189 sky130_fd_sc_hd__dlygate4sd3_1
Xhold136 sh0\[4\] VGND VGND VPWR VPWR net178 sky130_fd_sc_hd__dlygate4sd3_1
Xhold158 sh6\[3\] VGND VGND VPWR VPWR net200 sky130_fd_sc_hd__dlygate4sd3_1
XFILLER_0_1_641 VPWR VGND VPWR VGND sky130_ef_sc_hd__decap_12
X_4375_ _1232_ _1234_ _1223_ VGND VGND VPWR VPWR _1421_ sky130_fd_sc_hd__o21ai_1
XFILLER_0_111_487 VGND VGND VPWR VPWR sky130_fd_sc_hd__decap_6
Xhold169 sh13\[7\] VGND VGND VPWR VPWR net211 sky130_fd_sc_hd__dlygate4sd3_1
X_7163_ _4123_ VGND VGND VPWR VPWR _0197_ sky130_fd_sc_hd__inv_2
XFILLER_0_1_685 VPWR VGND VPWR VGND sky130_ef_sc_hd__decap_12
X_6114_ _3045_ _3052_ _2977_ _3057_ VGND VGND VPWR VPWR _3121_ sky130_fd_sc_hd__a2bb2o_1
XTAP_430 VGND VPWR sky130_fd_sc_hd__tapvpwrvgnd_1
X_7094_ _4042_ _4077_ VGND VGND VPWR VPWR _4078_ sky130_fd_sc_hd__nand2_1
XTAP_441 VGND VPWR sky130_fd_sc_hd__tapvpwrvgnd_1
X_6045_ _3020_ _3028_ _3021_ _3024_ VGND VGND VPWR VPWR _3053_ sky130_fd_sc_hd__o211a_1
XTAP_452 VGND VPWR sky130_fd_sc_hd__tapvpwrvgnd_1
XTAP_463 VGND VPWR sky130_fd_sc_hd__tapvpwrvgnd_1
XTAP_474 VGND VPWR sky130_fd_sc_hd__tapvpwrvgnd_1
XTAP_485 VGND VPWR sky130_fd_sc_hd__tapvpwrvgnd_1
XFILLER_0_119_93 VGND VGND VPWR VPWR sky130_fd_sc_hd__decap_4
XTAP_496 VGND VPWR sky130_fd_sc_hd__tapvpwrvgnd_1
XTAP_1629 VGND VPWR sky130_fd_sc_hd__tapvpwrvgnd_1
XTAP_1618 VGND VPWR sky130_fd_sc_hd__tapvpwrvgnd_1
XTAP_1607 VGND VPWR sky130_fd_sc_hd__tapvpwrvgnd_1
X_7996_ _0843_ _0844_ VGND VGND VPWR VPWR _0845_ sky130_fd_sc_hd__or2_1
X_6947_ _3700_ _3702_ _3928_ VGND VGND VPWR VPWR _3934_ sky130_fd_sc_hd__a21oi_1
XFILLER_0_119_554 VGND VGND VPWR VPWR sky130_fd_sc_hd__decap_6
XFILLER_0_91_422 VGND VGND VPWR VPWR sky130_fd_sc_hd__decap_6
XFILLER_0_76_485 VGND VGND VPWR VPWR sky130_fd_sc_hd__fill_2
XFILLER_0_63_113 VGND VGND VPWR VPWR sky130_fd_sc_hd__decap_4
X_6878_ _3752_ _3858_ _3859_ VGND VGND VPWR VPWR _3866_ sky130_fd_sc_hd__a21o_1
XFILLER_0_17_530 VPWR VGND VPWR VGND sky130_ef_sc_hd__decap_12
X_5829_ _2842_ VGND VGND VPWR VPWR _2843_ sky130_fd_sc_hd__inv_2
X_8617_ clknet_leaf_56_clk net69 _0368_ VGND VGND VPWR VPWR s2\[9\] sky130_fd_sc_hd__dfrtp_1
X_8548_ clknet_leaf_32_clk net351 _0299_ VGND VGND VPWR VPWR carry2\[10\] sky130_fd_sc_hd__dfrtp_1
XFILLER_0_32_533 VPWR VGND VPWR VGND sky130_ef_sc_hd__decap_12
X_8479_ clknet_leaf_46_clk net177 _0230_ VGND VGND VPWR VPWR net17 sky130_fd_sc_hd__dfrtp_1
XFILLER_0_24_27 VGND VGND VPWR VPWR sky130_fd_sc_hd__fill_1
XFILLER_0_55_625 VGND VGND VPWR VPWR sky130_fd_sc_hd__fill_1
XFILLER_0_55_614 VGND VGND VPWR VPWR sky130_fd_sc_hd__fill_2
XFILLER_0_27_305 VGND VGND VPWR VPWR sky130_fd_sc_hd__decap_6
XFILLER_0_39_154 VGND VGND VPWR VPWR sky130_fd_sc_hd__fill_2
XFILLER_0_67_496 VGND VGND VPWR VPWR sky130_fd_sc_hd__decap_8
XFILLER_0_40_15 VPWR VGND VPWR VGND sky130_ef_sc_hd__decap_12
XFILLER_0_39_198 VGND VGND VPWR VPWR sky130_fd_sc_hd__fill_2
XFILLER_0_82_477 VGND VGND VPWR VPWR sky130_fd_sc_hd__decap_8
XFILLER_0_70_606 VPWR VGND VPWR VGND sky130_ef_sc_hd__decap_12
XFILLER_0_35_360 VGND VGND VPWR VPWR sky130_fd_sc_hd__decap_3
XFILLER_0_23_599 VPWR VGND VPWR VGND sky130_ef_sc_hd__decap_12
XFILLER_0_4_15 VPWR VGND VPWR VGND sky130_ef_sc_hd__decap_12
X_7850_ net354 s6\[7\] _0710_ VGND VGND VPWR VPWR _0047_ sky130_fd_sc_hd__o21a_1
X_6801_ _3769_ _3786_ _3788_ _3789_ VGND VGND VPWR VPWR _3790_ sky130_fd_sc_hd__a211oi_2
X_4993_ _1989_ _2024_ _1995_ _1948_ _1953_ VGND VGND VPWR VPWR _2025_ sky130_fd_sc_hd__o2111ai_4
XFILLER_0_81_55 VGND VGND VPWR VPWR sky130_fd_sc_hd__fill_1
X_7781_ carry2\[7\] net287 net208 VGND VGND VPWR VPWR _0676_ sky130_fd_sc_hd__a21o_1
XFILLER_0_85_271 VGND VGND VPWR VPWR sky130_fd_sc_hd__decap_8
XFILLER_0_18_305 VGND VGND VPWR VPWR sky130_fd_sc_hd__decap_3
X_6732_ sh5\[1\] sh7\[1\] VGND VGND VPWR VPWR _3722_ sky130_fd_sc_hd__nor2_1
XFILLER_0_105_95 VGND VGND VPWR VPWR sky130_fd_sc_hd__decap_8
X_6663_ _3623_ _3608_ _3655_ _3617_ VGND VGND VPWR VPWR _3657_ sky130_fd_sc_hd__o211ai_4
XFILLER_0_73_444 VGND VGND VPWR VPWR sky130_fd_sc_hd__decap_4
XFILLER_0_46_669 VPWR VGND VPWR VGND sky130_ef_sc_hd__decap_12
X_8402_ _1231_ sh0\[5\] VGND VGND VPWR VPWR _1232_ sky130_fd_sc_hd__nor2_1
X_5614_ _2623_ _2626_ _2627_ VGND VGND VPWR VPWR _2632_ sky130_fd_sc_hd__a21o_1
X_6594_ _3521_ _3528_ _3525_ VGND VGND VPWR VPWR _3590_ sky130_fd_sc_hd__a21boi_1
XFILLER_0_5_254 VGND VGND VPWR VPWR sky130_fd_sc_hd__decap_4
XFILLER_0_26_360 VGND VGND VPWR VPWR sky130_fd_sc_hd__decap_4
XFILLER_0_103_229 VGND VGND VPWR VPWR sky130_fd_sc_hd__fill_1
X_8333_ _1168_ _1169_ carry5\[9\] VGND VGND VPWR VPWR _1170_ sky130_fd_sc_hd__or3b_2
X_5545_ _2555_ _2554_ sh4\[0\] VGND VGND VPWR VPWR _2564_ sky130_fd_sc_hd__o21ai_2
XFILLER_0_5_298 VGND VGND VPWR VPWR sky130_fd_sc_hd__fill_1
XFILLER_0_76_3 VPWR VGND VPWR VGND sky130_ef_sc_hd__decap_12
X_8264_ _1106_ _1107_ VGND VGND VPWR VPWR _1108_ sky130_fd_sc_hd__nand2_1
X_5476_ _2492_ _2495_ VGND VGND VPWR VPWR _2496_ sky130_fd_sc_hd__nor2_1
X_7215_ _4129_ VGND VGND VPWR VPWR _0243_ sky130_fd_sc_hd__inv_2
X_4427_ _1315_ _1405_ _1400_ _1396_ VGND VGND VPWR VPWR _1473_ sky130_fd_sc_hd__o2bb2ai_2
X_8195_ _1036_ _1038_ _1040_ VGND VGND VPWR VPWR _1041_ sky130_fd_sc_hd__a21o_2
XFILLER_0_111_273 VGND VGND VPWR VPWR sky130_fd_sc_hd__decap_6
X_7146_ s0\[8\] s1\[8\] VGND VGND VPWR VPWR _4118_ sky130_fd_sc_hd__xnor2_1
X_4358_ _1401_ _1402_ _1404_ VGND VGND VPWR VPWR _1405_ sky130_fd_sc_hd__nand3_4
XTAP_260 VGND VPWR sky130_fd_sc_hd__tapvpwrvgnd_1
X_4289_ _1319_ _1320_ _1336_ VGND VGND VPWR VPWR _1337_ sky130_fd_sc_hd__a21oi_2
XTAP_282 VGND VPWR sky130_fd_sc_hd__tapvpwrvgnd_1
XTAP_271 VGND VPWR sky130_fd_sc_hd__tapvpwrvgnd_1
XTAP_293 VGND VPWR sky130_fd_sc_hd__tapvpwrvgnd_1
X_7077_ _4055_ _4059_ _4061_ VGND VGND VPWR VPWR _4062_ sky130_fd_sc_hd__o21a_1
X_6028_ _2958_ _3030_ _3031_ _3032_ _3035_ VGND VGND VPWR VPWR _3036_ sky130_fd_sc_hd__o221ai_4
XFILLER_0_68_205 VGND VGND VPWR VPWR sky130_fd_sc_hd__decap_3
XFILLER_0_96_547 VPWR VGND VPWR VGND sky130_ef_sc_hd__decap_12
XTAP_1415 VGND VPWR sky130_fd_sc_hd__tapvpwrvgnd_1
XTAP_1404 VGND VPWR sky130_fd_sc_hd__tapvpwrvgnd_1
XTAP_1448 VGND VPWR sky130_fd_sc_hd__tapvpwrvgnd_1
XTAP_1437 VGND VPWR sky130_fd_sc_hd__tapvpwrvgnd_1
XTAP_1426 VGND VPWR sky130_fd_sc_hd__tapvpwrvgnd_1
X_7979_ _0818_ _0821_ _0823_ _0827_ VGND VGND VPWR VPWR _0828_ sky130_fd_sc_hd__o2bb2ai_2
Xfanout31 sh8\[7\] VGND VGND VPWR VPWR net31 sky130_fd_sc_hd__clkbuf_4
XTAP_1459 VGND VPWR sky130_fd_sc_hd__tapvpwrvgnd_1
XFILLER_0_107_513 VGND VGND VPWR VPWR sky130_fd_sc_hd__fill_2
Xfanout42 net231 VGND VGND VPWR VPWR net42 sky130_fd_sc_hd__clkbuf_4
XFILLER_0_37_636 VPWR VGND VPWR VGND sky130_ef_sc_hd__decap_12
XFILLER_0_119_373 VPWR VGND VPWR VGND sky130_ef_sc_hd__decap_12
XFILLER_0_64_477 VGND VGND VPWR VPWR sky130_fd_sc_hd__decap_8
XFILLER_0_64_455 VGND VGND VPWR VPWR sky130_fd_sc_hd__decap_6
XFILLER_0_52_628 VGND VGND VPWR VPWR sky130_fd_sc_hd__decap_3
XFILLER_0_91_296 VGND VGND VPWR VPWR sky130_fd_sc_hd__decap_8
XFILLER_0_10_29 VPWR VGND VPWR VGND sky130_ef_sc_hd__decap_12
XFILLER_0_19_27 VGND VGND VPWR VPWR sky130_fd_sc_hd__decap_4
XFILLER_0_35_15 VPWR VGND VPWR VGND sky130_ef_sc_hd__decap_12
XFILLER_0_87_558 VGND VGND VPWR VPWR sky130_fd_sc_hd__fill_2
XFILLER_0_28_614 VPWR VGND VPWR VGND sky130_ef_sc_hd__decap_12
XFILLER_0_27_113 VGND VGND VPWR VPWR sky130_fd_sc_hd__decap_8
XFILLER_0_27_157 VGND VGND VPWR VPWR sky130_fd_sc_hd__fill_2
XFILLER_0_43_617 VGND VGND VPWR VPWR sky130_fd_sc_hd__fill_2
XFILLER_0_113_505 VPWR VGND VPWR VGND sky130_ef_sc_hd__decap_12
XFILLER_0_82_274 VGND VGND VPWR VPWR sky130_fd_sc_hd__fill_1
XFILLER_0_11_503 VGND VGND VPWR VPWR sky130_fd_sc_hd__fill_1
X_5330_ _2285_ _2296_ _2354_ _2355_ VGND VGND VPWR VPWR _2356_ sky130_fd_sc_hd__nand4_2
X_5261_ _2278_ _2287_ _2283_ VGND VGND VPWR VPWR _2288_ sky130_fd_sc_hd__nand3b_1
X_7000_ _3701_ _3702_ _3769_ _3909_ VGND VGND VPWR VPWR _3986_ sky130_fd_sc_hd__a22o_2
X_5192_ _2208_ _2210_ _2211_ VGND VGND VPWR VPWR _2220_ sky130_fd_sc_hd__a21o_1
XFILLER_0_76_77 VGND VGND VPWR VPWR sky130_fd_sc_hd__decap_6
X_7902_ _0746_ _0747_ VGND VGND VPWR VPWR _0752_ sky130_fd_sc_hd__nor2_1
XFILLER_0_116_83 VGND VGND VPWR VPWR sky130_fd_sc_hd__fill_1
X_7833_ sum3\[8\] net295 s5\[8\] VGND VGND VPWR VPWR _0702_ sky130_fd_sc_hd__a21o_1
XFILLER_0_93_517 VGND VGND VPWR VPWR sky130_fd_sc_hd__decap_8
X_7764_ carry4\[12\] s6\[13\] VGND VGND VPWR VPWR _0665_ sky130_fd_sc_hd__nor2_1
XFILLER_0_19_614 VGND VGND VPWR VPWR sky130_fd_sc_hd__fill_2
X_4976_ _2007_ _2008_ _1978_ VGND VGND VPWR VPWR _2009_ sky130_fd_sc_hd__a21oi_2
X_6715_ _3700_ _3702_ _3704_ VGND VGND VPWR VPWR _3705_ sky130_fd_sc_hd__and3_1
XFILLER_0_18_113 VPWR VGND VPWR VGND sky130_ef_sc_hd__decap_12
XFILLER_0_46_444 VGND VGND VPWR VPWR sky130_fd_sc_hd__decap_4
XFILLER_0_73_263 VPWR VGND VPWR VGND sky130_ef_sc_hd__decap_12
XFILLER_0_18_168 VPWR VGND VPWR VGND sky130_ef_sc_hd__decap_12
XFILLER_0_46_477 VGND VGND VPWR VPWR sky130_fd_sc_hd__decap_4
X_7695_ carry1\[5\] net394 _4211_ VGND VGND VPWR VPWR _0016_ sky130_fd_sc_hd__o21a_1
X_6646_ _3639_ _3640_ _3591_ VGND VGND VPWR VPWR _3641_ sky130_fd_sc_hd__a21o_1
XFILLER_0_116_376 VGND VGND VPWR VPWR sky130_fd_sc_hd__fill_1
XFILLER_0_116_365 VGND VGND VPWR VPWR sky130_fd_sc_hd__fill_1
X_6577_ _3495_ _3498_ _3491_ VGND VGND VPWR VPWR _3573_ sky130_fd_sc_hd__a21boi_1
X_8316_ _1153_ _1154_ VGND VGND VPWR VPWR _0170_ sky130_fd_sc_hd__nor2_1
XFILLER_0_14_363 VGND VGND VPWR VPWR sky130_fd_sc_hd__fill_1
X_5528_ net36 _2518_ sh13\[0\] VGND VGND VPWR VPWR _2547_ sky130_fd_sc_hd__o21ai_1
XFILLER_0_41_193 VPWR VGND VPWR VGND sky130_ef_sc_hd__decap_12
XFILLER_0_100_733 VGND VGND VPWR VPWR sky130_fd_sc_hd__fill_2
X_8247_ _1087_ _1091_ VGND VGND VPWR VPWR _1092_ sky130_fd_sc_hd__nand2_1
X_5459_ sh0\[0\] VGND VGND VPWR VPWR _2479_ sky130_fd_sc_hd__clkbuf_4
X_8178_ _1010_ _1018_ _1019_ VGND VGND VPWR VPWR _1024_ sky130_fd_sc_hd__nand3_1
X_7129_ _4108_ _3826_ _3827_ _4109_ VGND VGND VPWR VPWR _0145_ sky130_fd_sc_hd__a31o_1
XFILLER_0_69_503 VGND VGND VPWR VPWR sky130_fd_sc_hd__fill_1
XFILLER_0_96_300 VGND VGND VPWR VPWR sky130_fd_sc_hd__decap_8
XTAP_1223 VGND VPWR sky130_fd_sc_hd__tapvpwrvgnd_1
XTAP_1201 VGND VPWR sky130_fd_sc_hd__tapvpwrvgnd_1
XTAP_1212 VGND VPWR sky130_fd_sc_hd__tapvpwrvgnd_1
XTAP_1256 VGND VPWR sky130_fd_sc_hd__tapvpwrvgnd_1
XTAP_1245 VGND VPWR sky130_fd_sc_hd__tapvpwrvgnd_1
XTAP_1234 VGND VPWR sky130_fd_sc_hd__tapvpwrvgnd_1
XFILLER_0_56_208 VPWR VGND VPWR VGND sky130_ef_sc_hd__decap_12
XTAP_1289 VGND VPWR sky130_fd_sc_hd__tapvpwrvgnd_1
XTAP_1278 VGND VPWR sky130_fd_sc_hd__tapvpwrvgnd_1
XTAP_1267 VGND VPWR sky130_fd_sc_hd__tapvpwrvgnd_1
XFILLER_0_80_701 VPWR VGND VPWR VGND sky130_ef_sc_hd__decap_12
XFILLER_0_25_617 VGND VGND VPWR VPWR sky130_fd_sc_hd__decap_8
XFILLER_0_64_263 VPWR VGND VPWR VGND sky130_ef_sc_hd__decap_12
XFILLER_0_107_376 VPWR VGND VPWR VGND sky130_ef_sc_hd__decap_12
XFILLER_0_52_458 VPWR VGND VPWR VGND sky130_ef_sc_hd__decap_12
XFILLER_0_24_138 VGND VGND VPWR VPWR sky130_fd_sc_hd__fill_2
XFILLER_0_20_333 VGND VGND VPWR VPWR sky130_fd_sc_hd__decap_8
XFILLER_0_103_593 VPWR VGND VPWR VGND sky130_ef_sc_hd__decap_12
XFILLER_0_20_355 VGND VGND VPWR VPWR sky130_fd_sc_hd__decap_4
XFILLER_0_1_27 VPWR VGND VPWR VGND sky130_ef_sc_hd__decap_12
X_4830_ _1792_ _1861_ VGND VGND VPWR VPWR _1866_ sky130_fd_sc_hd__and2_1
XFILLER_0_87_366 VGND VGND VPWR VPWR sky130_fd_sc_hd__decap_3
XFILLER_0_7_305 VPWR VGND VPWR VGND sky130_ef_sc_hd__decap_12
XTAP_1790 VGND VPWR sky130_fd_sc_hd__tapvpwrvgnd_1
XFILLER_0_117_129 VGND VGND VPWR VPWR sky130_fd_sc_hd__fill_1
X_4761_ _1694_ _1696_ _1792_ _1795_ _1796_ VGND VGND VPWR VPWR _1798_ sky130_fd_sc_hd__o221a_4
XFILLER_0_90_509 VGND VGND VPWR VPWR sky130_fd_sc_hd__fill_1
XFILLER_0_83_561 VGND VGND VPWR VPWR sky130_fd_sc_hd__decap_4
XFILLER_0_28_455 VGND VGND VPWR VPWR sky130_fd_sc_hd__decap_3
X_4692_ _1693_ _1717_ VGND VGND VPWR VPWR _1730_ sky130_fd_sc_hd__nor2_2
X_7480_ _4155_ VGND VGND VPWR VPWR _0482_ sky130_fd_sc_hd__inv_2
XFILLER_0_83_594 VGND VGND VPWR VPWR sky130_fd_sc_hd__fill_2
X_6500_ _3333_ _3335_ _3451_ VGND VGND VPWR VPWR _3497_ sky130_fd_sc_hd__o21ai_1
XFILLER_0_7_349 VGND VGND VPWR VPWR sky130_fd_sc_hd__decap_4
XFILLER_0_28_477 VPWR VGND VPWR VGND sky130_ef_sc_hd__decap_12
XFILLER_0_43_425 VGND VGND VPWR VPWR sky130_fd_sc_hd__decap_4
X_6431_ _3295_ _3326_ VGND VGND VPWR VPWR _3429_ sky130_fd_sc_hd__nand2_1
XFILLER_0_102_85 VGND VGND VPWR VPWR sky130_fd_sc_hd__decap_8
X_6362_ _3360_ _3287_ VGND VGND VPWR VPWR _3361_ sky130_fd_sc_hd__nand2_2
XFILLER_0_3_522 VGND VGND VPWR VPWR sky130_fd_sc_hd__decap_4
XFILLER_0_24_672 VPWR VGND VPWR VGND sky130_ef_sc_hd__decap_12
X_8101_ _0937_ _0941_ _0944_ VGND VGND VPWR VPWR _0948_ sky130_fd_sc_hd__a21oi_1
X_5313_ _2318_ _2334_ _2338_ VGND VGND VPWR VPWR _2339_ sky130_fd_sc_hd__nand3b_2
XFILLER_0_51_480 VGND VGND VPWR VPWR sky130_fd_sc_hd__decap_6
X_6293_ _3288_ _3289_ _3292_ VGND VGND VPWR VPWR _3293_ sky130_fd_sc_hd__and3_1
X_8032_ _0863_ _0861_ _0879_ VGND VGND VPWR VPWR _0880_ sky130_fd_sc_hd__o21a_1
X_5244_ _2044_ _2049_ _2269_ VGND VGND VPWR VPWR _2271_ sky130_fd_sc_hd__a21o_1
Xhold29 bit_sum6\[1\] VGND VGND VPWR VPWR net71 sky130_fd_sc_hd__dlygate4sd3_1
Xhold18 bit_sum4\[0\] VGND VGND VPWR VPWR net60 sky130_fd_sc_hd__dlygate4sd3_1
X_5175_ sh4\[2\] net38 VGND VGND VPWR VPWR _2203_ sky130_fd_sc_hd__and2_1
XFILLER_0_39_3 VPWR VGND VPWR VGND sky130_ef_sc_hd__decap_12
XFILLER_0_98_609 VPWR VGND VPWR VGND sky130_ef_sc_hd__decap_12
X_8865_ clknet_leaf_17_clk net166 _0616_ VGND VGND VPWR VPWR sh14\[5\] sky130_fd_sc_hd__dfrtp_4
XFILLER_0_39_709 VGND VGND VPWR VPWR sky130_fd_sc_hd__decap_3
XFILLER_0_78_377 VGND VGND VPWR VPWR sky130_fd_sc_hd__decap_8
X_7816_ net217 _0693_ VGND VGND VPWR VPWR _0077_ sky130_fd_sc_hd__xnor2_1
X_8796_ clknet_leaf_47_clk net183 _0547_ VGND VGND VPWR VPWR sh6\[0\] sky130_fd_sc_hd__dfrtp_4
X_4959_ _1942_ _1939_ _1987_ _1988_ VGND VGND VPWR VPWR _1993_ sky130_fd_sc_hd__o211ai_2
X_7747_ _0650_ _0651_ VGND VGND VPWR VPWR _0099_ sky130_fd_sc_hd__nand2_1
X_7678_ _4200_ _4201_ VGND VGND VPWR VPWR _0082_ sky130_fd_sc_hd__nand2_1
X_6629_ _3606_ _3608_ _3623_ VGND VGND VPWR VPWR _3624_ sky130_fd_sc_hd__o21ai_1
XFILLER_0_61_222 VGND VGND VPWR VPWR sky130_fd_sc_hd__fill_2
XFILLER_0_6_360 VGND VGND VPWR VPWR sky130_fd_sc_hd__decap_4
XFILLER_0_22_609 VPWR VGND VPWR VGND sky130_ef_sc_hd__decap_12
XFILLER_0_34_436 VGND VGND VPWR VPWR sky130_fd_sc_hd__fill_1
XFILLER_0_116_195 VGND VGND VPWR VPWR sky130_fd_sc_hd__fill_1
XFILLER_0_30_653 VGND VGND VPWR VPWR sky130_fd_sc_hd__fill_1
XFILLER_0_30_697 VGND VGND VPWR VPWR sky130_fd_sc_hd__decap_3
XFILLER_0_107_19 VGND VGND VPWR VPWR sky130_fd_sc_hd__fill_1
XFILLER_0_69_344 VPWR VGND VPWR VGND sky130_ef_sc_hd__decap_12
XFILLER_0_97_697 VPWR VGND VPWR VGND sky130_ef_sc_hd__decap_12
XFILLER_0_96_141 VGND VGND VPWR VPWR sky130_fd_sc_hd__fill_1
XTAP_1031 VGND VPWR sky130_fd_sc_hd__tapvpwrvgnd_1
XTAP_1020 VGND VPWR sky130_fd_sc_hd__tapvpwrvgnd_1
XFILLER_0_29_219 VGND VGND VPWR VPWR sky130_fd_sc_hd__decap_4
XFILLER_0_123_29 VPWR VGND VPWR VGND sky130_ef_sc_hd__decap_12
XFILLER_0_123_18 VGND VGND VPWR VPWR sky130_fd_sc_hd__decap_8
XFILLER_0_84_325 VPWR VGND VPWR VGND sky130_ef_sc_hd__decap_12
XTAP_1064 VGND VPWR sky130_fd_sc_hd__tapvpwrvgnd_1
XTAP_1053 VGND VPWR sky130_fd_sc_hd__tapvpwrvgnd_1
XTAP_1042 VGND VPWR sky130_fd_sc_hd__tapvpwrvgnd_1
XFILLER_0_32_27 VGND VGND VPWR VPWR sky130_fd_sc_hd__fill_1
XTAP_1097 VGND VPWR sky130_fd_sc_hd__tapvpwrvgnd_1
XTAP_1086 VGND VPWR sky130_fd_sc_hd__tapvpwrvgnd_1
XTAP_1075 VGND VPWR sky130_fd_sc_hd__tapvpwrvgnd_1
XFILLER_0_52_211 VGND VGND VPWR VPWR sky130_fd_sc_hd__decap_3
XFILLER_0_108_685 VGND VGND VPWR VPWR sky130_fd_sc_hd__fill_2
XFILLER_0_107_162 VGND VGND VPWR VPWR sky130_fd_sc_hd__fill_2
XFILLER_0_92_391 VPWR VGND VPWR VGND sky130_ef_sc_hd__decap_12
XFILLER_0_25_447 VGND VGND VPWR VPWR sky130_fd_sc_hd__fill_1
XFILLER_0_122_121 VPWR VGND VPWR VGND sky130_ef_sc_hd__decap_12
XFILLER_0_80_586 VGND VGND VPWR VPWR sky130_fd_sc_hd__fill_2
XFILLER_0_52_277 VPWR VGND VPWR VGND sky130_ef_sc_hd__decap_12
XFILLER_0_13_609 VGND VGND VPWR VPWR sky130_fd_sc_hd__decap_6
XFILLER_0_122_165 VPWR VGND VPWR VGND sky130_ef_sc_hd__decap_12
XFILLER_0_110_305 VGND VGND VPWR VPWR sky130_fd_sc_hd__decap_3
XFILLER_0_20_141 VGND VGND VPWR VPWR sky130_fd_sc_hd__fill_1
XFILLER_0_21_653 VGND VGND VPWR VPWR sky130_fd_sc_hd__fill_1
XFILLER_0_103_390 VGND VGND VPWR VPWR sky130_fd_sc_hd__fill_2
XFILLER_0_21_697 VGND VGND VPWR VPWR sky130_fd_sc_hd__decap_8
XTAP_804 VGND VPWR sky130_fd_sc_hd__tapvpwrvgnd_1
XTAP_815 VGND VPWR sky130_fd_sc_hd__tapvpwrvgnd_1
XTAP_826 VGND VPWR sky130_fd_sc_hd__tapvpwrvgnd_1
XFILLER_0_57_57 VGND VGND VPWR VPWR sky130_fd_sc_hd__fill_1
XTAP_837 VGND VPWR sky130_fd_sc_hd__tapvpwrvgnd_1
XTAP_848 VGND VPWR sky130_fd_sc_hd__tapvpwrvgnd_1
XTAP_859 VGND VPWR sky130_fd_sc_hd__tapvpwrvgnd_1
XFILLER_0_73_34 VPWR VGND VPWR VGND sky130_ef_sc_hd__decap_12
X_6980_ _3911_ _3915_ _3919_ VGND VGND VPWR VPWR _3966_ sky130_fd_sc_hd__a21boi_1
X_5931_ _2873_ _2874_ _2938_ _2939_ VGND VGND VPWR VPWR _2940_ sky130_fd_sc_hd__a22o_1
X_5862_ sh10\[6\] sh11\[6\] net28 VGND VGND VPWR VPWR _2872_ sky130_fd_sc_hd__o21a_1
X_8650_ clknet_leaf_29_clk net142 _0401_ VGND VGND VPWR VPWR s6\[6\] sky130_fd_sc_hd__dfrtp_1
X_4813_ _1791_ _1679_ VGND VGND VPWR VPWR _1849_ sky130_fd_sc_hd__nor2_1
X_7601_ _4167_ VGND VGND VPWR VPWR _0591_ sky130_fd_sc_hd__inv_2
XFILLER_0_7_113 VPWR VGND VPWR VGND sky130_ef_sc_hd__decap_12
X_5793_ _2806_ _2749_ _2807_ VGND VGND VPWR VPWR _2808_ sky130_fd_sc_hd__nand3_2
X_8581_ clknet_leaf_35_clk net398 _0332_ VGND VGND VPWR VPWR carry1\[4\] sky130_fd_sc_hd__dfrtp_1
X_4744_ net41 sh2\[7\] net40 VGND VGND VPWR VPWR _1781_ sky130_fd_sc_hd__o21ai_4
XFILLER_0_113_51 VGND VGND VPWR VPWR sky130_fd_sc_hd__decap_4
XFILLER_0_90_317 VGND VGND VPWR VPWR sky130_fd_sc_hd__decap_3
X_7532_ _4158_ VGND VGND VPWR VPWR _4161_ sky130_fd_sc_hd__clkbuf_16
XFILLER_0_56_583 VGND VGND VPWR VPWR sky130_fd_sc_hd__decap_4
XFILLER_0_8_669 VPWR VGND VPWR VGND sky130_ef_sc_hd__decap_12
XFILLER_0_16_403 VGND VGND VPWR VPWR sky130_fd_sc_hd__decap_3
XFILLER_0_44_701 VPWR VGND VPWR VGND sky130_ef_sc_hd__decap_12
XFILLER_0_43_211 VGND VGND VPWR VPWR sky130_fd_sc_hd__fill_2
XFILLER_0_43_222 VGND VGND VPWR VPWR sky130_fd_sc_hd__fill_2
X_4675_ _1712_ _1697_ VGND VGND VPWR VPWR _1713_ sky130_fd_sc_hd__nand2_2
X_7463_ _4153_ VGND VGND VPWR VPWR _0467_ sky130_fd_sc_hd__inv_2
XFILLER_0_98_64 VGND VGND VPWR VPWR sky130_fd_sc_hd__fill_2
X_7394_ _4146_ VGND VGND VPWR VPWR _0405_ sky130_fd_sc_hd__inv_2
X_6414_ _3404_ _3405_ _3412_ VGND VGND VPWR VPWR _3413_ sky130_fd_sc_hd__a21oi_1
XFILLER_0_31_428 VPWR VGND VPWR VGND sky130_ef_sc_hd__decap_12
XFILLER_0_114_699 VGND VGND VPWR VPWR sky130_fd_sc_hd__fill_1
XFILLER_0_113_187 VGND VGND VPWR VPWR sky130_fd_sc_hd__fill_1
X_6345_ _3296_ sh2\[4\] VGND VGND VPWR VPWR _3344_ sky130_fd_sc_hd__or2_1
XFILLER_0_3_385 VGND VGND VPWR VPWR sky130_fd_sc_hd__decap_6
XFILLER_0_3_396 VGND VGND VPWR VPWR sky130_fd_sc_hd__decap_4
Xoutput19 net19 VGND VGND VPWR VPWR led[3] sky130_fd_sc_hd__clkbuf_4
X_6276_ _3269_ _3238_ _3266_ VGND VGND VPWR VPWR _3279_ sky130_fd_sc_hd__nand3_1
XFILLER_0_11_163 VGND VGND VPWR VPWR sky130_fd_sc_hd__decap_4
X_8015_ sh4\[3\] _0750_ VGND VGND VPWR VPWR _0863_ sky130_fd_sc_hd__and2_2
X_5227_ _2110_ _2109_ VGND VGND VPWR VPWR _2254_ sky130_fd_sc_hd__nand2_1
X_5158_ _2184_ _2083_ sh15\[2\] _2185_ VGND VGND VPWR VPWR _2186_ sky130_fd_sc_hd__a31o_1
X_5089_ _2113_ _2114_ _2097_ _2117_ VGND VGND VPWR VPWR _2118_ sky130_fd_sc_hd__o211ai_4
XFILLER_0_94_601 VPWR VGND VPWR VGND sky130_ef_sc_hd__decap_12
XFILLER_0_78_141 VPWR VGND VPWR VGND sky130_ef_sc_hd__decap_12
XFILLER_0_66_303 VGND VGND VPWR VPWR sky130_fd_sc_hd__fill_1
XFILLER_0_39_517 VGND VGND VPWR VPWR sky130_fd_sc_hd__fill_1
XFILLER_0_94_645 VGND VGND VPWR VPWR sky130_fd_sc_hd__decap_3
XFILLER_0_93_100 VPWR VGND VPWR VGND sky130_ef_sc_hd__decap_12
X_8848_ clknet_leaf_1_clk net188 _0599_ VGND VGND VPWR VPWR sh12\[4\] sky130_fd_sc_hd__dfrtp_4
XPHY_125 VGND VGND VPWR VPWR sky130_fd_sc_hd__decap_3
XPHY_114 VGND VGND VPWR VPWR sky130_fd_sc_hd__decap_3
XPHY_103 VGND VGND VPWR VPWR sky130_fd_sc_hd__decap_3
X_8779_ clknet_leaf_18_clk net362 _0530_ VGND VGND VPWR VPWR sh3\[7\] sky130_fd_sc_hd__dfrtp_1
XFILLER_0_109_438 VGND VGND VPWR VPWR sky130_fd_sc_hd__decap_8
XPHY_158 VGND VGND VPWR VPWR sky130_fd_sc_hd__decap_3
XPHY_147 VGND VGND VPWR VPWR sky130_fd_sc_hd__decap_3
XPHY_136 VGND VGND VPWR VPWR sky130_fd_sc_hd__decap_3
XFILLER_0_93_177 VGND VGND VPWR VPWR sky130_fd_sc_hd__fill_2
XPHY_169 VGND VGND VPWR VPWR sky130_fd_sc_hd__decap_3
XFILLER_0_105_600 VGND VGND VPWR VPWR sky130_fd_sc_hd__decap_6
XFILLER_0_62_575 VGND VGND VPWR VPWR sky130_fd_sc_hd__fill_2
XFILLER_0_34_277 VGND VGND VPWR VPWR sky130_fd_sc_hd__decap_6
XFILLER_0_104_187 VGND VGND VPWR VPWR sky130_fd_sc_hd__fill_1
XFILLER_0_118_29 VPWR VGND VPWR VGND sky130_ef_sc_hd__decap_12
XFILLER_0_69_152 VGND VGND VPWR VPWR sky130_fd_sc_hd__decap_4
XFILLER_0_43_15 VPWR VGND VPWR VGND sky130_ef_sc_hd__decap_12
XFILLER_0_85_634 VPWR VGND VPWR VGND sky130_ef_sc_hd__decap_12
XFILLER_0_69_196 VGND VGND VPWR VPWR sky130_fd_sc_hd__fill_2
XPHY_5 VGND VGND VPWR VPWR sky130_fd_sc_hd__decap_3
XFILLER_0_84_133 VGND VGND VPWR VPWR sky130_fd_sc_hd__decap_6
XFILLER_0_26_701 VPWR VGND VPWR VGND sky130_ef_sc_hd__decap_12
XFILLER_0_65_391 VGND VGND VPWR VPWR sky130_fd_sc_hd__fill_1
XFILLER_0_5_617 VPWR VGND VPWR VGND sky130_ef_sc_hd__decap_12
X_4460_ _1502_ _1503_ _1504_ VGND VGND VPWR VPWR _1505_ sky130_fd_sc_hd__o21ai_2
XFILLER_0_7_15 VPWR VGND VPWR VGND sky130_ef_sc_hd__decap_12
XFILLER_0_40_225 VGND VGND VPWR VPWR sky130_fd_sc_hd__decap_6
Xhold307 _0002_ VGND VGND VPWR VPWR net349 sky130_fd_sc_hd__dlygate4sd3_1
XFILLER_0_111_625 VGND VGND VPWR VPWR sky130_fd_sc_hd__fill_1
X_4391_ _1425_ VGND VGND VPWR VPWR _1437_ sky130_fd_sc_hd__inv_2
Xhold318 carry4\[11\] VGND VGND VPWR VPWR net360 sky130_fd_sc_hd__dlygate4sd3_1
Xhold329 s0\[3\] VGND VGND VPWR VPWR net371 sky130_fd_sc_hd__dlygate4sd3_1
X_6130_ _3106_ _3104_ _3094_ VGND VGND VPWR VPWR _3136_ sky130_fd_sc_hd__a21o_2
XTAP_612 VGND VPWR sky130_fd_sc_hd__tapvpwrvgnd_1
XTAP_601 VGND VPWR sky130_fd_sc_hd__tapvpwrvgnd_1
XTAP_623 VGND VPWR sky130_fd_sc_hd__tapvpwrvgnd_1
XTAP_634 VGND VPWR sky130_fd_sc_hd__tapvpwrvgnd_1
X_6061_ _2997_ _3065_ _3067_ VGND VGND VPWR VPWR _3069_ sky130_fd_sc_hd__nand3_2
XTAP_645 VGND VPWR sky130_fd_sc_hd__tapvpwrvgnd_1
XTAP_656 VGND VPWR sky130_fd_sc_hd__tapvpwrvgnd_1
XTAP_667 VGND VPWR sky130_fd_sc_hd__tapvpwrvgnd_1
X_5012_ sh10\[2\] _2040_ VGND VGND VPWR VPWR _2042_ sky130_fd_sc_hd__nor2_1
XTAP_678 VGND VPWR sky130_fd_sc_hd__tapvpwrvgnd_1
XTAP_689 VGND VPWR sky130_fd_sc_hd__tapvpwrvgnd_1
XFILLER_0_84_77 VGND VGND VPWR VPWR sky130_fd_sc_hd__decap_6
XFILLER_0_88_461 VGND VGND VPWR VPWR sky130_fd_sc_hd__decap_3
XFILLER_0_76_601 VGND VGND VPWR VPWR sky130_fd_sc_hd__decap_6
X_6963_ _3863_ _3860_ _3862_ net29 _3787_ VGND VGND VPWR VPWR _3950_ sky130_fd_sc_hd__o311a_1
X_5914_ sh13\[6\] VGND VGND VPWR VPWR _2923_ sky130_fd_sc_hd__buf_4
XFILLER_0_88_494 VGND VGND VPWR VPWR sky130_fd_sc_hd__decap_8
XFILLER_0_76_645 VGND VGND VPWR VPWR sky130_fd_sc_hd__decap_8
XFILLER_0_75_111 VGND VGND VPWR VPWR sky130_fd_sc_hd__fill_1
X_6894_ _3872_ _3873_ _3857_ VGND VGND VPWR VPWR _3882_ sky130_fd_sc_hd__o21ai_1
X_8702_ clknet_leaf_56_clk _0111_ _0453_ VGND VGND VPWR VPWR bit_sum3\[3\] sky130_fd_sc_hd__dfrtp_1
XFILLER_0_75_133 VGND VGND VPWR VPWR sky130_fd_sc_hd__decap_3
X_8633_ clknet_leaf_32_clk net48 _0384_ VGND VGND VPWR VPWR s4\[7\] sky130_fd_sc_hd__dfrtp_1
XFILLER_0_33_70 VGND VGND VPWR VPWR sky130_fd_sc_hd__fill_2
X_5845_ _2856_ _2857_ VGND VGND VPWR VPWR _2858_ sky130_fd_sc_hd__nand2_1
XFILLER_0_76_689 VGND VGND VPWR VPWR sky130_fd_sc_hd__decap_8
X_8564_ clknet_leaf_28_clk net59 _0315_ VGND VGND VPWR VPWR sum4\[14\] sky130_fd_sc_hd__dfrtp_1
XFILLER_0_8_477 VGND VGND VPWR VPWR sky130_fd_sc_hd__fill_1
XFILLER_0_16_211 VGND VGND VPWR VPWR sky130_fd_sc_hd__decap_4
X_5776_ sh15\[0\] sh11\[0\] _2518_ VGND VGND VPWR VPWR _2791_ sky130_fd_sc_hd__and3_2
XFILLER_0_44_520 VGND VGND VPWR VPWR sky130_fd_sc_hd__decap_6
X_7515_ _4159_ VGND VGND VPWR VPWR _0513_ sky130_fd_sc_hd__inv_2
X_4727_ _1754_ _1757_ _1764_ VGND VGND VPWR VPWR _1765_ sky130_fd_sc_hd__a21oi_1
XFILLER_0_44_553 VPWR VGND VPWR VGND sky130_ef_sc_hd__decap_12
X_8495_ clknet_leaf_41_clk net122 _0246_ VGND VGND VPWR VPWR final_sum\[1\] sky130_fd_sc_hd__dfrtp_1
XFILLER_0_114_441 VGND VGND VPWR VPWR sky130_fd_sc_hd__fill_1
X_4658_ _1641_ _1638_ net31 VGND VGND VPWR VPWR _1696_ sky130_fd_sc_hd__o21a_1
X_7446_ _4152_ VGND VGND VPWR VPWR _0451_ sky130_fd_sc_hd__inv_2
XFILLER_0_102_636 VGND VGND VPWR VPWR sky130_fd_sc_hd__decap_8
XFILLER_0_101_113 VPWR VGND VPWR VGND sky130_ef_sc_hd__decap_12
X_4589_ _1605_ _1614_ _1623_ VGND VGND VPWR VPWR _1630_ sky130_fd_sc_hd__and3_1
XFILLER_0_102_669 VPWR VGND VPWR VGND sky130_ef_sc_hd__decap_12
X_7377_ _4145_ VGND VGND VPWR VPWR _0389_ sky130_fd_sc_hd__inv_2
XFILLER_0_3_193 VPWR VGND VPWR VGND sky130_ef_sc_hd__decap_12
X_6328_ _3296_ _3326_ sh6\[4\] VGND VGND VPWR VPWR _3327_ sky130_fd_sc_hd__o21ai_4
X_6259_ _3260_ _3261_ _3262_ VGND VGND VPWR VPWR _3263_ sky130_fd_sc_hd__a21o_1
XFILLER_0_79_461 VPWR VGND VPWR VGND sky130_ef_sc_hd__decap_12
XFILLER_0_39_314 VGND VGND VPWR VPWR sky130_fd_sc_hd__fill_2
XFILLER_0_109_202 VGND VGND VPWR VPWR sky130_fd_sc_hd__fill_2
XFILLER_0_94_431 VPWR VGND VPWR VGND sky130_ef_sc_hd__decap_12
XFILLER_0_109_235 VGND VGND VPWR VPWR sky130_fd_sc_hd__decap_6
XFILLER_0_67_689 VPWR VGND VPWR VGND sky130_ef_sc_hd__decap_12
XFILLER_0_81_125 VPWR VGND VPWR VGND sky130_ef_sc_hd__decap_12
XFILLER_0_50_501 VPWR VGND VPWR VGND sky130_ef_sc_hd__decap_12
XFILLER_0_50_545 VPWR VGND VPWR VGND sky130_ef_sc_hd__decap_12
XFILLER_0_120_433 VGND VGND VPWR VPWR sky130_fd_sc_hd__decap_6
XFILLER_0_22_269 VGND VGND VPWR VPWR sky130_fd_sc_hd__decap_4
XFILLER_0_120_477 VGND VGND VPWR VPWR sky130_fd_sc_hd__decap_6
XFILLER_0_38_26 VGND VGND VPWR VPWR sky130_fd_sc_hd__fill_2
XFILLER_0_101_680 VPWR VGND VPWR VGND sky130_ef_sc_hd__decap_12
XFILLER_0_89_225 VPWR VGND VPWR VGND sky130_ef_sc_hd__decap_12
XFILLER_0_89_269 VGND VGND VPWR VPWR sky130_fd_sc_hd__decap_8
XFILLER_0_54_58 VGND VGND VPWR VPWR sky130_fd_sc_hd__decap_4
XFILLER_0_73_637 VPWR VGND VPWR VGND sky130_ef_sc_hd__decap_12
XFILLER_0_70_68 VGND VGND VPWR VPWR sky130_fd_sc_hd__decap_8
XFILLER_0_70_79 VGND VGND VPWR VPWR sky130_fd_sc_hd__decap_4
XFILLER_0_57_188 VGND VGND VPWR VPWR sky130_fd_sc_hd__decap_8
X_5630_ _2645_ _2646_ _2647_ VGND VGND VPWR VPWR _2648_ sky130_fd_sc_hd__nand3_4
XFILLER_0_60_309 VPWR VGND VPWR VGND sky130_ef_sc_hd__decap_12
XFILLER_0_5_447 VGND VGND VPWR VPWR sky130_fd_sc_hd__fill_1
X_5561_ _2576_ _2577_ _2579_ VGND VGND VPWR VPWR _2580_ sky130_fd_sc_hd__o21ai_2
X_4512_ _1552_ _1555_ _1246_ VGND VGND VPWR VPWR _1556_ sky130_fd_sc_hd__nand3b_2
X_8280_ _1122_ _1087_ _1041_ _1092_ _1048_ VGND VGND VPWR VPWR _1123_ sky130_fd_sc_hd__a221oi_2
XFILLER_0_5_469 VGND VGND VPWR VPWR sky130_fd_sc_hd__fill_2
X_5492_ sh1\[0\] _2477_ _2482_ VGND VGND VPWR VPWR _2511_ sky130_fd_sc_hd__o21a_2
X_7300_ _4138_ VGND VGND VPWR VPWR _0319_ sky130_fd_sc_hd__inv_2
XFILLER_0_123_271 VGND VGND VPWR VPWR sky130_fd_sc_hd__decap_8
Xhold115 sh8\[4\] VGND VGND VPWR VPWR net157 sky130_fd_sc_hd__dlygate4sd3_1
Xhold104 bit_sum6\[2\] VGND VGND VPWR VPWR net146 sky130_fd_sc_hd__dlygate4sd3_1
XFILLER_0_79_55 VGND VGND VPWR VPWR sky130_fd_sc_hd__fill_1
X_7231_ _4130_ VGND VGND VPWR VPWR _0258_ sky130_fd_sc_hd__inv_2
Xhold126 sh0\[0\] VGND VGND VPWR VPWR net168 sky130_fd_sc_hd__dlygate4sd3_1
XFILLER_0_123_293 VPWR VGND VPWR VGND sky130_ef_sc_hd__decap_12
X_4443_ _1231_ sh5\[5\] sh6\[5\] VGND VGND VPWR VPWR _1488_ sky130_fd_sc_hd__o21ai_4
XFILLER_0_110_85 VGND VGND VPWR VPWR sky130_fd_sc_hd__decap_4
Xhold159 sh3\[3\] VGND VGND VPWR VPWR net201 sky130_fd_sc_hd__dlygate4sd3_1
Xhold137 sh1\[3\] VGND VGND VPWR VPWR net179 sky130_fd_sc_hd__dlygate4sd3_1
XFILLER_0_1_653 VPWR VGND VPWR VGND sky130_ef_sc_hd__decap_12
Xhold148 sh10\[2\] VGND VGND VPWR VPWR net190 sky130_fd_sc_hd__dlygate4sd3_1
X_4374_ _1357_ _1364_ VGND VGND VPWR VPWR _1420_ sky130_fd_sc_hd__nor2_1
X_7162_ _4123_ VGND VGND VPWR VPWR _0196_ sky130_fd_sc_hd__inv_2
XFILLER_0_0_141 VPWR VGND VPWR VGND sky130_ef_sc_hd__decap_12
X_6113_ _3071_ _3072_ _3116_ _3119_ VGND VGND VPWR VPWR _3120_ sky130_fd_sc_hd__o211a_2
XTAP_431 VGND VPWR sky130_fd_sc_hd__tapvpwrvgnd_1
XTAP_420 VGND VPWR sky130_fd_sc_hd__tapvpwrvgnd_1
XFILLER_0_1_697 VPWR VGND VPWR VGND sky130_ef_sc_hd__decap_12
X_7093_ _4035_ _4046_ VGND VGND VPWR VPWR _4077_ sky130_fd_sc_hd__nand2_1
XTAP_442 VGND VPWR sky130_fd_sc_hd__tapvpwrvgnd_1
X_6044_ _2973_ _3047_ _3050_ _3051_ VGND VGND VPWR VPWR _3052_ sky130_fd_sc_hd__o2bb2ai_2
XTAP_453 VGND VPWR sky130_fd_sc_hd__tapvpwrvgnd_1
XTAP_464 VGND VPWR sky130_fd_sc_hd__tapvpwrvgnd_1
XTAP_475 VGND VPWR sky130_fd_sc_hd__tapvpwrvgnd_1
XTAP_486 VGND VPWR sky130_fd_sc_hd__tapvpwrvgnd_1
XTAP_497 VGND VPWR sky130_fd_sc_hd__tapvpwrvgnd_1
XFILLER_0_21_3 VPWR VGND VPWR VGND sky130_ef_sc_hd__decap_12
X_7995_ _0767_ _0763_ _0840_ _0841_ _0769_ VGND VGND VPWR VPWR _0844_ sky130_fd_sc_hd__o221a_1
XTAP_1619 VGND VPWR sky130_fd_sc_hd__tapvpwrvgnd_1
XTAP_1608 VGND VPWR sky130_fd_sc_hd__tapvpwrvgnd_1
X_6946_ _3931_ _3932_ VGND VGND VPWR VPWR _3933_ sky130_fd_sc_hd__nand2_1
XFILLER_0_49_634 VGND VGND VPWR VPWR sky130_fd_sc_hd__decap_4
XFILLER_0_49_667 VGND VGND VPWR VPWR sky130_fd_sc_hd__decap_4
XFILLER_0_119_533 VGND VGND VPWR VPWR sky130_fd_sc_hd__decap_3
XFILLER_0_64_604 VPWR VGND VPWR VGND sky130_ef_sc_hd__decap_12
X_6877_ _3859_ _3860_ _3862_ _3864_ VGND VGND VPWR VPWR _3865_ sky130_fd_sc_hd__o211ai_2
XFILLER_0_107_706 VPWR VGND VPWR VGND sky130_ef_sc_hd__decap_12
X_5828_ _2824_ _2838_ _2841_ VGND VGND VPWR VPWR _2842_ sky130_fd_sc_hd__nand3_2
X_8616_ clknet_leaf_56_clk net57 _0367_ VGND VGND VPWR VPWR s2\[8\] sky130_fd_sc_hd__dfrtp_1
XFILLER_0_119_599 VPWR VGND VPWR VGND sky130_ef_sc_hd__decap_12
XFILLER_0_63_169 VPWR VGND VPWR VGND sky130_ef_sc_hd__decap_12
X_8547_ clknet_leaf_32_clk net370 _0298_ VGND VGND VPWR VPWR carry2\[9\] sky130_fd_sc_hd__dfrtp_1
X_5759_ sh4\[0\] _2506_ VGND VGND VPWR VPWR _2774_ sky130_fd_sc_hd__and2_2
XFILLER_0_17_542 VGND VGND VPWR VPWR sky130_fd_sc_hd__decap_8
XFILLER_0_44_361 VGND VGND VPWR VPWR sky130_fd_sc_hd__decap_3
X_8478_ clknet_leaf_46_clk net204 _0229_ VGND VGND VPWR VPWR net10 sky130_fd_sc_hd__dfrtp_1
XFILLER_0_32_545 VPWR VGND VPWR VGND sky130_ef_sc_hd__decap_12
X_7429_ _4150_ VGND VGND VPWR VPWR _0436_ sky130_fd_sc_hd__inv_2
XFILLER_0_32_589 VGND VGND VPWR VPWR sky130_fd_sc_hd__decap_6
XFILLER_0_102_477 VPWR VGND VPWR VGND sky130_ef_sc_hd__decap_12
XFILLER_0_102_499 VGND VGND VPWR VPWR sky130_fd_sc_hd__fill_1
XFILLER_0_99_501 VGND VGND VPWR VPWR sky130_fd_sc_hd__decap_3
XFILLER_0_99_534 VPWR VGND VPWR VGND sky130_ef_sc_hd__decap_12
XFILLER_0_86_239 VGND VGND VPWR VPWR sky130_fd_sc_hd__fill_1
XFILLER_0_27_317 VPWR VGND VPWR VGND sky130_ef_sc_hd__decap_12
XFILLER_0_39_177 VGND VGND VPWR VPWR sky130_fd_sc_hd__fill_1
XFILLER_0_40_27 VGND VGND VPWR VPWR sky130_fd_sc_hd__fill_1
XFILLER_0_70_618 VGND VGND VPWR VPWR sky130_fd_sc_hd__fill_2
XFILLER_0_42_309 VGND VGND VPWR VPWR sky130_fd_sc_hd__decap_8
XFILLER_0_113_709 VPWR VGND VPWR VGND sky130_ef_sc_hd__decap_12
XFILLER_0_11_729 VGND VGND VPWR VPWR sky130_fd_sc_hd__decap_6
XFILLER_0_50_353 VGND VGND VPWR VPWR sky130_fd_sc_hd__decap_8
XFILLER_0_4_27 VGND VGND VPWR VPWR sky130_fd_sc_hd__fill_1
XFILLER_0_65_57 VGND VGND VPWR VPWR sky130_fd_sc_hd__fill_1
X_6800_ _3787_ net29 VGND VGND VPWR VPWR _3789_ sky130_fd_sc_hd__nor2_1
X_4992_ _2020_ VGND VGND VPWR VPWR _2024_ sky130_fd_sc_hd__inv_2
X_7780_ carry2\[6\] net402 _0675_ VGND VGND VPWR VPWR _0027_ sky130_fd_sc_hd__o21a_1
XFILLER_0_92_209 VGND VGND VPWR VPWR sky130_fd_sc_hd__decap_3
XFILLER_0_58_475 VGND VGND VPWR VPWR sky130_fd_sc_hd__fill_1
XFILLER_0_14_72 VGND VGND VPWR VPWR sky130_fd_sc_hd__fill_2
X_6731_ _3719_ _3720_ VGND VGND VPWR VPWR _3721_ sky130_fd_sc_hd__nand2_1
X_6662_ _3617_ _3653_ _3655_ VGND VGND VPWR VPWR _3656_ sky130_fd_sc_hd__a21oi_2
XFILLER_0_6_701 VPWR VGND VPWR VGND sky130_ef_sc_hd__decap_12
XFILLER_0_18_339 VGND VGND VPWR VPWR sky130_fd_sc_hd__fill_1
X_8401_ sh1\[5\] VGND VGND VPWR VPWR _1231_ sky130_fd_sc_hd__clkbuf_4
XFILLER_0_116_514 VGND VGND VPWR VPWR sky130_fd_sc_hd__fill_1
Xclkbuf_3_2__f_clk clknet_0_clk VGND VGND VPWR VPWR clknet_3_2__leaf_clk sky130_fd_sc_hd__clkbuf_16
X_5613_ _2617_ _2620_ _2628_ _2630_ VGND VGND VPWR VPWR _2631_ sky130_fd_sc_hd__o22ai_4
XFILLER_0_121_51 VGND VGND VPWR VPWR sky130_fd_sc_hd__decap_4
X_6593_ _3512_ _3585_ _3588_ VGND VGND VPWR VPWR _3589_ sky130_fd_sc_hd__nand3b_1
X_8332_ sum5\[10\] s7\[10\] VGND VGND VPWR VPWR _1169_ sky130_fd_sc_hd__and2_1
XFILLER_0_60_128 VPWR VGND VPWR VGND sky130_ef_sc_hd__decap_12
XFILLER_0_54_681 VPWR VGND VPWR VGND sky130_ef_sc_hd__decap_12
XFILLER_0_103_208 VGND VGND VPWR VPWR sky130_fd_sc_hd__fill_1
X_5544_ _2559_ _2560_ _2562_ VGND VGND VPWR VPWR _2563_ sky130_fd_sc_hd__o21a_1
XFILLER_0_41_331 VGND VGND VPWR VPWR sky130_fd_sc_hd__fill_1
X_8263_ sh13\[3\] _0892_ _1100_ VGND VGND VPWR VPWR _1107_ sky130_fd_sc_hd__a21oi_1
X_5475_ _2489_ _2491_ VGND VGND VPWR VPWR _2495_ sky130_fd_sc_hd__nor2_1
XFILLER_0_14_589 VPWR VGND VPWR VGND sky130_ef_sc_hd__decap_12
X_7214_ _4129_ VGND VGND VPWR VPWR _0242_ sky130_fd_sc_hd__inv_2
X_4426_ _1468_ _1463_ _1464_ VGND VGND VPWR VPWR _1472_ sky130_fd_sc_hd__a21o_1
XFILLER_0_69_3 VGND VGND VPWR VPWR sky130_fd_sc_hd__decap_8
XFILLER_0_1_461 VPWR VGND VPWR VGND sky130_ef_sc_hd__decap_12
X_8194_ _0974_ _0986_ _0982_ VGND VGND VPWR VPWR _1040_ sky130_fd_sc_hd__a21oi_1
X_7145_ net225 _4117_ VGND VGND VPWR VPWR _0057_ sky130_fd_sc_hd__xnor2_1
X_4357_ _1403_ _1398_ _1395_ VGND VGND VPWR VPWR _1404_ sky130_fd_sc_hd__nand3_1
XTAP_250 VGND VPWR sky130_fd_sc_hd__tapvpwrvgnd_1
X_4288_ _1327_ _1334_ _1335_ VGND VGND VPWR VPWR _1336_ sky130_fd_sc_hd__a21oi_2
XTAP_261 VGND VPWR sky130_fd_sc_hd__tapvpwrvgnd_1
XTAP_283 VGND VPWR sky130_fd_sc_hd__tapvpwrvgnd_1
XTAP_272 VGND VPWR sky130_fd_sc_hd__tapvpwrvgnd_1
X_7076_ _4058_ _4060_ _4056_ VGND VGND VPWR VPWR _4061_ sky130_fd_sc_hd__a21o_1
X_6027_ _3031_ _3034_ net28 VGND VGND VPWR VPWR _3035_ sky130_fd_sc_hd__o21bai_1
XTAP_294 VGND VPWR sky130_fd_sc_hd__tapvpwrvgnd_1
XTAP_1405 VGND VPWR sky130_fd_sc_hd__tapvpwrvgnd_1
XFILLER_0_69_729 VGND VGND VPWR VPWR sky130_fd_sc_hd__decap_6
XFILLER_0_68_217 VPWR VGND VPWR VGND sky130_ef_sc_hd__decap_12
XFILLER_0_96_559 VGND VGND VPWR VPWR sky130_fd_sc_hd__decap_6
XTAP_1438 VGND VPWR sky130_fd_sc_hd__tapvpwrvgnd_1
XTAP_1427 VGND VPWR sky130_fd_sc_hd__tapvpwrvgnd_1
XTAP_1416 VGND VPWR sky130_fd_sc_hd__tapvpwrvgnd_1
X_7978_ _0824_ _0825_ _0826_ VGND VGND VPWR VPWR _0827_ sky130_fd_sc_hd__o21ba_1
XFILLER_0_119_330 VGND VGND VPWR VPWR sky130_fd_sc_hd__decap_6
XTAP_1449 VGND VPWR sky130_fd_sc_hd__tapvpwrvgnd_1
X_6929_ _3717_ _3712_ _3703_ VGND VGND VPWR VPWR _3916_ sky130_fd_sc_hd__o21a_1
Xfanout32 sh8\[5\] VGND VGND VPWR VPWR net32 sky130_fd_sc_hd__clkbuf_4
XFILLER_0_76_283 VGND VGND VPWR VPWR sky130_fd_sc_hd__fill_1
XFILLER_0_64_445 VGND VGND VPWR VPWR sky130_fd_sc_hd__fill_2
XFILLER_0_9_561 VPWR VGND VPWR VGND sky130_ef_sc_hd__decap_12
XFILLER_0_37_648 VPWR VGND VPWR VGND sky130_ef_sc_hd__decap_12
XFILLER_0_119_385 VGND VGND VPWR VPWR sky130_fd_sc_hd__decap_6
XFILLER_0_107_525 VGND VGND VPWR VPWR sky130_fd_sc_hd__decap_3
XFILLER_0_91_286 VGND VGND VPWR VPWR sky130_fd_sc_hd__decap_4
XFILLER_0_45_670 VGND VGND VPWR VPWR sky130_fd_sc_hd__fill_2
XFILLER_0_102_263 VGND VGND VPWR VPWR sky130_fd_sc_hd__fill_1
XFILLER_0_99_342 VPWR VGND VPWR VGND sky130_ef_sc_hd__decap_12
XFILLER_0_35_27 VPWR VGND VPWR VGND sky130_ef_sc_hd__decap_12
XFILLER_0_51_15 VGND VGND VPWR VPWR sky130_fd_sc_hd__decap_6
XFILLER_0_51_26 VPWR VGND VPWR VGND sky130_ef_sc_hd__decap_12
XFILLER_0_28_626 VGND VGND VPWR VPWR sky130_fd_sc_hd__decap_4
XFILLER_0_82_253 VGND VGND VPWR VPWR sky130_fd_sc_hd__fill_1
XFILLER_0_36_681 VPWR VGND VPWR VGND sky130_ef_sc_hd__decap_12
XFILLER_0_113_528 VGND VGND VPWR VPWR sky130_fd_sc_hd__decap_3
XFILLER_0_113_517 VGND VGND VPWR VPWR sky130_fd_sc_hd__decap_8
XFILLER_0_42_139 VGND VGND VPWR VPWR sky130_fd_sc_hd__fill_1
XFILLER_0_51_651 VGND VGND VPWR VPWR sky130_fd_sc_hd__decap_4
X_5260_ _2280_ _2266_ _2277_ VGND VGND VPWR VPWR _2287_ sky130_fd_sc_hd__a21o_1
XFILLER_0_11_559 VGND VGND VPWR VPWR sky130_fd_sc_hd__fill_1
X_5191_ _2203_ _2201_ _2218_ VGND VGND VPWR VPWR _2219_ sky130_fd_sc_hd__o21a_1
X_7901_ sh6\[3\] _0750_ VGND VGND VPWR VPWR _0751_ sky130_fd_sc_hd__and2_1
XFILLER_0_116_73 VGND VGND VPWR VPWR sky130_fd_sc_hd__fill_2
X_7832_ sum3\[7\] net312 _0701_ VGND VGND VPWR VPWR _0037_ sky130_fd_sc_hd__o21a_1
X_4975_ _1975_ _2006_ _2004_ _2005_ VGND VGND VPWR VPWR _2008_ sky130_fd_sc_hd__a211o_1
X_7763_ carry4\[12\] s6\[13\] VGND VGND VPWR VPWR _0664_ sky130_fd_sc_hd__and2_1
XFILLER_0_25_82 VGND VGND VPWR VPWR sky130_fd_sc_hd__fill_2
X_6714_ _3703_ VGND VGND VPWR VPWR _3704_ sky130_fd_sc_hd__buf_2
XFILLER_0_18_125 VPWR VGND VPWR VGND sky130_ef_sc_hd__decap_12
XFILLER_0_46_412 VGND VGND VPWR VPWR sky130_fd_sc_hd__decap_8
XFILLER_0_73_231 VGND VGND VPWR VPWR sky130_fd_sc_hd__fill_1
XFILLER_0_34_618 VGND VGND VPWR VPWR sky130_fd_sc_hd__decap_8
XFILLER_0_46_456 VGND VGND VPWR VPWR sky130_fd_sc_hd__fill_1
X_7694_ carry1\[5\] sum1\[6\] net205 VGND VGND VPWR VPWR _4211_ sky130_fd_sc_hd__a21o_1
X_6645_ _3636_ _3637_ VGND VGND VPWR VPWR _3640_ sky130_fd_sc_hd__nand2_1
XFILLER_0_73_275 VGND VGND VPWR VPWR sky130_fd_sc_hd__decap_4
XFILLER_0_6_531 VGND VGND VPWR VPWR sky130_fd_sc_hd__fill_1
XFILLER_0_41_81 VPWR VGND VPWR VGND sky130_ef_sc_hd__decap_12
XFILLER_0_104_517 VPWR VGND VPWR VGND sky130_ef_sc_hd__decap_12
X_6576_ _3567_ _3559_ _3564_ VGND VGND VPWR VPWR _3572_ sky130_fd_sc_hd__nand3b_1
XFILLER_0_73_297 VGND VGND VPWR VPWR sky130_fd_sc_hd__decap_6
XFILLER_0_26_191 VGND VGND VPWR VPWR sky130_fd_sc_hd__fill_2
XFILLER_0_104_539 VGND VGND VPWR VPWR sky130_fd_sc_hd__fill_1
X_8315_ _1148_ _1149_ _1152_ VGND VGND VPWR VPWR _1154_ sky130_fd_sc_hd__a21oi_1
XFILLER_0_6_597 VGND VGND VPWR VPWR sky130_fd_sc_hd__fill_1
X_5527_ _2503_ _2545_ VGND VGND VPWR VPWR _2546_ sky130_fd_sc_hd__nand2_2
XFILLER_0_112_561 VGND VGND VPWR VPWR sky130_fd_sc_hd__fill_1
XFILLER_0_100_701 VPWR VGND VPWR VGND sky130_ef_sc_hd__decap_12
X_8246_ _1089_ _1050_ _1090_ VGND VGND VPWR VPWR _1091_ sky130_fd_sc_hd__nand3_1
X_5458_ sh1\[0\] _2477_ VGND VGND VPWR VPWR _2478_ sky130_fd_sc_hd__nor2_2
X_4409_ _1447_ _1448_ _1388_ _1383_ VGND VGND VPWR VPWR _1455_ sky130_fd_sc_hd__o211a_1
X_8177_ _1018_ _1019_ _1010_ VGND VGND VPWR VPWR _1023_ sky130_fd_sc_hd__a21o_1
X_5389_ _2396_ _2401_ _2408_ VGND VGND VPWR VPWR _2414_ sky130_fd_sc_hd__a21o_1
XFILLER_0_5_81 VPWR VGND VPWR VGND sky130_ef_sc_hd__decap_12
X_7128_ _4108_ _3827_ _3825_ VGND VGND VPWR VPWR _4109_ sky130_fd_sc_hd__a21oi_1
X_7059_ _3787_ _3752_ sh15\[1\] VGND VGND VPWR VPWR _4044_ sky130_fd_sc_hd__a21oi_1
XFILLER_0_96_345 VGND VGND VPWR VPWR sky130_fd_sc_hd__fill_1
XTAP_1202 VGND VPWR sky130_fd_sc_hd__tapvpwrvgnd_1
XTAP_1213 VGND VPWR sky130_fd_sc_hd__tapvpwrvgnd_1
XTAP_1257 VGND VPWR sky130_fd_sc_hd__tapvpwrvgnd_1
XTAP_1246 VGND VPWR sky130_fd_sc_hd__tapvpwrvgnd_1
XTAP_1235 VGND VPWR sky130_fd_sc_hd__tapvpwrvgnd_1
XTAP_1224 VGND VPWR sky130_fd_sc_hd__tapvpwrvgnd_1
XTAP_1279 VGND VPWR sky130_fd_sc_hd__tapvpwrvgnd_1
XTAP_1268 VGND VPWR sky130_fd_sc_hd__tapvpwrvgnd_1
XFILLER_0_65_721 VGND VGND VPWR VPWR sky130_fd_sc_hd__decap_6
XFILLER_0_49_261 VGND VGND VPWR VPWR sky130_fd_sc_hd__decap_3
XFILLER_0_49_272 VGND VGND VPWR VPWR sky130_fd_sc_hd__decap_8
XFILLER_0_119_160 VGND VGND VPWR VPWR sky130_fd_sc_hd__decap_8
XFILLER_0_64_253 VGND VGND VPWR VPWR sky130_fd_sc_hd__decap_3
XFILLER_0_80_724 VGND VGND VPWR VPWR sky130_fd_sc_hd__decap_8
XFILLER_0_80_713 VGND VGND VPWR VPWR sky130_fd_sc_hd__decap_3
XFILLER_0_64_275 VPWR VGND VPWR VGND sky130_ef_sc_hd__decap_12
XFILLER_0_9_391 VGND VGND VPWR VPWR sky130_fd_sc_hd__fill_1
XFILLER_0_24_117 VGND VGND VPWR VPWR sky130_fd_sc_hd__decap_6
XFILLER_0_107_388 VGND VGND VPWR VPWR sky130_fd_sc_hd__decap_4
XFILLER_0_107_366 VGND VGND VPWR VPWR sky130_fd_sc_hd__fill_1
XFILLER_0_33_673 VPWR VGND VPWR VGND sky130_ef_sc_hd__decap_12
XFILLER_0_103_561 VGND VGND VPWR VPWR sky130_fd_sc_hd__decap_4
XFILLER_0_60_481 VGND VGND VPWR VPWR sky130_fd_sc_hd__fill_1
XFILLER_0_46_15 VPWR VGND VPWR VGND sky130_ef_sc_hd__decap_12
XFILLER_0_46_37 VGND VGND VPWR VPWR sky130_fd_sc_hd__fill_2
XFILLER_0_1_39 VPWR VGND VPWR VGND sky130_ef_sc_hd__decap_12
XFILLER_0_47_209 VGND VGND VPWR VPWR sky130_fd_sc_hd__fill_1
XFILLER_0_68_570 VPWR VGND VPWR VGND sky130_ef_sc_hd__decap_12
XFILLER_0_56_732 VGND VGND VPWR VPWR sky130_fd_sc_hd__decap_3
XTAP_1791 VGND VPWR sky130_fd_sc_hd__tapvpwrvgnd_1
XTAP_1780 VGND VPWR sky130_fd_sc_hd__tapvpwrvgnd_1
X_4760_ _1793_ _1796_ _1713_ VGND VGND VPWR VPWR _1797_ sky130_fd_sc_hd__a21oi_2
XFILLER_0_7_317 VPWR VGND VPWR VGND sky130_ef_sc_hd__decap_12
X_4691_ _1693_ _1717_ _1728_ VGND VGND VPWR VPWR _1729_ sky130_fd_sc_hd__o21ai_4
XFILLER_0_83_573 VGND VGND VPWR VPWR sky130_fd_sc_hd__decap_3
XFILLER_0_15_106 VGND VGND VPWR VPWR sky130_fd_sc_hd__decap_6
XFILLER_0_28_489 VPWR VGND VPWR VGND sky130_ef_sc_hd__decap_12
X_6430_ _3294_ _3326_ _3298_ VGND VGND VPWR VPWR _3428_ sky130_fd_sc_hd__o21a_1
XFILLER_0_11_51 VGND VGND VPWR VPWR sky130_fd_sc_hd__decap_4
XFILLER_0_113_314 VGND VGND VPWR VPWR sky130_fd_sc_hd__decap_8
X_6361_ sh10\[4\] _3286_ VGND VGND VPWR VPWR _3360_ sky130_fd_sc_hd__nand2_1
XFILLER_0_70_278 VGND VGND VPWR VPWR sky130_fd_sc_hd__fill_1
XFILLER_0_30_109 VPWR VGND VPWR VGND sky130_ef_sc_hd__decap_12
XFILLER_0_113_369 VGND VGND VPWR VPWR sky130_fd_sc_hd__decap_3
XFILLER_0_70_289 VPWR VGND VPWR VGND sky130_ef_sc_hd__decap_12
X_8100_ _0930_ _0932_ _0937_ _0941_ VGND VGND VPWR VPWR _0947_ sky130_fd_sc_hd__o211a_1
XFILLER_0_3_556 VGND VGND VPWR VPWR sky130_fd_sc_hd__decap_4
XFILLER_0_24_684 VPWR VGND VPWR VGND sky130_ef_sc_hd__decap_12
X_5312_ _2333_ _2337_ _2329_ VGND VGND VPWR VPWR _2338_ sky130_fd_sc_hd__a21o_1
XFILLER_0_87_77 VGND VGND VPWR VPWR sky130_fd_sc_hd__fill_1
XFILLER_0_87_55 VGND VGND VPWR VPWR sky130_fd_sc_hd__fill_1
X_6292_ _3290_ _3291_ sh12\[4\] VGND VGND VPWR VPWR _3292_ sky130_fd_sc_hd__o21bai_4
XFILLER_0_60_7 VGND VGND VPWR VPWR sky130_fd_sc_hd__fill_1
XFILLER_0_11_334 VGND VGND VPWR VPWR sky130_fd_sc_hd__fill_2
X_8031_ _0863_ _0864_ net35 VGND VGND VPWR VPWR _0879_ sky130_fd_sc_hd__o21bai_1
X_5243_ _2039_ _2041_ _2269_ _2044_ VGND VGND VPWR VPWR _2270_ sky130_fd_sc_hd__o211ai_4
X_5174_ _2057_ _2071_ _2201_ VGND VGND VPWR VPWR _2202_ sky130_fd_sc_hd__a21oi_1
Xhold19 s0\[0\] VGND VGND VPWR VPWR net61 sky130_fd_sc_hd__dlygate4sd3_1
X_8864_ clknet_leaf_12_clk net428 _0615_ VGND VGND VPWR VPWR sh14\[4\] sky130_fd_sc_hd__dfrtp_4
X_7815_ carry2\[6\] sum2\[7\] VGND VGND VPWR VPWR _0693_ sky130_fd_sc_hd__xnor2_1
XFILLER_0_38_209 VPWR VGND VPWR VGND sky130_ef_sc_hd__decap_12
X_8795_ clknet_leaf_18_clk net336 _0546_ VGND VGND VPWR VPWR sh5\[7\] sky130_fd_sc_hd__dfrtp_4
X_4958_ _1989_ _1991_ VGND VGND VPWR VPWR _1992_ sky130_fd_sc_hd__nor2_1
XFILLER_0_108_119 VPWR VGND VPWR VGND sky130_ef_sc_hd__decap_12
X_7746_ net281 _0648_ _0649_ VGND VGND VPWR VPWR _0651_ sky130_fd_sc_hd__or3_1
XFILLER_0_19_445 VGND VGND VPWR VPWR sky130_fd_sc_hd__decap_3
X_4889_ _1690_ _1912_ _1916_ VGND VGND VPWR VPWR _1924_ sky130_fd_sc_hd__a21oi_1
X_7677_ net301 _4198_ _4199_ VGND VGND VPWR VPWR _4201_ sky130_fd_sc_hd__or3_1
XFILLER_0_74_584 VGND VGND VPWR VPWR sky130_fd_sc_hd__decap_4
XFILLER_0_46_253 VPWR VGND VPWR VGND sky130_ef_sc_hd__decap_12
XFILLER_0_117_664 VGND VGND VPWR VPWR sky130_fd_sc_hd__decap_8
XFILLER_0_116_141 VGND VGND VPWR VPWR sky130_fd_sc_hd__decap_6
X_6628_ _3621_ _3622_ VGND VGND VPWR VPWR _3623_ sky130_fd_sc_hd__nand2_2
XFILLER_0_34_448 VGND VGND VPWR VPWR sky130_fd_sc_hd__fill_2
XFILLER_0_15_673 VPWR VGND VPWR VGND sky130_ef_sc_hd__decap_12
X_6559_ _3294_ sh5\[4\] VGND VGND VPWR VPWR _3555_ sky130_fd_sc_hd__and2_1
XFILLER_0_100_553 VGND VGND VPWR VPWR sky130_fd_sc_hd__fill_1
XFILLER_0_100_531 VGND VGND VPWR VPWR sky130_fd_sc_hd__fill_1
X_8229_ _1070_ _1051_ _1073_ VGND VGND VPWR VPWR _1074_ sky130_fd_sc_hd__a21oi_2
XFILLER_0_16_29 VPWR VGND VPWR VGND sky130_ef_sc_hd__decap_12
XFILLER_0_69_356 VPWR VGND VPWR VGND sky130_ef_sc_hd__decap_12
XTAP_1021 VGND VPWR sky130_fd_sc_hd__tapvpwrvgnd_1
XTAP_1010 VGND VPWR sky130_fd_sc_hd__tapvpwrvgnd_1
XFILLER_0_96_197 VPWR VGND VPWR VGND sky130_ef_sc_hd__decap_12
XFILLER_0_84_337 VGND VGND VPWR VPWR sky130_fd_sc_hd__decap_6
XTAP_1065 VGND VPWR sky130_fd_sc_hd__tapvpwrvgnd_1
XTAP_1054 VGND VPWR sky130_fd_sc_hd__tapvpwrvgnd_1
XTAP_1032 VGND VPWR sky130_fd_sc_hd__tapvpwrvgnd_1
XTAP_1043 VGND VPWR sky130_fd_sc_hd__tapvpwrvgnd_1
XFILLER_0_84_359 VGND VGND VPWR VPWR sky130_fd_sc_hd__fill_2
XTAP_1098 VGND VPWR sky130_fd_sc_hd__tapvpwrvgnd_1
XTAP_1087 VGND VPWR sky130_fd_sc_hd__tapvpwrvgnd_1
XTAP_1076 VGND VPWR sky130_fd_sc_hd__tapvpwrvgnd_1
XFILLER_0_108_675 VGND VGND VPWR VPWR sky130_fd_sc_hd__decap_3
XFILLER_0_4_309 VGND VGND VPWR VPWR sky130_fd_sc_hd__decap_4
XFILLER_0_107_185 VGND VGND VPWR VPWR sky130_fd_sc_hd__fill_2
XFILLER_0_40_407 VPWR VGND VPWR VGND sky130_ef_sc_hd__decap_12
XFILLER_0_122_133 VGND VGND VPWR VPWR sky130_fd_sc_hd__decap_6
XFILLER_0_52_289 VPWR VGND VPWR VGND sky130_ef_sc_hd__decap_12
XFILLER_0_40_429 VGND VGND VPWR VPWR sky130_fd_sc_hd__fill_1
XFILLER_0_122_177 VPWR VGND VPWR VGND sky130_ef_sc_hd__decap_12
XFILLER_0_103_380 VGND VGND VPWR VPWR sky130_fd_sc_hd__fill_2
XFILLER_0_20_175 VGND VGND VPWR VPWR sky130_fd_sc_hd__decap_3
XTAP_805 VGND VPWR sky130_fd_sc_hd__tapvpwrvgnd_1
XTAP_816 VGND VPWR sky130_fd_sc_hd__tapvpwrvgnd_1
XFILLER_0_57_36 VGND VGND VPWR VPWR sky130_fd_sc_hd__fill_1
XFILLER_0_20_197 VPWR VGND VPWR VGND sky130_ef_sc_hd__decap_12
XTAP_827 VGND VPWR sky130_fd_sc_hd__tapvpwrvgnd_1
XTAP_838 VGND VPWR sky130_fd_sc_hd__tapvpwrvgnd_1
XTAP_849 VGND VPWR sky130_fd_sc_hd__tapvpwrvgnd_1
XFILLER_0_73_46 VGND VGND VPWR VPWR sky130_fd_sc_hd__decap_8
X_5930_ sh14\[6\] _2896_ _2937_ VGND VGND VPWR VPWR _2939_ sky130_fd_sc_hd__or3_1
XFILLER_0_88_643 VGND VGND VPWR VPWR sky130_fd_sc_hd__fill_1
XFILLER_0_73_57 VGND VGND VPWR VPWR sky130_fd_sc_hd__decap_6
XFILLER_0_87_164 VGND VGND VPWR VPWR sky130_fd_sc_hd__decap_4
X_5861_ _2869_ _2870_ net28 VGND VGND VPWR VPWR _2871_ sky130_fd_sc_hd__o21bai_4
X_7600_ _4167_ VGND VGND VPWR VPWR _0590_ sky130_fd_sc_hd__inv_2
XFILLER_0_29_721 VGND VGND VPWR VPWR sky130_fd_sc_hd__decap_6
XFILLER_0_48_529 VGND VGND VPWR VPWR sky130_fd_sc_hd__decap_3
X_4812_ _1639_ _1722_ _1838_ VGND VGND VPWR VPWR _1848_ sky130_fd_sc_hd__a21oi_4
X_5792_ _2794_ _2793_ _2797_ _2795_ VGND VGND VPWR VPWR _2807_ sky130_fd_sc_hd__o211ai_4
X_8580_ clknet_leaf_35_clk net372 _0331_ VGND VGND VPWR VPWR carry1\[3\] sky130_fd_sc_hd__dfrtp_1
X_4743_ _1776_ _1778_ _1779_ VGND VGND VPWR VPWR _1780_ sky130_fd_sc_hd__a21oi_4
X_7531_ _4160_ VGND VGND VPWR VPWR _0528_ sky130_fd_sc_hd__inv_2
XFILLER_0_56_573 VGND VGND VPWR VPWR sky130_fd_sc_hd__decap_6
XFILLER_0_7_125 VPWR VGND VPWR VGND sky130_ef_sc_hd__decap_12
XFILLER_0_44_713 VPWR VGND VPWR VGND sky130_ef_sc_hd__decap_12
XFILLER_0_114_601 VPWR VGND VPWR VGND sky130_ef_sc_hd__decap_12
X_7462_ _4153_ VGND VGND VPWR VPWR _0466_ sky130_fd_sc_hd__inv_2
XFILLER_0_7_169 VPWR VGND VPWR VGND sky130_ef_sc_hd__decap_12
XFILLER_0_114_645 VGND VGND VPWR VPWR sky130_fd_sc_hd__decap_8
X_4674_ sh5\[7\] _1638_ VGND VGND VPWR VPWR _1712_ sky130_fd_sc_hd__nand2_1
X_6413_ _3410_ _3325_ sh15\[4\] _3411_ VGND VGND VPWR VPWR _3412_ sky130_fd_sc_hd__a31oi_4
XFILLER_0_113_155 VGND VGND VPWR VPWR sky130_fd_sc_hd__decap_6
X_7393_ _4146_ VGND VGND VPWR VPWR _0404_ sky130_fd_sc_hd__inv_2
XFILLER_0_71_598 VGND VGND VPWR VPWR sky130_fd_sc_hd__decap_4
XFILLER_0_113_177 VGND VGND VPWR VPWR sky130_fd_sc_hd__decap_6
X_6344_ _3296_ sh2\[4\] VGND VGND VPWR VPWR _3343_ sky130_fd_sc_hd__nand2_1
X_6275_ _3269_ _3238_ _3266_ _3277_ VGND VGND VPWR VPWR _3278_ sky130_fd_sc_hd__a31oi_1
X_8014_ _0740_ _0747_ _0861_ VGND VGND VPWR VPWR _0862_ sky130_fd_sc_hd__a21oi_1
X_5226_ _2072_ _2102_ _2189_ VGND VGND VPWR VPWR _2253_ sky130_fd_sc_hd__o21a_1
XFILLER_0_51_3 VPWR VGND VPWR VGND sky130_ef_sc_hd__decap_12
X_5157_ _2133_ VGND VGND VPWR VPWR _2185_ sky130_fd_sc_hd__inv_2
XFILLER_0_98_407 VPWR VGND VPWR VGND sky130_ef_sc_hd__decap_12
X_5088_ _2115_ _2116_ VGND VGND VPWR VPWR _2117_ sky130_fd_sc_hd__nand2_2
XFILLER_0_78_153 VGND VGND VPWR VPWR sky130_fd_sc_hd__decap_6
XFILLER_0_94_613 VPWR VGND VPWR VGND sky130_ef_sc_hd__decap_12
X_8847_ clknet_leaf_4_clk net283 _0598_ VGND VGND VPWR VPWR sh12\[3\] sky130_fd_sc_hd__dfrtp_1
XPHY_115 VGND VGND VPWR VPWR sky130_fd_sc_hd__decap_3
XPHY_104 VGND VGND VPWR VPWR sky130_fd_sc_hd__decap_3
X_8778_ clknet_leaf_7_clk net202 _0529_ VGND VGND VPWR VPWR sh3\[6\] sky130_fd_sc_hd__dfrtp_4
XPHY_148 VGND VGND VPWR VPWR sky130_fd_sc_hd__decap_3
XPHY_137 VGND VGND VPWR VPWR sky130_fd_sc_hd__decap_3
XPHY_126 VGND VGND VPWR VPWR sky130_fd_sc_hd__decap_3
XPHY_159 VGND VGND VPWR VPWR sky130_fd_sc_hd__decap_3
X_7729_ carry4\[5\] sum4\[6\] VGND VGND VPWR VPWR _0637_ sky130_fd_sc_hd__nor2_1
XFILLER_0_117_472 VGND VGND VPWR VPWR sky130_fd_sc_hd__fill_1
XFILLER_0_62_565 VGND VGND VPWR VPWR sky130_fd_sc_hd__fill_2
XFILLER_0_30_495 VGND VGND VPWR VPWR sky130_fd_sc_hd__decap_6
XFILLER_0_43_27 VPWR VGND VPWR VGND sky130_ef_sc_hd__decap_12
XPHY_6 VGND VGND VPWR VPWR sky130_fd_sc_hd__decap_3
XFILLER_0_85_646 VGND VGND VPWR VPWR sky130_fd_sc_hd__decap_8
XFILLER_0_26_713 VGND VGND VPWR VPWR sky130_fd_sc_hd__decap_6
XFILLER_0_5_629 VPWR VGND VPWR VGND sky130_ef_sc_hd__decap_12
XFILLER_0_5_607 VGND VGND VPWR VPWR sky130_fd_sc_hd__decap_8
XFILLER_0_25_223 VGND VGND VPWR VPWR sky130_fd_sc_hd__fill_1
XFILLER_0_53_576 VPWR VGND VPWR VGND sky130_ef_sc_hd__decap_12
XFILLER_0_4_139 VGND VGND VPWR VPWR sky130_fd_sc_hd__fill_1
XFILLER_0_7_27 VPWR VGND VPWR VGND sky130_ef_sc_hd__decap_12
XFILLER_0_41_727 VGND VGND VPWR VPWR sky130_fd_sc_hd__fill_1
Xhold308 sum1\[10\] VGND VGND VPWR VPWR net350 sky130_fd_sc_hd__dlygate4sd3_1
X_4390_ _1430_ _1431_ _1422_ VGND VGND VPWR VPWR _1436_ sky130_fd_sc_hd__o21ai_2
Xhold319 _0042_ VGND VGND VPWR VPWR net361 sky130_fd_sc_hd__dlygate4sd3_1
XFILLER_0_68_35 VGND VGND VPWR VPWR sky130_fd_sc_hd__fill_1
XFILLER_0_68_24 VGND VGND VPWR VPWR sky130_fd_sc_hd__decap_4
XFILLER_0_40_237 VGND VGND VPWR VPWR sky130_fd_sc_hd__decap_6
XFILLER_0_110_147 VGND VGND VPWR VPWR sky130_fd_sc_hd__fill_1
XFILLER_0_0_345 VGND VGND VPWR VPWR sky130_fd_sc_hd__fill_2
XTAP_613 VGND VPWR sky130_fd_sc_hd__tapvpwrvgnd_1
XTAP_602 VGND VPWR sky130_fd_sc_hd__tapvpwrvgnd_1
XTAP_624 VGND VPWR sky130_fd_sc_hd__tapvpwrvgnd_1
X_6060_ _3065_ _3067_ _2997_ VGND VGND VPWR VPWR _3068_ sky130_fd_sc_hd__a21o_1
XTAP_635 VGND VPWR sky130_fd_sc_hd__tapvpwrvgnd_1
XTAP_646 VGND VPWR sky130_fd_sc_hd__tapvpwrvgnd_1
XTAP_657 VGND VPWR sky130_fd_sc_hd__tapvpwrvgnd_1
XTAP_668 VGND VPWR sky130_fd_sc_hd__tapvpwrvgnd_1
X_5011_ sh10\[2\] _2040_ sh12\[2\] VGND VGND VPWR VPWR _2041_ sky130_fd_sc_hd__o21ai_4
XTAP_679 VGND VPWR sky130_fd_sc_hd__tapvpwrvgnd_1
X_6962_ _3943_ _3947_ _3948_ _3873_ VGND VGND VPWR VPWR _3949_ sky130_fd_sc_hd__o2bb2ai_4
X_5913_ sh8\[6\] VGND VGND VPWR VPWR _2922_ sky130_fd_sc_hd__clkbuf_4
XFILLER_0_88_473 VGND VGND VPWR VPWR sky130_fd_sc_hd__decap_3
X_6893_ _3863_ _3860_ _3862_ _3788_ VGND VGND VPWR VPWR _3881_ sky130_fd_sc_hd__o31ai_1
X_8701_ clknet_leaf_56_clk _0110_ _0452_ VGND VGND VPWR VPWR bit_sum3\[2\] sky130_fd_sc_hd__dfrtp_1
X_8632_ clknet_leaf_32_clk net51 _0383_ VGND VGND VPWR VPWR s4\[6\] sky130_fd_sc_hd__dfrtp_1
X_5844_ _2849_ _2813_ _2844_ _2842_ VGND VGND VPWR VPWR _2857_ sky130_fd_sc_hd__o211ai_2
X_8563_ clknet_leaf_29_clk _0083_ _0314_ VGND VGND VPWR VPWR sum4\[13\] sky130_fd_sc_hd__dfrtp_1
XFILLER_0_75_156 VGND VGND VPWR VPWR sky130_fd_sc_hd__decap_6
X_7514_ _4159_ VGND VGND VPWR VPWR _0512_ sky130_fd_sc_hd__inv_2
XFILLER_0_99_3 VPWR VGND VPWR VGND sky130_ef_sc_hd__decap_12
X_5775_ net30 _2518_ sh15\[0\] VGND VGND VPWR VPWR _2790_ sky130_fd_sc_hd__a21oi_2
X_4726_ _1758_ _1762_ _1763_ VGND VGND VPWR VPWR _1764_ sky130_fd_sc_hd__o21ai_1
XFILLER_0_44_565 VGND VGND VPWR VPWR sky130_fd_sc_hd__decap_4
X_8494_ clknet_leaf_40_clk net126 _0245_ VGND VGND VPWR VPWR final_sum\[0\] sky130_fd_sc_hd__dfrtp_1
X_4657_ _1641_ _1638_ VGND VGND VPWR VPWR _1695_ sky130_fd_sc_hd__nor2_1
XFILLER_0_71_373 VPWR VGND VPWR VGND sky130_ef_sc_hd__decap_12
XFILLER_0_16_278 VGND VGND VPWR VPWR sky130_fd_sc_hd__decap_8
X_7445_ _4152_ VGND VGND VPWR VPWR _0450_ sky130_fd_sc_hd__inv_2
XFILLER_0_114_475 VGND VGND VPWR VPWR sky130_fd_sc_hd__fill_1
X_7376_ _4136_ VGND VGND VPWR VPWR _4145_ sky130_fd_sc_hd__buf_4
XFILLER_0_3_161 VGND VGND VPWR VPWR sky130_fd_sc_hd__decap_6
XFILLER_0_101_125 VPWR VGND VPWR VGND sky130_ef_sc_hd__decap_12
X_4588_ _1622_ _1628_ _1629_ VGND VGND VPWR VPWR _0134_ sky130_fd_sc_hd__a21oi_1
X_6327_ sh2\[4\] VGND VGND VPWR VPWR _3326_ sky130_fd_sc_hd__buf_4
X_6258_ _3161_ _3226_ _3221_ VGND VGND VPWR VPWR _3262_ sky130_fd_sc_hd__o21ai_1
X_6189_ _2923_ _3033_ sh14\[6\] VGND VGND VPWR VPWR _3194_ sky130_fd_sc_hd__o21ai_4
X_5209_ _2179_ _2236_ _2177_ VGND VGND VPWR VPWR _2237_ sky130_fd_sc_hd__o21a_1
XFILLER_0_99_727 VGND VGND VPWR VPWR sky130_fd_sc_hd__fill_1
XFILLER_0_79_440 VGND VGND VPWR VPWR sky130_fd_sc_hd__fill_1
XFILLER_0_67_602 VPWR VGND VPWR VGND sky130_ef_sc_hd__decap_12
XFILLER_0_94_421 VGND VGND VPWR VPWR sky130_fd_sc_hd__decap_4
XFILLER_0_79_484 VGND VGND VPWR VPWR sky130_fd_sc_hd__fill_2
XFILLER_0_79_473 VGND VGND VPWR VPWR sky130_fd_sc_hd__decap_4
XFILLER_0_94_443 VPWR VGND VPWR VGND sky130_ef_sc_hd__decap_12
XFILLER_0_39_337 VGND VGND VPWR VPWR sky130_fd_sc_hd__fill_2
XFILLER_0_81_137 VPWR VGND VPWR VGND sky130_ef_sc_hd__decap_12
XFILLER_0_35_521 VGND VGND VPWR VPWR sky130_fd_sc_hd__fill_1
XFILLER_0_62_351 VPWR VGND VPWR VGND sky130_ef_sc_hd__decap_12
XFILLER_0_35_565 VPWR VGND VPWR VGND sky130_ef_sc_hd__decap_12
XFILLER_0_90_693 VGND VGND VPWR VPWR sky130_fd_sc_hd__decap_6
XFILLER_0_23_727 VGND VGND VPWR VPWR sky130_fd_sc_hd__fill_1
XFILLER_0_50_513 VGND VGND VPWR VPWR sky130_fd_sc_hd__decap_6
XFILLER_0_50_557 VGND VGND VPWR VPWR sky130_fd_sc_hd__decap_4
XFILLER_0_50_579 VGND VGND VPWR VPWR sky130_fd_sc_hd__fill_1
XFILLER_0_30_292 VGND VGND VPWR VPWR sky130_fd_sc_hd__decap_3
XFILLER_0_101_692 VPWR VGND VPWR VGND sky130_ef_sc_hd__decap_12
XFILLER_0_89_204 VGND VGND VPWR VPWR sky130_fd_sc_hd__fill_1
XFILLER_0_89_237 VGND VGND VPWR VPWR sky130_fd_sc_hd__decap_3
XFILLER_0_57_167 VGND VGND VPWR VPWR sky130_fd_sc_hd__fill_1
XFILLER_0_73_649 VPWR VGND VPWR VGND sky130_ef_sc_hd__decap_12
X_5560_ _2578_ _2569_ VGND VGND VPWR VPWR _2579_ sky130_fd_sc_hd__nand2_1
XFILLER_0_26_554 VGND VGND VPWR VPWR sky130_fd_sc_hd__decap_8
X_4511_ _1243_ _1268_ VGND VGND VPWR VPWR _1555_ sky130_fd_sc_hd__nand2_1
XFILLER_0_108_291 VGND VGND VPWR VPWR sky130_fd_sc_hd__fill_1
XFILLER_0_81_671 VGND VGND VPWR VPWR sky130_fd_sc_hd__fill_1
XFILLER_0_53_362 VPWR VGND VPWR VGND sky130_ef_sc_hd__decap_12
X_5491_ _2508_ _2509_ VGND VGND VPWR VPWR _2510_ sky130_fd_sc_hd__nand2_2
X_4442_ _1231_ sh5\[5\] VGND VGND VPWR VPWR _1487_ sky130_fd_sc_hd__and2_1
Xhold105 bit_sum6\[8\] VGND VGND VPWR VPWR net147 sky130_fd_sc_hd__dlygate4sd3_1
Xhold116 final_sum\[11\] VGND VGND VPWR VPWR net158 sky130_fd_sc_hd__dlygate4sd3_1
X_7230_ _4130_ VGND VGND VPWR VPWR _0257_ sky130_fd_sc_hd__inv_2
XFILLER_0_13_248 VGND VGND VPWR VPWR sky130_fd_sc_hd__decap_8
Xhold127 sh9\[7\] VGND VGND VPWR VPWR net169 sky130_fd_sc_hd__dlygate4sd3_1
Xhold149 sh10\[6\] VGND VGND VPWR VPWR net191 sky130_fd_sc_hd__dlygate4sd3_1
Xhold138 sh2\[1\] VGND VGND VPWR VPWR net180 sky130_fd_sc_hd__dlygate4sd3_1
X_4373_ _1237_ _1238_ _1268_ VGND VGND VPWR VPWR _1419_ sky130_fd_sc_hd__o21bai_2
XFILLER_0_111_456 VPWR VGND VPWR VGND sky130_ef_sc_hd__decap_12
XFILLER_0_110_97 VPWR VGND VPWR VGND sky130_ef_sc_hd__decap_12
X_7161_ _4123_ VGND VGND VPWR VPWR _0195_ sky130_fd_sc_hd__inv_2
XFILLER_0_0_153 VPWR VGND VPWR VGND sky130_ef_sc_hd__decap_12
XFILLER_0_1_665 VGND VGND VPWR VPWR sky130_fd_sc_hd__decap_6
XFILLER_0_21_281 VGND VGND VPWR VPWR sky130_fd_sc_hd__decap_3
X_6112_ _3117_ _3118_ _3073_ VGND VGND VPWR VPWR _3119_ sky130_fd_sc_hd__o21ai_4
XTAP_432 VGND VPWR sky130_fd_sc_hd__tapvpwrvgnd_1
XTAP_421 VGND VPWR sky130_fd_sc_hd__tapvpwrvgnd_1
XTAP_410 VGND VPWR sky130_fd_sc_hd__tapvpwrvgnd_1
X_7092_ _4073_ _4074_ _4075_ VGND VGND VPWR VPWR _4076_ sky130_fd_sc_hd__a21o_1
XFILLER_0_0_197 VPWR VGND VPWR VGND sky130_ef_sc_hd__decap_12
XFILLER_0_119_51 VGND VGND VPWR VPWR sky130_fd_sc_hd__decap_4
X_6043_ _3029_ _3044_ VGND VGND VPWR VPWR _3051_ sky130_fd_sc_hd__nand2_1
XFILLER_0_95_77 VPWR VGND VPWR VGND sky130_ef_sc_hd__decap_12
XTAP_443 VGND VPWR sky130_fd_sc_hd__tapvpwrvgnd_1
XTAP_454 VGND VPWR sky130_fd_sc_hd__tapvpwrvgnd_1
XTAP_465 VGND VPWR sky130_fd_sc_hd__tapvpwrvgnd_1
XTAP_476 VGND VPWR sky130_fd_sc_hd__tapvpwrvgnd_1
XTAP_487 VGND VPWR sky130_fd_sc_hd__tapvpwrvgnd_1
XTAP_498 VGND VPWR sky130_fd_sc_hd__tapvpwrvgnd_1
XFILLER_0_28_93 VGND VGND VPWR VPWR sky130_fd_sc_hd__fill_1
XFILLER_0_14_3 VPWR VGND VPWR VGND sky130_ef_sc_hd__decap_12
X_7994_ _0839_ _0842_ VGND VGND VPWR VPWR _0843_ sky130_fd_sc_hd__nor2_1
XTAP_1609 VGND VPWR sky130_fd_sc_hd__tapvpwrvgnd_1
XFILLER_0_95_207 VPWR VGND VPWR VGND sky130_ef_sc_hd__decap_12
X_6945_ _3700_ _3702_ _3928_ VGND VGND VPWR VPWR _3932_ sky130_fd_sc_hd__a21o_1
XFILLER_0_48_101 VGND VGND VPWR VPWR sky130_fd_sc_hd__fill_1
XFILLER_0_119_512 VPWR VGND VPWR VGND sky130_ef_sc_hd__decap_12
XFILLER_0_76_443 VGND VGND VPWR VPWR sky130_fd_sc_hd__decap_3
XFILLER_0_76_421 VGND VGND VPWR VPWR sky130_fd_sc_hd__decap_8
XFILLER_0_44_92 VPWR VGND VPWR VGND sky130_ef_sc_hd__decap_12
XFILLER_0_91_402 VPWR VGND VPWR VGND sky130_ef_sc_hd__decap_12
XFILLER_0_76_454 VGND VGND VPWR VPWR sky130_fd_sc_hd__fill_2
XFILLER_0_64_616 VGND VGND VPWR VPWR sky130_fd_sc_hd__decap_4
XFILLER_0_9_721 VGND VGND VPWR VPWR sky130_fd_sc_hd__decap_6
X_6876_ _3863_ _3860_ net29 VGND VGND VPWR VPWR _3864_ sky130_fd_sc_hd__o21bai_2
XFILLER_0_36_307 VGND VGND VPWR VPWR sky130_fd_sc_hd__fill_1
XFILLER_0_107_729 VGND VGND VPWR VPWR sky130_fd_sc_hd__decap_6
XFILLER_0_107_718 VGND VGND VPWR VPWR sky130_fd_sc_hd__decap_8
XFILLER_0_63_126 VPWR VGND VPWR VGND sky130_ef_sc_hd__decap_12
XFILLER_0_17_510 VGND VGND VPWR VPWR sky130_fd_sc_hd__decap_4
X_5827_ _2839_ _2840_ _2791_ VGND VGND VPWR VPWR _2841_ sky130_fd_sc_hd__nand3_2
X_8615_ clknet_leaf_57_clk net54 _0366_ VGND VGND VPWR VPWR s2\[7\] sky130_fd_sc_hd__dfrtp_1
X_8546_ clknet_leaf_33_clk net274 _0297_ VGND VGND VPWR VPWR carry2\[8\] sky130_fd_sc_hd__dfrtp_1
X_5758_ _2487_ _2473_ _2772_ VGND VGND VPWR VPWR _2773_ sky130_fd_sc_hd__a21o_2
X_4709_ _1743_ _1745_ _1746_ VGND VGND VPWR VPWR _1747_ sky130_fd_sc_hd__and3_1
X_8477_ clknet_leaf_51_clk net148 _0228_ VGND VGND VPWR VPWR s0\[9\] sky130_fd_sc_hd__dfrtp_2
X_5689_ _2703_ _2704_ _2705_ VGND VGND VPWR VPWR _2706_ sky130_fd_sc_hd__nand3_2
X_7428_ _4150_ VGND VGND VPWR VPWR _0435_ sky130_fd_sc_hd__inv_2
XFILLER_0_32_557 VGND VGND VPWR VPWR sky130_fd_sc_hd__fill_2
X_7359_ _4143_ VGND VGND VPWR VPWR _0373_ sky130_fd_sc_hd__inv_2
XFILLER_0_102_489 VGND VGND VPWR VPWR sky130_fd_sc_hd__decap_3
XFILLER_0_12_292 VGND VGND VPWR VPWR sky130_fd_sc_hd__fill_1
XFILLER_0_99_546 VPWR VGND VPWR VGND sky130_ef_sc_hd__decap_12
XFILLER_0_94_240 VPWR VGND VPWR VGND sky130_ef_sc_hd__decap_12
XFILLER_0_27_329 VGND VGND VPWR VPWR sky130_fd_sc_hd__decap_6
XFILLER_0_63_671 VGND VGND VPWR VPWR sky130_fd_sc_hd__fill_1
XFILLER_0_112_209 VPWR VGND VPWR VGND sky130_ef_sc_hd__decap_12
XFILLER_0_23_557 VGND VGND VPWR VPWR sky130_fd_sc_hd__decap_3
XFILLER_0_121_721 VGND VGND VPWR VPWR sky130_fd_sc_hd__decap_4
XFILLER_0_49_15 VPWR VGND VPWR VGND sky130_ef_sc_hd__decap_12
XFILLER_0_120_264 VGND VGND VPWR VPWR sky130_fd_sc_hd__fill_2
X_4991_ _2018_ _2023_ VGND VGND VPWR VPWR _0187_ sky130_fd_sc_hd__nand2_1
XFILLER_0_81_57 VPWR VGND VPWR VGND sky130_ef_sc_hd__decap_12
X_6730_ _3708_ _3709_ _3710_ VGND VGND VPWR VPWR _3720_ sky130_fd_sc_hd__o21ai_1
X_6661_ _3302_ _3289_ _3654_ VGND VGND VPWR VPWR _3655_ sky130_fd_sc_hd__a21oi_2
XFILLER_0_73_435 VGND VGND VPWR VPWR sky130_fd_sc_hd__decap_3
XFILLER_0_45_104 VGND VGND VPWR VPWR sky130_fd_sc_hd__decap_8
X_8400_ _1226_ _1229_ _1223_ VGND VGND VPWR VPWR _1230_ sky130_fd_sc_hd__a21oi_2
X_6592_ _3518_ _3522_ _3586_ _3587_ VGND VGND VPWR VPWR _3588_ sky130_fd_sc_hd__nand4_2
XFILLER_0_6_713 VGND VGND VPWR VPWR sky130_fd_sc_hd__fill_2
X_5612_ _2629_ _2622_ _2627_ _2623_ VGND VGND VPWR VPWR _2630_ sky130_fd_sc_hd__o211a_1
X_8331_ sum5\[10\] s7\[10\] VGND VGND VPWR VPWR _1168_ sky130_fd_sc_hd__nor2_1
XFILLER_0_54_660 VGND VGND VPWR VPWR sky130_fd_sc_hd__decap_8
XFILLER_0_5_223 VGND VGND VPWR VPWR sky130_fd_sc_hd__fill_1
XFILLER_0_14_502 VGND VGND VPWR VPWR sky130_fd_sc_hd__decap_8
X_5543_ _2561_ _2559_ _2518_ VGND VGND VPWR VPWR _2562_ sky130_fd_sc_hd__o21bai_1
XFILLER_0_54_693 VGND VGND VPWR VPWR sky130_fd_sc_hd__decap_6
XFILLER_0_14_546 VPWR VGND VPWR VGND sky130_ef_sc_hd__decap_12
X_8262_ _1103_ _1104_ VGND VGND VPWR VPWR _1106_ sky130_fd_sc_hd__nor2_1
X_5474_ _2489_ _2491_ _2493_ VGND VGND VPWR VPWR _2494_ sky130_fd_sc_hd__o21ai_1
X_7213_ _4129_ VGND VGND VPWR VPWR _0241_ sky130_fd_sc_hd__inv_2
X_4425_ _1451_ _1453_ _1463_ _1464_ VGND VGND VPWR VPWR _1471_ sky130_fd_sc_hd__o211ai_4
X_8193_ _0967_ _0977_ _1036_ _1038_ VGND VGND VPWR VPWR _1039_ sky130_fd_sc_hd__nand4_2
X_4356_ _1369_ _1375_ _1376_ VGND VGND VPWR VPWR _1403_ sky130_fd_sc_hd__a21o_1
XFILLER_0_1_473 VPWR VGND VPWR VGND sky130_ef_sc_hd__decap_12
X_7144_ s0\[7\] s1\[7\] VGND VGND VPWR VPWR _4117_ sky130_fd_sc_hd__xnor2_1
XTAP_251 VGND VPWR sky130_fd_sc_hd__tapvpwrvgnd_1
X_4287_ _1325_ _1326_ _1322_ VGND VGND VPWR VPWR _1335_ sky130_fd_sc_hd__a21oi_2
XTAP_262 VGND VPWR sky130_fd_sc_hd__tapvpwrvgnd_1
XTAP_284 VGND VPWR sky130_fd_sc_hd__tapvpwrvgnd_1
XTAP_273 VGND VPWR sky130_fd_sc_hd__tapvpwrvgnd_1
X_7075_ _4015_ _4016_ _4052_ _4054_ VGND VGND VPWR VPWR _4060_ sky130_fd_sc_hd__o211ai_4
X_6026_ _2922_ _3033_ VGND VGND VPWR VPWR _3034_ sky130_fd_sc_hd__nor2_1
XTAP_295 VGND VPWR sky130_fd_sc_hd__tapvpwrvgnd_1
XFILLER_0_55_80 VGND VGND VPWR VPWR sky130_fd_sc_hd__decap_8
XTAP_1406 VGND VPWR sky130_fd_sc_hd__tapvpwrvgnd_1
XFILLER_0_68_229 VPWR VGND VPWR VGND sky130_ef_sc_hd__decap_12
XTAP_1439 VGND VPWR sky130_fd_sc_hd__tapvpwrvgnd_1
XTAP_1428 VGND VPWR sky130_fd_sc_hd__tapvpwrvgnd_1
XTAP_1417 VGND VPWR sky130_fd_sc_hd__tapvpwrvgnd_1
X_7977_ _0762_ VGND VGND VPWR VPWR _0826_ sky130_fd_sc_hd__buf_4
XFILLER_0_76_251 VGND VGND VPWR VPWR sky130_fd_sc_hd__fill_1
X_6928_ _3708_ _3912_ _3913_ _3914_ VGND VGND VPWR VPWR _3915_ sky130_fd_sc_hd__o211ai_4
XFILLER_0_37_605 VGND VGND VPWR VPWR sky130_fd_sc_hd__decap_8
XFILLER_0_92_733 VGND VGND VPWR VPWR sky130_fd_sc_hd__fill_2
Xfanout33 sh8\[4\] VGND VGND VPWR VPWR net33 sky130_fd_sc_hd__clkbuf_4
X_6859_ _3834_ _3836_ _3844_ _3846_ VGND VGND VPWR VPWR _3847_ sky130_fd_sc_hd__o22ai_4
XFILLER_0_91_232 VGND VGND VPWR VPWR sky130_fd_sc_hd__decap_8
XFILLER_0_9_573 VGND VGND VPWR VPWR sky130_fd_sc_hd__decap_8
XFILLER_0_36_159 VGND VGND VPWR VPWR sky130_fd_sc_hd__fill_2
XFILLER_0_107_559 VGND VGND VPWR VPWR sky130_fd_sc_hd__fill_1
XFILLER_0_17_351 VGND VGND VPWR VPWR sky130_fd_sc_hd__fill_1
X_8529_ clknet_leaf_39_clk _0073_ _0280_ VGND VGND VPWR VPWR sum3\[3\] sky130_fd_sc_hd__dfrtp_1
XFILLER_0_17_384 VGND VGND VPWR VPWR sky130_fd_sc_hd__fill_2
XFILLER_0_32_365 VGND VGND VPWR VPWR sky130_fd_sc_hd__decap_8
XFILLER_0_3_3 VPWR VGND VPWR VGND sky130_ef_sc_hd__decap_12
XFILLER_0_99_354 VGND VGND VPWR VPWR sky130_fd_sc_hd__decap_4
XFILLER_0_35_39 VGND VGND VPWR VPWR sky130_fd_sc_hd__decap_8
XFILLER_0_95_593 VGND VGND VPWR VPWR sky130_fd_sc_hd__fill_2
XFILLER_0_55_413 VPWR VGND VPWR VGND sky130_ef_sc_hd__decap_12
XFILLER_0_51_38 VGND VGND VPWR VPWR sky130_fd_sc_hd__fill_1
XFILLER_0_70_427 VGND VGND VPWR VPWR sky130_fd_sc_hd__decap_4
XFILLER_0_3_727 VGND VGND VPWR VPWR sky130_fd_sc_hd__fill_1
XFILLER_0_36_693 VGND VGND VPWR VPWR sky130_fd_sc_hd__decap_6
XFILLER_0_50_151 VGND VGND VPWR VPWR sky130_fd_sc_hd__decap_8
XFILLER_0_11_549 VGND VGND VPWR VPWR sky130_fd_sc_hd__decap_4
XFILLER_0_11_538 VGND VGND VPWR VPWR sky130_fd_sc_hd__fill_1
X_5190_ _2203_ _2204_ _2072_ VGND VGND VPWR VPWR _2218_ sky130_fd_sc_hd__o21bai_1
X_7900_ sh5\[3\] VGND VGND VPWR VPWR _0750_ sky130_fd_sc_hd__clkbuf_4
XFILLER_0_116_41 VPWR VGND VPWR VGND sky130_ef_sc_hd__decap_12
XFILLER_0_78_505 VGND VGND VPWR VPWR sky130_fd_sc_hd__decap_4
XFILLER_0_116_85 VPWR VGND VPWR VGND sky130_ef_sc_hd__decap_12
X_7831_ sum3\[7\] net312 s5\[7\] VGND VGND VPWR VPWR _0701_ sky130_fd_sc_hd__a21o_1
X_4974_ _2004_ _2005_ _1975_ _2006_ VGND VGND VPWR VPWR _2007_ sky130_fd_sc_hd__o211ai_4
X_7762_ _0662_ _0663_ VGND VGND VPWR VPWR _0092_ sky130_fd_sc_hd__nand2_1
X_6713_ sh2\[1\] VGND VGND VPWR VPWR _3703_ sky130_fd_sc_hd__buf_4
XFILLER_0_19_638 VPWR VGND VPWR VGND sky130_ef_sc_hd__decap_12
X_7693_ carry1\[4\] net405 _4210_ VGND VGND VPWR VPWR _0015_ sky130_fd_sc_hd__o21a_1
X_6644_ _3512_ _3588_ _3581_ VGND VGND VPWR VPWR _3639_ sky130_fd_sc_hd__a21oi_1
XFILLER_0_18_137 VGND VGND VPWR VPWR sky130_fd_sc_hd__decap_3
XFILLER_0_27_671 VGND VGND VPWR VPWR sky130_fd_sc_hd__fill_1
XFILLER_0_41_93 VPWR VGND VPWR VGND sky130_ef_sc_hd__decap_12
XFILLER_0_116_389 VGND VGND VPWR VPWR sky130_fd_sc_hd__fill_2
XFILLER_0_104_529 VGND VGND VPWR VPWR sky130_fd_sc_hd__decap_3
X_6575_ _3559_ _3564_ _3567_ VGND VGND VPWR VPWR _3571_ sky130_fd_sc_hd__a21bo_1
XFILLER_0_81_3 VPWR VGND VPWR VGND sky130_ef_sc_hd__decap_12
XFILLER_0_61_449 VPWR VGND VPWR VGND sky130_ef_sc_hd__decap_12
XFILLER_0_61_438 VGND VGND VPWR VPWR sky130_fd_sc_hd__decap_8
XFILLER_0_14_321 VGND VGND VPWR VPWR sky130_fd_sc_hd__fill_2
X_8314_ _1148_ _1149_ _1152_ VGND VGND VPWR VPWR _1153_ sky130_fd_sc_hd__and3_1
XFILLER_0_14_365 VGND VGND VPWR VPWR sky130_fd_sc_hd__decap_3
X_5526_ _2543_ _2542_ _2539_ VGND VGND VPWR VPWR _2545_ sky130_fd_sc_hd__nand3b_1
X_8245_ _1001_ _1083_ _1088_ VGND VGND VPWR VPWR _1090_ sky130_fd_sc_hd__nand3_1
X_5457_ sh0\[0\] VGND VGND VPWR VPWR _2477_ sky130_fd_sc_hd__clkbuf_4
X_4408_ _1395_ _1377_ _1398_ VGND VGND VPWR VPWR _1454_ sky130_fd_sc_hd__o21ai_2
XFILLER_0_100_713 VPWR VGND VPWR VGND sky130_ef_sc_hd__decap_12
X_8176_ _1011_ _1015_ _1017_ _1021_ VGND VGND VPWR VPWR _1022_ sky130_fd_sc_hd__o211ai_4
XFILLER_0_1_281 VGND VGND VPWR VPWR sky130_fd_sc_hd__decap_4
X_5388_ _2369_ _2406_ _2396_ _2401_ VGND VGND VPWR VPWR _2413_ sky130_fd_sc_hd__o211ai_1
X_4339_ _1382_ _1385_ sh12\[5\] VGND VGND VPWR VPWR _1386_ sky130_fd_sc_hd__o21bai_1
X_7127_ _3824_ _3822_ _3823_ VGND VGND VPWR VPWR _4108_ sky130_fd_sc_hd__nand3_1
X_7058_ sh15\[1\] _3787_ _3752_ VGND VGND VPWR VPWR _4043_ sky130_fd_sc_hd__and3_2
XFILLER_0_5_93 VPWR VGND VPWR VGND sky130_ef_sc_hd__decap_12
X_6009_ _2889_ _2911_ VGND VGND VPWR VPWR _3017_ sky130_fd_sc_hd__nand2_1
XTAP_1203 VGND VPWR sky130_fd_sc_hd__tapvpwrvgnd_1
XTAP_1214 VGND VPWR sky130_fd_sc_hd__tapvpwrvgnd_1
XFILLER_0_69_549 VGND VGND VPWR VPWR sky130_fd_sc_hd__decap_8
XTAP_1247 VGND VPWR sky130_fd_sc_hd__tapvpwrvgnd_1
XTAP_1236 VGND VPWR sky130_fd_sc_hd__tapvpwrvgnd_1
XTAP_1225 VGND VPWR sky130_fd_sc_hd__tapvpwrvgnd_1
XTAP_1269 VGND VPWR sky130_fd_sc_hd__tapvpwrvgnd_1
XTAP_1258 VGND VPWR sky130_fd_sc_hd__tapvpwrvgnd_1
XFILLER_0_92_530 VGND VGND VPWR VPWR sky130_fd_sc_hd__fill_2
XFILLER_0_64_287 VPWR VGND VPWR VGND sky130_ef_sc_hd__decap_12
XFILLER_0_52_416 VGND VGND VPWR VPWR sky130_fd_sc_hd__decap_4
XFILLER_0_18_660 VPWR VGND VPWR VGND sky130_ef_sc_hd__decap_12
XFILLER_0_52_449 VGND VGND VPWR VPWR sky130_fd_sc_hd__fill_2
XFILLER_0_33_641 VGND VGND VPWR VPWR sky130_fd_sc_hd__decap_8
XFILLER_0_122_326 VGND VGND VPWR VPWR sky130_fd_sc_hd__decap_3
XFILLER_0_33_685 VPWR VGND VPWR VGND sky130_ef_sc_hd__decap_12
XFILLER_0_20_368 VPWR VGND VPWR VGND sky130_ef_sc_hd__decap_12
XFILLER_0_46_27 VGND VGND VPWR VPWR sky130_fd_sc_hd__fill_1
Xclkbuf_leaf_57_clk clknet_3_1__leaf_clk VGND VGND VPWR VPWR clknet_leaf_57_clk sky130_fd_sc_hd__clkbuf_16
XFILLER_0_87_324 VGND VGND VPWR VPWR sky130_fd_sc_hd__decap_8
XFILLER_0_87_357 VGND VGND VPWR VPWR sky130_fd_sc_hd__fill_1
XFILLER_0_75_508 VPWR VGND VPWR VGND sky130_ef_sc_hd__decap_12
XTAP_1770 VGND VPWR sky130_fd_sc_hd__tapvpwrvgnd_1
XFILLER_0_68_582 VGND VGND VPWR VPWR sky130_fd_sc_hd__decap_6
XTAP_1792 VGND VPWR sky130_fd_sc_hd__tapvpwrvgnd_1
XTAP_1781 VGND VPWR sky130_fd_sc_hd__tapvpwrvgnd_1
XFILLER_0_7_329 VGND VGND VPWR VPWR sky130_fd_sc_hd__decap_6
XFILLER_0_28_435 VPWR VGND VPWR VGND sky130_ef_sc_hd__decap_12
X_4690_ _1717_ _1693_ _1727_ VGND VGND VPWR VPWR _1728_ sky130_fd_sc_hd__a21oi_1
XFILLER_0_55_276 VGND VGND VPWR VPWR sky130_fd_sc_hd__decap_4
XFILLER_0_28_468 VGND VGND VPWR VPWR sky130_fd_sc_hd__decap_8
XFILLER_0_24_630 VGND VGND VPWR VPWR sky130_fd_sc_hd__fill_1
XFILLER_0_43_438 VGND VGND VPWR VPWR sky130_fd_sc_hd__decap_8
XFILLER_0_43_449 VGND VGND VPWR VPWR sky130_fd_sc_hd__decap_6
XFILLER_0_113_337 VPWR VGND VPWR VGND sky130_ef_sc_hd__decap_12
X_6360_ sh14\[4\] _3358_ VGND VGND VPWR VPWR _3359_ sky130_fd_sc_hd__nand2_1
XFILLER_0_70_257 VGND VGND VPWR VPWR sky130_fd_sc_hd__fill_1
XFILLER_0_23_184 VGND VGND VPWR VPWR sky130_fd_sc_hd__decap_4
XFILLER_0_24_696 VGND VGND VPWR VPWR sky130_fd_sc_hd__decap_4
X_5311_ _2055_ _2322_ _2321_ _2319_ _2336_ VGND VGND VPWR VPWR _2337_ sky130_fd_sc_hd__o221ai_4
X_6291_ sh10\[4\] sh11\[4\] VGND VGND VPWR VPWR _3291_ sky130_fd_sc_hd__and2_1
X_8030_ _0814_ _0868_ VGND VGND VPWR VPWR _0878_ sky130_fd_sc_hd__nand2_2
X_5242_ _2268_ _2201_ VGND VGND VPWR VPWR _2269_ sky130_fd_sc_hd__nand2_2
X_5173_ _2057_ _2071_ _2072_ VGND VGND VPWR VPWR _2201_ sky130_fd_sc_hd__o21ai_2
Xinput1 rst VGND VGND VPWR VPWR net1 sky130_fd_sc_hd__buf_1
Xclkbuf_leaf_48_clk clknet_3_4__leaf_clk VGND VGND VPWR VPWR clknet_leaf_48_clk sky130_fd_sc_hd__clkbuf_16
XFILLER_0_36_71 VPWR VGND VPWR VGND sky130_ef_sc_hd__decap_12
XFILLER_0_78_313 VPWR VGND VPWR VGND sky130_ef_sc_hd__decap_12
X_8863_ clknet_leaf_4_clk net282 _0614_ VGND VGND VPWR VPWR sh14\[3\] sky130_fd_sc_hd__dfrtp_4
XFILLER_0_93_305 VGND VGND VPWR VPWR sky130_fd_sc_hd__fill_1
X_7814_ net222 _0692_ VGND VGND VPWR VPWR _0076_ sky130_fd_sc_hd__xnor2_1
X_8794_ clknet_leaf_6_clk net39 _0545_ VGND VGND VPWR VPWR sh5\[6\] sky130_fd_sc_hd__dfrtp_1
XFILLER_0_117_610 VGND VGND VPWR VPWR sky130_fd_sc_hd__fill_1
X_4957_ _1987_ _1988_ _1990_ VGND VGND VPWR VPWR _1991_ sky130_fd_sc_hd__a21boi_1
X_7745_ _0648_ _0649_ net281 VGND VGND VPWR VPWR _0650_ sky130_fd_sc_hd__o21ai_1
XFILLER_0_52_81 VGND VGND VPWR VPWR sky130_fd_sc_hd__decap_3
XFILLER_0_117_654 VGND VGND VPWR VPWR sky130_fd_sc_hd__fill_1
X_4888_ _1911_ _1917_ _1922_ VGND VGND VPWR VPWR _1923_ sky130_fd_sc_hd__nand3b_1
X_7676_ _4198_ _4199_ net301 VGND VGND VPWR VPWR _4200_ sky130_fd_sc_hd__o21ai_1
XFILLER_0_46_265 VPWR VGND VPWR VGND sky130_ef_sc_hd__decap_12
X_6627_ _3609_ _3612_ sh14\[4\] VGND VGND VPWR VPWR _3622_ sky130_fd_sc_hd__o21bai_1
XFILLER_0_116_197 VGND VGND VPWR VPWR sky130_fd_sc_hd__fill_1
X_6558_ _3294_ _3296_ _3326_ VGND VGND VPWR VPWR _3554_ sky130_fd_sc_hd__o21a_1
XFILLER_0_61_268 VPWR VGND VPWR VGND sky130_ef_sc_hd__decap_12
XFILLER_0_14_173 VPWR VGND VPWR VGND sky130_ef_sc_hd__decap_12
XFILLER_0_15_685 VPWR VGND VPWR VGND sky130_ef_sc_hd__decap_12
X_6489_ _3420_ _3423_ _3437_ VGND VGND VPWR VPWR _3486_ sky130_fd_sc_hd__o21ai_1
XFILLER_0_14_195 VGND VGND VPWR VPWR sky130_fd_sc_hd__fill_1
X_5509_ _2515_ _2517_ _2522_ _2525_ VGND VGND VPWR VPWR _2528_ sky130_fd_sc_hd__nand4_4
XFILLER_0_100_521 VGND VGND VPWR VPWR sky130_fd_sc_hd__fill_1
X_8228_ _1071_ _1072_ VGND VGND VPWR VPWR _1073_ sky130_fd_sc_hd__or2_2
X_8159_ _1002_ _1004_ _0746_ VGND VGND VPWR VPWR _1005_ sky130_fd_sc_hd__o21ai_2
Xclkbuf_leaf_39_clk clknet_3_5__leaf_clk VGND VGND VPWR VPWR clknet_leaf_39_clk sky130_fd_sc_hd__clkbuf_16
XFILLER_0_69_335 VGND VGND VPWR VPWR sky130_fd_sc_hd__fill_1
XFILLER_0_69_368 VGND VGND VPWR VPWR sky130_fd_sc_hd__decap_6
XTAP_1022 VGND VPWR sky130_fd_sc_hd__tapvpwrvgnd_1
XTAP_1011 VGND VPWR sky130_fd_sc_hd__tapvpwrvgnd_1
XTAP_1000 VGND VPWR sky130_fd_sc_hd__tapvpwrvgnd_1
XFILLER_0_84_305 VGND VGND VPWR VPWR sky130_fd_sc_hd__decap_3
XTAP_1055 VGND VPWR sky130_fd_sc_hd__tapvpwrvgnd_1
XTAP_1033 VGND VPWR sky130_fd_sc_hd__tapvpwrvgnd_1
XTAP_1044 VGND VPWR sky130_fd_sc_hd__tapvpwrvgnd_1
XFILLER_0_32_29 VGND VGND VPWR VPWR sky130_fd_sc_hd__decap_8
XFILLER_0_38_733 VGND VGND VPWR VPWR sky130_fd_sc_hd__fill_2
XFILLER_0_77_390 VGND VGND VPWR VPWR sky130_fd_sc_hd__fill_2
XTAP_1099 VGND VPWR sky130_fd_sc_hd__tapvpwrvgnd_1
XTAP_1088 VGND VPWR sky130_fd_sc_hd__tapvpwrvgnd_1
XTAP_1077 VGND VPWR sky130_fd_sc_hd__tapvpwrvgnd_1
XTAP_1066 VGND VPWR sky130_fd_sc_hd__tapvpwrvgnd_1
XFILLER_0_123_602 VGND VGND VPWR VPWR sky130_fd_sc_hd__decap_6
XFILLER_0_108_665 VGND VGND VPWR VPWR sky130_fd_sc_hd__decap_6
XFILLER_0_80_533 VGND VGND VPWR VPWR sky130_fd_sc_hd__fill_1
XFILLER_0_25_449 VGND VGND VPWR VPWR sky130_fd_sc_hd__decap_4
XFILLER_0_108_698 VGND VGND VPWR VPWR sky130_fd_sc_hd__fill_2
XFILLER_0_40_419 VGND VGND VPWR VPWR sky130_fd_sc_hd__fill_1
XFILLER_0_122_189 VGND VGND VPWR VPWR sky130_fd_sc_hd__decap_6
XFILLER_0_0_505 VPWR VGND VPWR VGND sky130_ef_sc_hd__decap_12
XFILLER_0_20_154 VGND VGND VPWR VPWR sky130_fd_sc_hd__fill_1
XTAP_806 VGND VPWR sky130_fd_sc_hd__tapvpwrvgnd_1
XTAP_817 VGND VPWR sky130_fd_sc_hd__tapvpwrvgnd_1
XTAP_828 VGND VPWR sky130_fd_sc_hd__tapvpwrvgnd_1
XTAP_839 VGND VPWR sky130_fd_sc_hd__tapvpwrvgnd_1
X_5860_ sh10\[6\] sh11\[6\] VGND VGND VPWR VPWR _2870_ sky130_fd_sc_hd__and2_2
X_4811_ _1835_ _1646_ _1846_ _1836_ VGND VGND VPWR VPWR _1847_ sky130_fd_sc_hd__o211ai_4
XFILLER_0_88_699 VGND VGND VPWR VPWR sky130_fd_sc_hd__fill_1
XFILLER_0_118_429 VGND VGND VPWR VPWR sky130_fd_sc_hd__decap_3
XFILLER_0_75_349 VGND VGND VPWR VPWR sky130_fd_sc_hd__fill_1
XFILLER_0_8_605 VGND VGND VPWR VPWR sky130_fd_sc_hd__fill_1
X_5791_ _2800_ _2797_ _2795_ VGND VGND VPWR VPWR _2806_ sky130_fd_sc_hd__a21o_1
X_4742_ _1651_ _1647_ _1700_ VGND VGND VPWR VPWR _1779_ sky130_fd_sc_hd__o21ai_4
X_7530_ _4160_ VGND VGND VPWR VPWR _0527_ sky130_fd_sc_hd__inv_2
XFILLER_0_7_137 VPWR VGND VPWR VGND sky130_ef_sc_hd__decap_12
XFILLER_0_16_416 VGND VGND VPWR VPWR sky130_fd_sc_hd__fill_1
XFILLER_0_28_276 VGND VGND VPWR VPWR sky130_fd_sc_hd__decap_8
XFILLER_0_44_725 VGND VGND VPWR VPWR sky130_fd_sc_hd__decap_8
X_4673_ _1704_ _1710_ VGND VGND VPWR VPWR _1711_ sky130_fd_sc_hd__nand2_1
X_7461_ _4153_ VGND VGND VPWR VPWR _0465_ sky130_fd_sc_hd__inv_2
XFILLER_0_16_449 VGND VGND VPWR VPWR sky130_fd_sc_hd__decap_6
XFILLER_0_114_613 VGND VGND VPWR VPWR sky130_fd_sc_hd__decap_4
X_6412_ _3406_ _3408_ _3409_ VGND VGND VPWR VPWR _3411_ sky130_fd_sc_hd__a21oi_2
X_7392_ _4146_ VGND VGND VPWR VPWR _0403_ sky130_fd_sc_hd__inv_2
XFILLER_0_3_321 VPWR VGND VPWR VGND sky130_ef_sc_hd__decap_12
X_6343_ _3327_ _3328_ sh6\[4\] VGND VGND VPWR VPWR _3342_ sky130_fd_sc_hd__o21ai_1
X_6274_ _3270_ _3276_ VGND VGND VPWR VPWR _3277_ sky130_fd_sc_hd__nand2_1
X_8013_ _0740_ _0747_ _0748_ VGND VGND VPWR VPWR _0861_ sky130_fd_sc_hd__o21ai_2
XFILLER_0_11_198 VPWR VGND VPWR VGND sky130_ef_sc_hd__decap_12
X_5225_ _2207_ _2209_ _2250_ _2055_ _2251_ VGND VGND VPWR VPWR _2252_ sky130_fd_sc_hd__o221a_2
XFILLER_0_44_3 VPWR VGND VPWR VGND sky130_ef_sc_hd__decap_12
X_5156_ _2129_ _2132_ _2130_ VGND VGND VPWR VPWR _2184_ sky130_fd_sc_hd__or3_1
XFILLER_0_98_419 VGND VGND VPWR VPWR sky130_fd_sc_hd__fill_1
XFILLER_0_79_600 VPWR VGND VPWR VGND sky130_ef_sc_hd__decap_12
X_5087_ _2107_ _2110_ _2109_ VGND VGND VPWR VPWR _2116_ sky130_fd_sc_hd__nand3_1
XFILLER_0_2_83 VGND VGND VPWR VPWR sky130_fd_sc_hd__fill_1
XFILLER_0_94_625 VGND VGND VPWR VPWR sky130_fd_sc_hd__decap_4
XFILLER_0_93_113 VPWR VGND VPWR VGND sky130_ef_sc_hd__decap_12
XFILLER_0_66_327 VGND VGND VPWR VPWR sky130_fd_sc_hd__fill_1
XPHY_116 VGND VGND VPWR VPWR sky130_fd_sc_hd__decap_3
XPHY_105 VGND VGND VPWR VPWR sky130_fd_sc_hd__decap_3
X_8846_ clknet_leaf_59_clk net193 _0597_ VGND VGND VPWR VPWR sh12\[2\] sky130_fd_sc_hd__dfrtp_4
X_8777_ clknet_leaf_10_clk net328 _0528_ VGND VGND VPWR VPWR sh3\[5\] sky130_fd_sc_hd__dfrtp_4
X_5989_ _2990_ _2992_ _2997_ VGND VGND VPWR VPWR _0137_ sky130_fd_sc_hd__a21oi_2
XPHY_149 VGND VGND VPWR VPWR sky130_fd_sc_hd__decap_3
XPHY_138 VGND VGND VPWR VPWR sky130_fd_sc_hd__decap_3
XPHY_127 VGND VGND VPWR VPWR sky130_fd_sc_hd__decap_3
XFILLER_0_93_157 VGND VGND VPWR VPWR sky130_fd_sc_hd__fill_2
X_7728_ carry4\[5\] sum4\[6\] VGND VGND VPWR VPWR _0636_ sky130_fd_sc_hd__and2_1
XFILLER_0_19_265 VPWR VGND VPWR VGND sky130_ef_sc_hd__decap_12
XFILLER_0_74_382 VGND VGND VPWR VPWR sky130_fd_sc_hd__decap_8
XFILLER_0_62_533 VPWR VGND VPWR VGND sky130_ef_sc_hd__decap_12
XFILLER_0_62_522 VGND VGND VPWR VPWR sky130_fd_sc_hd__decap_8
X_7659_ sum3\[9\] carry3\[8\] VGND VGND VPWR VPWR _4186_ sky130_fd_sc_hd__and2_1
XFILLER_0_7_671 VGND VGND VPWR VPWR sky130_fd_sc_hd__fill_1
XFILLER_0_30_430 VGND VGND VPWR VPWR sky130_fd_sc_hd__decap_6
XFILLER_0_30_485 VGND VGND VPWR VPWR sky130_fd_sc_hd__decap_3
XFILLER_0_100_373 VGND VGND VPWR VPWR sky130_fd_sc_hd__decap_8
XFILLER_0_57_305 VPWR VGND VPWR VGND sky130_ef_sc_hd__decap_12
XPHY_7 VGND VGND VPWR VPWR sky130_fd_sc_hd__decap_3
XFILLER_0_43_39 VPWR VGND VPWR VGND sky130_ef_sc_hd__decap_12
XFILLER_0_38_530 VGND VGND VPWR VPWR sky130_fd_sc_hd__fill_2
XFILLER_0_65_360 VPWR VGND VPWR VGND sky130_ef_sc_hd__decap_12
XFILLER_0_53_500 VGND VGND VPWR VPWR sky130_fd_sc_hd__decap_4
XFILLER_0_108_451 VGND VGND VPWR VPWR sky130_fd_sc_hd__fill_2
XFILLER_0_65_393 VPWR VGND VPWR VGND sky130_ef_sc_hd__decap_12
XFILLER_0_123_421 VPWR VGND VPWR VGND sky130_ef_sc_hd__decap_12
XFILLER_0_80_341 VPWR VGND VPWR VGND sky130_ef_sc_hd__decap_12
XFILLER_0_53_555 VGND VGND VPWR VPWR sky130_fd_sc_hd__fill_2
XFILLER_0_80_385 VGND VGND VPWR VPWR sky130_fd_sc_hd__decap_3
XFILLER_0_80_363 VGND VGND VPWR VPWR sky130_fd_sc_hd__fill_1
XFILLER_0_53_588 VGND VGND VPWR VPWR sky130_fd_sc_hd__decap_8
XFILLER_0_123_487 VPWR VGND VPWR VGND sky130_ef_sc_hd__decap_12
Xhold309 _0010_ VGND VGND VPWR VPWR net351 sky130_fd_sc_hd__dlygate4sd3_1
XFILLER_0_7_39 VPWR VGND VPWR VGND sky130_ef_sc_hd__decap_12
XFILLER_0_33_290 VGND VGND VPWR VPWR sky130_fd_sc_hd__decap_6
XFILLER_0_68_69 VGND VGND VPWR VPWR sky130_fd_sc_hd__fill_1
XFILLER_0_21_441 VGND VGND VPWR VPWR sky130_fd_sc_hd__decap_6
XFILLER_0_21_474 VGND VGND VPWR VPWR sky130_fd_sc_hd__decap_3
XTAP_614 VGND VPWR sky130_fd_sc_hd__tapvpwrvgnd_1
XTAP_603 VGND VPWR sky130_fd_sc_hd__tapvpwrvgnd_1
XTAP_625 VGND VPWR sky130_fd_sc_hd__tapvpwrvgnd_1
X_5010_ sh11\[2\] VGND VGND VPWR VPWR _2040_ sky130_fd_sc_hd__clkbuf_4
XTAP_636 VGND VPWR sky130_fd_sc_hd__tapvpwrvgnd_1
XTAP_647 VGND VPWR sky130_fd_sc_hd__tapvpwrvgnd_1
XTAP_658 VGND VPWR sky130_fd_sc_hd__tapvpwrvgnd_1
XTAP_669 VGND VPWR sky130_fd_sc_hd__tapvpwrvgnd_1
XFILLER_0_17_40 VGND VGND VPWR VPWR sky130_fd_sc_hd__decap_4
X_6961_ _3787_ net29 _3872_ VGND VGND VPWR VPWR _3948_ sky130_fd_sc_hd__a21oi_1
X_8700_ clknet_leaf_56_clk _0109_ _0451_ VGND VGND VPWR VPWR bit_sum3\[1\] sky130_fd_sc_hd__dfrtp_1
X_5912_ _2882_ _2914_ _2917_ _2916_ _2920_ VGND VGND VPWR VPWR _2921_ sky130_fd_sc_hd__o221ai_4
X_6892_ _3831_ _3871_ _3879_ VGND VGND VPWR VPWR _3880_ sky130_fd_sc_hd__nand3_1
XFILLER_0_75_113 VPWR VGND VPWR VGND sky130_ef_sc_hd__decap_12
X_8631_ clknet_leaf_54_clk net77 _0382_ VGND VGND VPWR VPWR s4\[5\] sky130_fd_sc_hd__dfrtp_1
XFILLER_0_29_541 VGND VGND VPWR VPWR sky130_fd_sc_hd__decap_8
X_5843_ _2842_ _2855_ VGND VGND VPWR VPWR _2856_ sky130_fd_sc_hd__xor2_1
XFILLER_0_118_226 VPWR VGND VPWR VGND sky130_ef_sc_hd__decap_12
X_8562_ clknet_leaf_29_clk _0082_ _0313_ VGND VGND VPWR VPWR sum4\[12\] sky130_fd_sc_hd__dfrtp_1
XFILLER_0_8_424 VPWR VGND VPWR VGND sky130_ef_sc_hd__decap_12
X_7513_ _4159_ VGND VGND VPWR VPWR _0511_ sky130_fd_sc_hd__inv_2
X_5774_ _2784_ _2787_ _2788_ VGND VGND VPWR VPWR _2789_ sky130_fd_sc_hd__a21o_1
XFILLER_0_29_585 VGND VGND VPWR VPWR sky130_fd_sc_hd__fill_1
X_8493_ clknet_leaf_20_clk net174 _0244_ VGND VGND VPWR VPWR net16 sky130_fd_sc_hd__dfrtp_1
X_4725_ _1669_ _1671_ _1760_ _1761_ VGND VGND VPWR VPWR _1763_ sky130_fd_sc_hd__o211ai_1
XFILLER_0_90_149 VPWR VGND VPWR VGND sky130_ef_sc_hd__decap_12
XFILLER_0_71_352 VGND VGND VPWR VPWR sky130_fd_sc_hd__fill_1
XFILLER_0_114_421 VGND VGND VPWR VPWR sky130_fd_sc_hd__decap_8
X_4656_ sh5\[7\] sh7\[7\] VGND VGND VPWR VPWR _1694_ sky130_fd_sc_hd__and2_1
XFILLER_0_71_385 VGND VGND VPWR VPWR sky130_fd_sc_hd__decap_6
XFILLER_0_4_641 VGND VGND VPWR VPWR sky130_fd_sc_hd__decap_3
X_7444_ _4152_ VGND VGND VPWR VPWR _0449_ sky130_fd_sc_hd__inv_2
X_4587_ _1622_ _1627_ _1626_ VGND VGND VPWR VPWR _1629_ sky130_fd_sc_hd__a21oi_1
X_7375_ _4144_ VGND VGND VPWR VPWR _0388_ sky130_fd_sc_hd__inv_2
XFILLER_0_101_137 VGND VGND VPWR VPWR sky130_fd_sc_hd__decap_8
X_6326_ net359 _3325_ VGND VGND VPWR VPWR _0101_ sky130_fd_sc_hd__xor2_1
X_6257_ _3253_ _3259_ _3213_ VGND VGND VPWR VPWR _3261_ sky130_fd_sc_hd__nand3_2
XFILLER_0_58_80 VGND VGND VPWR VPWR sky130_fd_sc_hd__fill_1
X_6188_ _3192_ VGND VGND VPWR VPWR _3193_ sky130_fd_sc_hd__buf_2
X_5208_ _2167_ _2174_ _2175_ VGND VGND VPWR VPWR _2236_ sky130_fd_sc_hd__a21boi_1
X_5139_ _2151_ _2157_ _2153_ _2166_ VGND VGND VPWR VPWR _2168_ sky130_fd_sc_hd__a31oi_1
XFILLER_0_98_238 VGND VGND VPWR VPWR sky130_fd_sc_hd__fill_1
XFILLER_0_79_430 VGND VGND VPWR VPWR sky130_fd_sc_hd__decap_6
XFILLER_0_67_614 VGND VGND VPWR VPWR sky130_fd_sc_hd__fill_2
X_8829_ clknet_leaf_49_clk net43 _0580_ VGND VGND VPWR VPWR sh10\[1\] sky130_fd_sc_hd__dfrtp_1
XFILLER_0_94_477 VGND VGND VPWR VPWR sky130_fd_sc_hd__decap_4
XFILLER_0_94_455 VGND VGND VPWR VPWR sky130_fd_sc_hd__fill_1
XFILLER_0_81_105 VGND VGND VPWR VPWR sky130_fd_sc_hd__decap_6
XFILLER_0_47_371 VGND VGND VPWR VPWR sky130_fd_sc_hd__fill_1
XFILLER_0_81_149 VPWR VGND VPWR VGND sky130_ef_sc_hd__decap_12
XFILLER_0_62_385 VGND VGND VPWR VPWR sky130_fd_sc_hd__decap_4
XFILLER_0_62_363 VGND VGND VPWR VPWR sky130_fd_sc_hd__fill_1
XFILLER_0_35_577 VPWR VGND VPWR VGND sky130_ef_sc_hd__decap_12
XFILLER_0_101_671 VGND VGND VPWR VPWR sky130_fd_sc_hd__fill_1
XFILLER_0_100_192 VGND VGND VPWR VPWR sky130_fd_sc_hd__decap_4
XFILLER_0_54_27 VGND VGND VPWR VPWR sky130_fd_sc_hd__fill_1
XFILLER_0_54_16 VGND VGND VPWR VPWR sky130_fd_sc_hd__fill_1
XFILLER_0_57_102 VGND VGND VPWR VPWR sky130_fd_sc_hd__fill_1
XFILLER_0_70_15 VGND VGND VPWR VPWR sky130_fd_sc_hd__decap_6
XFILLER_0_73_617 VPWR VGND VPWR VGND sky130_ef_sc_hd__decap_12
XFILLER_0_66_680 VPWR VGND VPWR VGND sky130_ef_sc_hd__decap_12
XFILLER_0_72_149 VGND VGND VPWR VPWR sky130_fd_sc_hd__fill_1
XFILLER_0_65_190 VGND VGND VPWR VPWR sky130_fd_sc_hd__decap_6
XFILLER_0_53_341 VGND VGND VPWR VPWR sky130_fd_sc_hd__fill_1
X_4510_ _1549_ _1550_ _1551_ _1553_ VGND VGND VPWR VPWR _1554_ sky130_fd_sc_hd__o211a_1
XFILLER_0_53_374 VPWR VGND VPWR VGND sky130_ef_sc_hd__decap_12
X_5490_ _2479_ sh2\[0\] sh6\[0\] VGND VGND VPWR VPWR _2509_ sky130_fd_sc_hd__o21ai_4
XFILLER_0_5_449 VGND VGND VPWR VPWR sky130_fd_sc_hd__fill_2
XFILLER_0_41_503 VGND VGND VPWR VPWR sky130_fd_sc_hd__fill_1
X_4441_ _1231_ _1239_ _1268_ VGND VGND VPWR VPWR _1486_ sky130_fd_sc_hd__o21a_1
XFILLER_0_102_3 VPWR VGND VPWR VGND sky130_ef_sc_hd__decap_12
XFILLER_0_80_171 VGND VGND VPWR VPWR sky130_fd_sc_hd__fill_1
XFILLER_0_79_57 VPWR VGND VPWR VGND sky130_ef_sc_hd__decap_12
Xhold106 bit_sum0\[9\] VGND VGND VPWR VPWR net148 sky130_fd_sc_hd__dlygate4sd3_1
Xhold117 final_sum\[5\] VGND VGND VPWR VPWR net159 sky130_fd_sc_hd__dlygate4sd3_1
Xhold128 sh7\[7\] VGND VGND VPWR VPWR net170 sky130_fd_sc_hd__dlygate4sd3_1
Xhold139 final_sum\[14\] VGND VGND VPWR VPWR net181 sky130_fd_sc_hd__dlygate4sd3_1
X_7160_ _4123_ VGND VGND VPWR VPWR _0194_ sky130_fd_sc_hd__inv_2
XFILLER_0_111_468 VGND VGND VPWR VPWR sky130_fd_sc_hd__decap_6
X_6111_ _3094_ _3114_ _3105_ _3112_ VGND VGND VPWR VPWR _3118_ sky130_fd_sc_hd__o211a_1
X_4372_ _1396_ _1400_ _1315_ _1405_ VGND VGND VPWR VPWR _1418_ sky130_fd_sc_hd__a2bb2oi_1
XFILLER_0_95_23 VGND VGND VPWR VPWR sky130_fd_sc_hd__fill_1
XTAP_400 VGND VPWR sky130_fd_sc_hd__tapvpwrvgnd_1
XFILLER_0_21_260 VPWR VGND VPWR VGND sky130_ef_sc_hd__decap_12
XTAP_433 VGND VPWR sky130_fd_sc_hd__tapvpwrvgnd_1
XTAP_422 VGND VPWR sky130_fd_sc_hd__tapvpwrvgnd_1
XTAP_411 VGND VPWR sky130_fd_sc_hd__tapvpwrvgnd_1
X_7091_ sh13\[1\] _3858_ _4026_ VGND VGND VPWR VPWR _4075_ sky130_fd_sc_hd__a21o_1
XFILLER_0_0_165 VGND VGND VPWR VPWR sky130_fd_sc_hd__decap_3
X_6042_ _3023_ _3049_ _3013_ _3021_ VGND VGND VPWR VPWR _3050_ sky130_fd_sc_hd__a2bb2oi_4
XFILLER_0_95_89 VPWR VGND VPWR VGND sky130_ef_sc_hd__decap_12
XTAP_444 VGND VPWR sky130_fd_sc_hd__tapvpwrvgnd_1
XTAP_455 VGND VPWR sky130_fd_sc_hd__tapvpwrvgnd_1
XTAP_466 VGND VPWR sky130_fd_sc_hd__tapvpwrvgnd_1
XTAP_477 VGND VPWR sky130_fd_sc_hd__tapvpwrvgnd_1
XTAP_488 VGND VPWR sky130_fd_sc_hd__tapvpwrvgnd_1
XTAP_499 VGND VPWR sky130_fd_sc_hd__tapvpwrvgnd_1
X_7993_ _0840_ _0841_ VGND VGND VPWR VPWR _0842_ sky130_fd_sc_hd__or2_1
XFILLER_0_95_219 VGND VGND VPWR VPWR sky130_fd_sc_hd__decap_4
X_6944_ _3752_ _3858_ _3859_ VGND VGND VPWR VPWR _3931_ sky130_fd_sc_hd__a21bo_1
XFILLER_0_49_614 VGND VGND VPWR VPWR sky130_fd_sc_hd__fill_2
XFILLER_0_49_625 VGND VGND VPWR VPWR sky130_fd_sc_hd__decap_3
XFILLER_0_48_113 VPWR VGND VPWR VGND sky130_ef_sc_hd__decap_12
XFILLER_0_119_524 VGND VGND VPWR VPWR sky130_fd_sc_hd__fill_2
XFILLER_0_76_477 VGND VGND VPWR VPWR sky130_fd_sc_hd__decap_8
X_6875_ sh8\[1\] sh9\[1\] VGND VGND VPWR VPWR _3863_ sky130_fd_sc_hd__nor2_1
X_8614_ clknet_leaf_57_clk net152 _0365_ VGND VGND VPWR VPWR s2\[6\] sky130_fd_sc_hd__dfrtp_1
XFILLER_0_91_436 VPWR VGND VPWR VGND sky130_ef_sc_hd__decap_12
XFILLER_0_91_414 VGND VGND VPWR VPWR sky130_fd_sc_hd__decap_4
X_5826_ _2799_ _2836_ _2796_ _2834_ _2831_ VGND VGND VPWR VPWR _2840_ sky130_fd_sc_hd__o2111ai_2
XFILLER_0_63_138 VGND VGND VPWR VPWR sky130_fd_sc_hd__fill_2
XFILLER_0_56_190 VGND VGND VPWR VPWR sky130_fd_sc_hd__decap_6
X_8545_ clknet_leaf_33_clk net386 _0296_ VGND VGND VPWR VPWR carry2\[7\] sky130_fd_sc_hd__dfrtp_1
X_5757_ sh4\[0\] _2506_ sh6\[0\] VGND VGND VPWR VPWR _2772_ sky130_fd_sc_hd__o21ai_4
XFILLER_0_8_287 VPWR VGND VPWR VGND sky130_ef_sc_hd__decap_12
XFILLER_0_29_393 VGND VGND VPWR VPWR sky130_fd_sc_hd__decap_6
X_4708_ _1642_ _1744_ sh14\[7\] VGND VGND VPWR VPWR _1746_ sky130_fd_sc_hd__o21ai_4
XFILLER_0_72_661 VPWR VGND VPWR VGND sky130_ef_sc_hd__decap_12
X_8476_ clknet_leaf_43_clk net99 _0227_ VGND VGND VPWR VPWR s0\[8\] sky130_fd_sc_hd__dfrtp_2
X_5688_ _2694_ _2697_ _2674_ _2675_ VGND VGND VPWR VPWR _2705_ sky130_fd_sc_hd__o2bb2ai_1
X_7427_ _4150_ VGND VGND VPWR VPWR _0434_ sky130_fd_sc_hd__inv_2
X_4639_ _1676_ VGND VGND VPWR VPWR _1677_ sky130_fd_sc_hd__buf_4
X_7358_ _4143_ VGND VGND VPWR VPWR _0372_ sky130_fd_sc_hd__inv_2
X_6309_ _3306_ _3307_ VGND VGND VPWR VPWR _3309_ sky130_fd_sc_hd__and2_2
X_7289_ _4137_ VGND VGND VPWR VPWR _0309_ sky130_fd_sc_hd__inv_2
XFILLER_0_99_558 VGND VGND VPWR VPWR sky130_fd_sc_hd__fill_2
XFILLER_0_95_720 VGND VGND VPWR VPWR sky130_fd_sc_hd__decap_8
XFILLER_0_55_617 VGND VGND VPWR VPWR sky130_fd_sc_hd__decap_8
XFILLER_0_48_691 VGND VGND VPWR VPWR sky130_fd_sc_hd__fill_1
XFILLER_0_82_458 VPWR VGND VPWR VGND sky130_ef_sc_hd__decap_12
XFILLER_0_40_29 VPWR VGND VPWR VGND sky130_ef_sc_hd__decap_12
XFILLER_0_63_694 VPWR VGND VPWR VGND sky130_ef_sc_hd__decap_12
XFILLER_0_2_419 VGND VGND VPWR VPWR sky130_fd_sc_hd__fill_1
XFILLER_0_23_536 VGND VGND VPWR VPWR sky130_fd_sc_hd__fill_2
XFILLER_0_35_396 VGND VGND VPWR VPWR sky130_fd_sc_hd__decap_4
XFILLER_0_120_221 VGND VGND VPWR VPWR sky130_fd_sc_hd__decap_4
XFILLER_0_11_709 VPWR VGND VPWR VGND sky130_ef_sc_hd__decap_12
XFILLER_0_23_569 VGND VGND VPWR VPWR sky130_fd_sc_hd__fill_2
XFILLER_0_49_27 VGND VGND VPWR VPWR sky130_fd_sc_hd__decap_6
XFILLER_0_65_15 VGND VGND VPWR VPWR sky130_fd_sc_hd__fill_2
XFILLER_0_4_29 VPWR VGND VPWR VGND sky130_ef_sc_hd__decap_12
XFILLER_0_77_208 VGND VGND VPWR VPWR sky130_fd_sc_hd__decap_3
X_4990_ _2019_ _1989_ _2021_ _1997_ _2022_ VGND VGND VPWR VPWR _2023_ sky130_fd_sc_hd__o2111ai_1
XFILLER_0_81_69 VPWR VGND VPWR VGND sky130_ef_sc_hd__decap_12
XFILLER_0_58_477 VGND VGND VPWR VPWR sky130_fd_sc_hd__decap_4
XFILLER_0_14_41 VGND VGND VPWR VPWR sky130_fd_sc_hd__decap_8
X_6660_ _3302_ _3289_ _3602_ VGND VGND VPWR VPWR _3654_ sky130_fd_sc_hd__a21oi_2
X_6591_ _3576_ _3577_ _3570_ _3574_ VGND VGND VPWR VPWR _3587_ sky130_fd_sc_hd__o211ai_1
X_5611_ _2484_ _2473_ _2482_ VGND VGND VPWR VPWR _2629_ sky130_fd_sc_hd__o21ai_2
X_8330_ _1157_ _1159_ _1161_ VGND VGND VPWR VPWR _1167_ sky130_fd_sc_hd__nand3_1
X_5542_ _2490_ net36 VGND VGND VPWR VPWR _2561_ sky130_fd_sc_hd__nor2_1
XFILLER_0_81_491 VGND VGND VPWR VPWR sky130_fd_sc_hd__decap_6
XFILLER_0_112_733 VGND VGND VPWR VPWR sky130_fd_sc_hd__fill_2
X_8261_ _1052_ _1100_ _1103_ _1104_ VGND VGND VPWR VPWR _1105_ sky130_fd_sc_hd__o22ai_4
XFILLER_0_14_558 VPWR VGND VPWR VGND sky130_ef_sc_hd__decap_12
X_5473_ net36 VGND VGND VPWR VPWR _2493_ sky130_fd_sc_hd__clkbuf_4
XFILLER_0_111_254 VGND VGND VPWR VPWR sky130_fd_sc_hd__fill_1
XFILLER_0_111_221 VGND VGND VPWR VPWR sky130_fd_sc_hd__decap_3
X_4424_ _1418_ _1465_ _1469_ VGND VGND VPWR VPWR _1470_ sky130_fd_sc_hd__nor3_1
X_7212_ _4129_ VGND VGND VPWR VPWR _0240_ sky130_fd_sc_hd__inv_2
X_8192_ _1030_ _1035_ _1037_ VGND VGND VPWR VPWR _1038_ sky130_fd_sc_hd__a21o_1
XFILLER_0_22_580 VGND VGND VPWR VPWR sky130_fd_sc_hd__fill_1
X_4355_ _1307_ _1309_ _1310_ _1305_ _1318_ VGND VGND VPWR VPWR _1402_ sky130_fd_sc_hd__a32oi_4
XFILLER_0_1_485 VPWR VGND VPWR VGND sky130_ef_sc_hd__decap_12
X_7143_ net212 _4116_ VGND VGND VPWR VPWR _0056_ sky130_fd_sc_hd__xnor2_1
X_7074_ _4056_ _4058_ VGND VGND VPWR VPWR _4059_ sky130_fd_sc_hd__nand2_2
X_4286_ _1332_ _1333_ VGND VGND VPWR VPWR _1334_ sky130_fd_sc_hd__nand2_1
XTAP_252 VGND VPWR sky130_fd_sc_hd__tapvpwrvgnd_1
XTAP_274 VGND VPWR sky130_fd_sc_hd__tapvpwrvgnd_1
XTAP_263 VGND VPWR sky130_fd_sc_hd__tapvpwrvgnd_1
X_6025_ sh9\[6\] VGND VGND VPWR VPWR _3033_ sky130_fd_sc_hd__clkbuf_4
XTAP_285 VGND VPWR sky130_fd_sc_hd__tapvpwrvgnd_1
XTAP_296 VGND VPWR sky130_fd_sc_hd__tapvpwrvgnd_1
XFILLER_0_96_528 VGND VGND VPWR VPWR sky130_fd_sc_hd__decap_4
XTAP_1429 VGND VPWR sky130_fd_sc_hd__tapvpwrvgnd_1
XTAP_1418 VGND VPWR sky130_fd_sc_hd__tapvpwrvgnd_1
XTAP_1407 VGND VPWR sky130_fd_sc_hd__tapvpwrvgnd_1
X_7976_ _0747_ _0748_ VGND VGND VPWR VPWR _0825_ sky130_fd_sc_hd__nor2_1
XFILLER_0_92_701 VGND VGND VPWR VPWR sky130_fd_sc_hd__decap_4
X_6927_ _3708_ _3709_ _3704_ VGND VGND VPWR VPWR _3914_ sky130_fd_sc_hd__o21ai_1
XFILLER_0_37_617 VPWR VGND VPWR VGND sky130_ef_sc_hd__decap_12
XFILLER_0_49_455 VPWR VGND VPWR VGND sky130_ef_sc_hd__decap_12
Xfanout34 sh7\[5\] VGND VGND VPWR VPWR net34 sky130_fd_sc_hd__clkbuf_4
XFILLER_0_76_263 VGND VGND VPWR VPWR sky130_fd_sc_hd__decap_6
X_6858_ _3845_ _3838_ _3843_ _3839_ VGND VGND VPWR VPWR _3846_ sky130_fd_sc_hd__o211a_2
XFILLER_0_107_505 VGND VGND VPWR VPWR sky130_fd_sc_hd__decap_8
XFILLER_0_91_244 VPWR VGND VPWR VGND sky130_ef_sc_hd__decap_12
XFILLER_0_64_469 VGND VGND VPWR VPWR sky130_fd_sc_hd__decap_6
XFILLER_0_17_330 VGND VGND VPWR VPWR sky130_fd_sc_hd__fill_1
X_5809_ _2805_ _2808_ _2803_ _2822_ VGND VGND VPWR VPWR _2823_ sky130_fd_sc_hd__a31o_1
X_6789_ _3723_ _3751_ _3753_ VGND VGND VPWR VPWR _3778_ sky130_fd_sc_hd__o21a_2
XFILLER_0_45_650 VPWR VGND VPWR VGND sky130_ef_sc_hd__decap_12
X_8528_ clknet_leaf_39_clk net49 _0279_ VGND VGND VPWR VPWR sum3\[2\] sky130_fd_sc_hd__dfrtp_1
XFILLER_0_44_193 VGND VGND VPWR VPWR sky130_fd_sc_hd__decap_3
X_8459_ clknet_leaf_26_clk net300 _0210_ VGND VGND VPWR VPWR carry5\[6\] sky130_fd_sc_hd__dfrtp_1
XFILLER_0_20_528 VGND VGND VPWR VPWR sky130_fd_sc_hd__decap_4
XFILLER_0_32_399 VGND VGND VPWR VPWR sky130_fd_sc_hd__fill_1
XFILLER_0_99_311 VPWR VGND VPWR VGND sky130_ef_sc_hd__decap_12
XFILLER_0_59_219 VGND VGND VPWR VPWR sky130_fd_sc_hd__decap_4
XFILLER_0_95_561 VPWR VGND VPWR VGND sky130_ef_sc_hd__decap_12
XFILLER_0_67_285 VGND VGND VPWR VPWR sky130_fd_sc_hd__fill_1
XFILLER_0_55_403 VGND VGND VPWR VPWR sky130_fd_sc_hd__decap_6
XFILLER_0_27_105 VGND VGND VPWR VPWR sky130_fd_sc_hd__decap_6
XFILLER_0_67_296 VGND VGND VPWR VPWR sky130_fd_sc_hd__fill_2
XFILLER_0_50_130 VGND VGND VPWR VPWR sky130_fd_sc_hd__fill_2
XFILLER_0_51_697 VGND VGND VPWR VPWR sky130_fd_sc_hd__fill_1
XFILLER_0_11_517 VGND VGND VPWR VPWR sky130_fd_sc_hd__decap_4
X_7830_ sum3\[6\] net259 _0700_ VGND VGND VPWR VPWR _0036_ sky130_fd_sc_hd__o21a_1
XFILLER_0_116_53 VPWR VGND VPWR VGND sky130_ef_sc_hd__decap_12
X_4973_ _1973_ _1979_ VGND VGND VPWR VPWR _2006_ sky130_fd_sc_hd__nand2_1
XFILLER_0_116_97 VGND VGND VPWR VPWR sky130_fd_sc_hd__decap_6
XFILLER_0_86_561 VPWR VGND VPWR VGND sky130_ef_sc_hd__decap_12
X_7761_ net346 _0660_ _0661_ VGND VGND VPWR VPWR _0663_ sky130_fd_sc_hd__or3_1
XFILLER_0_74_701 VGND VGND VPWR VPWR sky130_fd_sc_hd__fill_2
XFILLER_0_19_606 VGND VGND VPWR VPWR sky130_fd_sc_hd__decap_8
XFILLER_0_74_734 VGND VGND VPWR VPWR sky130_fd_sc_hd__fill_1
XFILLER_0_73_200 VGND VGND VPWR VPWR sky130_fd_sc_hd__decap_3
X_6712_ _3698_ _3701_ sh12\[1\] VGND VGND VPWR VPWR _3702_ sky130_fd_sc_hd__nand3b_4
XFILLER_0_46_403 VGND VGND VPWR VPWR sky130_fd_sc_hd__fill_2
X_7692_ carry1\[4\] sum1\[5\] net265 VGND VGND VPWR VPWR _4210_ sky130_fd_sc_hd__a21o_1
XFILLER_0_116_302 VGND VGND VPWR VPWR sky130_fd_sc_hd__fill_1
X_6643_ _3581_ _3601_ _3636_ _3637_ VGND VGND VPWR VPWR _3638_ sky130_fd_sc_hd__o211a_1
XFILLER_0_6_500 VPWR VGND VPWR VGND sky130_ef_sc_hd__decap_12
XFILLER_0_18_149 VGND VGND VPWR VPWR sky130_fd_sc_hd__fill_1
XFILLER_0_116_324 VGND VGND VPWR VPWR sky130_fd_sc_hd__fill_1
XFILLER_0_6_533 VGND VGND VPWR VPWR sky130_fd_sc_hd__fill_1
X_6574_ _3553_ _3568_ _3569_ VGND VGND VPWR VPWR _3570_ sky130_fd_sc_hd__nand3_2
XFILLER_0_54_480 VGND VGND VPWR VPWR sky130_fd_sc_hd__decap_4
X_8313_ _1151_ _1138_ _1146_ VGND VGND VPWR VPWR _1152_ sky130_fd_sc_hd__and3_1
XFILLER_0_14_355 VGND VGND VPWR VPWR sky130_fd_sc_hd__fill_1
X_5525_ _2539_ _2542_ _2543_ VGND VGND VPWR VPWR _2544_ sky130_fd_sc_hd__a21bo_2
X_8244_ _1083_ _1088_ _1001_ VGND VGND VPWR VPWR _1089_ sky130_fd_sc_hd__a21o_1
X_5456_ _2474_ _2475_ VGND VGND VPWR VPWR _2476_ sky130_fd_sc_hd__nor2_1
XFILLER_0_112_574 VPWR VGND VPWR VGND sky130_ef_sc_hd__decap_12
XFILLER_0_100_725 VGND VGND VPWR VPWR sky130_fd_sc_hd__decap_8
X_4407_ _1395_ _1377_ _1398_ _1452_ VGND VGND VPWR VPWR _1453_ sky130_fd_sc_hd__o211ai_4
XFILLER_0_112_596 VGND VGND VPWR VPWR sky130_fd_sc_hd__decap_3
X_8175_ _1018_ _1019_ _1020_ VGND VGND VPWR VPWR _1021_ sky130_fd_sc_hd__a21o_1
X_5387_ _2407_ _2409_ _2345_ VGND VGND VPWR VPWR _2412_ sky130_fd_sc_hd__o21ai_1
X_4338_ net32 _1384_ VGND VGND VPWR VPWR _1385_ sky130_fd_sc_hd__nor2_1
X_7126_ _4107_ _4102_ _4106_ VGND VGND VPWR VPWR _0153_ sky130_fd_sc_hd__a21o_1
X_4269_ _1316_ _1278_ _1313_ _1314_ _1312_ VGND VGND VPWR VPWR _1317_ sky130_fd_sc_hd__o221a_2
X_7057_ _4036_ _4040_ _4041_ VGND VGND VPWR VPWR _4042_ sky130_fd_sc_hd__nand3_2
X_6008_ _2878_ _2911_ sh3\[6\] VGND VGND VPWR VPWR _3016_ sky130_fd_sc_hd__o21a_1
XTAP_1204 VGND VPWR sky130_fd_sc_hd__tapvpwrvgnd_1
XFILLER_0_96_369 VGND VGND VPWR VPWR sky130_fd_sc_hd__fill_1
XTAP_1248 VGND VPWR sky130_fd_sc_hd__tapvpwrvgnd_1
XTAP_1237 VGND VPWR sky130_fd_sc_hd__tapvpwrvgnd_1
XTAP_1226 VGND VPWR sky130_fd_sc_hd__tapvpwrvgnd_1
XTAP_1215 VGND VPWR sky130_fd_sc_hd__tapvpwrvgnd_1
X_7959_ _0728_ _0758_ _0759_ net450 VGND VGND VPWR VPWR _0808_ sky130_fd_sc_hd__o211ai_1
XFILLER_0_77_561 VGND VGND VPWR VPWR sky130_fd_sc_hd__decap_6
XTAP_1259 VGND VPWR sky130_fd_sc_hd__tapvpwrvgnd_1
XFILLER_0_64_211 VPWR VGND VPWR VGND sky130_ef_sc_hd__decap_12
XFILLER_0_107_324 VGND VGND VPWR VPWR sky130_fd_sc_hd__decap_6
XFILLER_0_92_564 VGND VGND VPWR VPWR sky130_fd_sc_hd__decap_8
XFILLER_0_9_393 VPWR VGND VPWR VGND sky130_ef_sc_hd__decap_12
XFILLER_0_18_672 VPWR VGND VPWR VGND sky130_ef_sc_hd__decap_12
XFILLER_0_37_469 VPWR VGND VPWR VGND sky130_ef_sc_hd__decap_12
XFILLER_0_64_299 VGND VGND VPWR VPWR sky130_fd_sc_hd__decap_8
XFILLER_0_33_697 VPWR VGND VPWR VGND sky130_ef_sc_hd__decap_12
XTAP_1760 VGND VPWR sky130_fd_sc_hd__tapvpwrvgnd_1
XFILLER_0_56_712 VGND VGND VPWR VPWR sky130_fd_sc_hd__decap_4
XFILLER_0_28_425 VGND VGND VPWR VPWR sky130_fd_sc_hd__decap_3
XTAP_1793 VGND VPWR sky130_fd_sc_hd__tapvpwrvgnd_1
XTAP_1782 VGND VPWR sky130_fd_sc_hd__tapvpwrvgnd_1
XTAP_1771 VGND VPWR sky130_fd_sc_hd__tapvpwrvgnd_1
XFILLER_0_28_447 VGND VGND VPWR VPWR sky130_fd_sc_hd__decap_8
XFILLER_0_24_653 VGND VGND VPWR VPWR sky130_fd_sc_hd__fill_2
XFILLER_0_113_349 VPWR VGND VPWR VGND sky130_ef_sc_hd__decap_12
X_6290_ sh10\[4\] _3286_ VGND VGND VPWR VPWR _3290_ sky130_fd_sc_hd__nor2_1
XFILLER_0_11_303 VPWR VGND VPWR VGND sky130_ef_sc_hd__decap_12
XFILLER_0_23_163 VGND VGND VPWR VPWR sky130_fd_sc_hd__decap_4
X_5310_ _2321_ _2335_ sh6\[2\] VGND VGND VPWR VPWR _2336_ sky130_fd_sc_hd__o21bai_1
XFILLER_0_121_360 VGND VGND VPWR VPWR sky130_fd_sc_hd__fill_2
XFILLER_0_87_57 VPWR VGND VPWR VGND sky130_ef_sc_hd__decap_12
X_5241_ _2057_ _2071_ VGND VGND VPWR VPWR _2268_ sky130_fd_sc_hd__nand2_1
X_5172_ _2195_ _2196_ _2199_ VGND VGND VPWR VPWR _2200_ sky130_fd_sc_hd__o21ai_4
Xinput2 x[0] VGND VGND VPWR VPWR net2 sky130_fd_sc_hd__clkbuf_2
XFILLER_0_78_325 VGND VGND VPWR VPWR sky130_fd_sc_hd__decap_8
X_8862_ clknet_leaf_58_clk net93 _0613_ VGND VGND VPWR VPWR sh14\[2\] sky130_fd_sc_hd__dfrtp_4
XFILLER_0_36_83 VGND VGND VPWR VPWR sky130_fd_sc_hd__fill_1
X_8793_ clknet_leaf_9_clk net162 _0544_ VGND VGND VPWR VPWR sh5\[5\] sky130_fd_sc_hd__dfrtp_4
XFILLER_0_78_347 VGND VGND VPWR VPWR sky130_fd_sc_hd__fill_2
X_7813_ carry2\[5\] sum2\[6\] VGND VGND VPWR VPWR _0692_ sky130_fd_sc_hd__xnor2_1
X_7744_ carry4\[8\] s6\[9\] VGND VGND VPWR VPWR _0649_ sky130_fd_sc_hd__nor2_1
XFILLER_0_59_572 VGND VGND VPWR VPWR sky130_fd_sc_hd__decap_4
X_4956_ _1909_ _1938_ _1940_ VGND VGND VPWR VPWR _1990_ sky130_fd_sc_hd__o21a_1
X_4887_ _1919_ _1920_ _1921_ VGND VGND VPWR VPWR _1922_ sky130_fd_sc_hd__a21o_1
X_7675_ sum3\[12\] carry3\[11\] VGND VGND VPWR VPWR _4199_ sky130_fd_sc_hd__nor2_1
X_6626_ _3609_ _3610_ sh14\[4\] VGND VGND VPWR VPWR _3621_ sky130_fd_sc_hd__nand3b_1
XFILLER_0_74_597 VGND VGND VPWR VPWR sky130_fd_sc_hd__decap_8
XFILLER_0_61_225 VGND VGND VPWR VPWR sky130_fd_sc_hd__decap_8
XFILLER_0_34_428 VGND VGND VPWR VPWR sky130_fd_sc_hd__decap_8
X_6557_ _3491_ _3552_ VGND VGND VPWR VPWR _3553_ sky130_fd_sc_hd__nand2_1
X_5508_ _2515_ _2517_ _2526_ VGND VGND VPWR VPWR _2527_ sky130_fd_sc_hd__a21o_1
XFILLER_0_15_697 VPWR VGND VPWR VGND sky130_ef_sc_hd__decap_12
X_6488_ _3460_ _3302_ _3370_ VGND VGND VPWR VPWR _3485_ sky130_fd_sc_hd__a21oi_1
XFILLER_0_14_185 VGND VGND VPWR VPWR sky130_fd_sc_hd__decap_6
XFILLER_0_30_634 VGND VGND VPWR VPWR sky130_fd_sc_hd__decap_6
XFILLER_0_30_645 VGND VGND VPWR VPWR sky130_fd_sc_hd__fill_1
X_8227_ sh15\[3\] _0797_ _0826_ VGND VGND VPWR VPWR _1072_ sky130_fd_sc_hd__and3_1
X_5439_ _2452_ _2454_ _2460_ VGND VGND VPWR VPWR _2462_ sky130_fd_sc_hd__a21oi_1
X_8158_ _1003_ VGND VGND VPWR VPWR _1004_ sky130_fd_sc_hd__clkbuf_4
X_7109_ _4060_ _4092_ VGND VGND VPWR VPWR _4093_ sky130_fd_sc_hd__nand2_1
X_8089_ _0935_ _0738_ VGND VGND VPWR VPWR _0936_ sky130_fd_sc_hd__nand2_1
XFILLER_0_96_155 VGND VGND VPWR VPWR sky130_fd_sc_hd__fill_1
XTAP_1012 VGND VPWR sky130_fd_sc_hd__tapvpwrvgnd_1
XTAP_1001 VGND VPWR sky130_fd_sc_hd__tapvpwrvgnd_1
XTAP_1056 VGND VPWR sky130_fd_sc_hd__tapvpwrvgnd_1
XTAP_1034 VGND VPWR sky130_fd_sc_hd__tapvpwrvgnd_1
XTAP_1045 VGND VPWR sky130_fd_sc_hd__tapvpwrvgnd_1
XTAP_1023 VGND VPWR sky130_fd_sc_hd__tapvpwrvgnd_1
XFILLER_0_38_701 VPWR VGND VPWR VGND sky130_ef_sc_hd__decap_12
XFILLER_0_65_520 VGND VGND VPWR VPWR sky130_fd_sc_hd__decap_6
XTAP_1089 VGND VPWR sky130_fd_sc_hd__tapvpwrvgnd_1
XTAP_1078 VGND VPWR sky130_fd_sc_hd__tapvpwrvgnd_1
XTAP_1067 VGND VPWR sky130_fd_sc_hd__tapvpwrvgnd_1
XFILLER_0_107_154 VGND VGND VPWR VPWR sky130_fd_sc_hd__decap_8
XFILLER_0_52_203 VGND VGND VPWR VPWR sky130_fd_sc_hd__decap_8
XFILLER_0_33_483 VGND VGND VPWR VPWR sky130_fd_sc_hd__decap_3
XFILLER_0_0_517 VPWR VGND VPWR VGND sky130_ef_sc_hd__decap_12
XFILLER_0_33_494 VGND VGND VPWR VPWR sky130_fd_sc_hd__decap_8
XFILLER_0_21_667 VGND VGND VPWR VPWR sky130_fd_sc_hd__decap_4
XTAP_807 VGND VPWR sky130_fd_sc_hd__tapvpwrvgnd_1
XTAP_818 VGND VPWR sky130_fd_sc_hd__tapvpwrvgnd_1
XTAP_829 VGND VPWR sky130_fd_sc_hd__tapvpwrvgnd_1
XFILLER_0_73_15 VGND VGND VPWR VPWR sky130_fd_sc_hd__decap_4
XFILLER_0_87_133 VGND VGND VPWR VPWR sky130_fd_sc_hd__decap_3
X_4810_ _1650_ _1682_ _1781_ VGND VGND VPWR VPWR _1846_ sky130_fd_sc_hd__o21ai_2
XFILLER_0_75_306 VGND VGND VPWR VPWR sky130_fd_sc_hd__decap_4
XFILLER_0_7_105 VGND VGND VPWR VPWR sky130_fd_sc_hd__decap_6
X_5790_ _2726_ _2804_ _2757_ VGND VGND VPWR VPWR _2805_ sky130_fd_sc_hd__o21ai_2
X_4741_ _1650_ _1682_ _1777_ VGND VGND VPWR VPWR _1778_ sky130_fd_sc_hd__o21ai_2
XFILLER_0_113_65 VGND VGND VPWR VPWR sky130_fd_sc_hd__fill_2
XTAP_1590 VGND VPWR sky130_fd_sc_hd__tapvpwrvgnd_1
XFILLER_0_90_309 VGND VGND VPWR VPWR sky130_fd_sc_hd__decap_8
XFILLER_0_83_361 VGND VGND VPWR VPWR sky130_fd_sc_hd__fill_2
X_4672_ _1705_ _1708_ _1709_ VGND VGND VPWR VPWR _1710_ sky130_fd_sc_hd__nand3_4
X_7460_ _4153_ VGND VGND VPWR VPWR _0464_ sky130_fd_sc_hd__inv_2
XFILLER_0_7_149 VPWR VGND VPWR VGND sky130_ef_sc_hd__decap_12
XFILLER_0_22_74 VGND VGND VPWR VPWR sky130_fd_sc_hd__decap_3
XFILLER_0_22_85 VPWR VGND VPWR VGND sky130_ef_sc_hd__decap_12
XFILLER_0_43_225 VGND VGND VPWR VPWR sky130_fd_sc_hd__fill_2
XFILLER_0_113_113 VPWR VGND VPWR VGND sky130_ef_sc_hd__decap_12
X_6411_ _3406_ _3408_ _3409_ VGND VGND VPWR VPWR _3410_ sky130_fd_sc_hd__nand3_2
X_7391_ _4146_ VGND VGND VPWR VPWR _0402_ sky130_fd_sc_hd__inv_2
XFILLER_0_3_333 VGND VGND VPWR VPWR sky130_fd_sc_hd__decap_3
XFILLER_0_24_450 VGND VGND VPWR VPWR sky130_fd_sc_hd__decap_6
X_6342_ _3336_ _3340_ VGND VGND VPWR VPWR _3341_ sky130_fd_sc_hd__nand2_2
XFILLER_0_11_111 VGND VGND VPWR VPWR sky130_fd_sc_hd__fill_1
X_6273_ _3274_ _3275_ VGND VGND VPWR VPWR _3276_ sky130_fd_sc_hd__nor2_1
X_5224_ _2053_ _2055_ _2037_ VGND VGND VPWR VPWR _2251_ sky130_fd_sc_hd__o21bai_1
X_8012_ _0845_ _0835_ VGND VGND VPWR VPWR _0860_ sky130_fd_sc_hd__nor2_1
X_5155_ _2181_ _2182_ _2183_ VGND VGND VPWR VPWR _0155_ sky130_fd_sc_hd__a21oi_1
XFILLER_0_37_3 VPWR VGND VPWR VGND sky130_ef_sc_hd__decap_12
X_5086_ _2103_ _2105_ _2106_ VGND VGND VPWR VPWR _2115_ sky130_fd_sc_hd__o21ai_1
XFILLER_0_79_612 VGND VGND VPWR VPWR sky130_fd_sc_hd__decap_4
X_8845_ clknet_leaf_49_clk net203 _0596_ VGND VGND VPWR VPWR sh12\[1\] sky130_fd_sc_hd__dfrtp_1
XFILLER_0_63_70 VGND VGND VPWR VPWR sky130_fd_sc_hd__fill_1
XPHY_106 VGND VGND VPWR VPWR sky130_fd_sc_hd__decap_3
X_5988_ _2989_ _2992_ _2996_ VGND VGND VPWR VPWR _2997_ sky130_fd_sc_hd__a21oi_2
XFILLER_0_93_125 VPWR VGND VPWR VGND sky130_ef_sc_hd__decap_12
X_8776_ clknet_leaf_3_clk net187 _0527_ VGND VGND VPWR VPWR sh3\[4\] sky130_fd_sc_hd__dfrtp_1
XPHY_139 VGND VGND VPWR VPWR sky130_fd_sc_hd__decap_3
XPHY_128 VGND VGND VPWR VPWR sky130_fd_sc_hd__decap_3
XPHY_117 VGND VGND VPWR VPWR sky130_fd_sc_hd__decap_3
XFILLER_0_19_222 VGND VGND VPWR VPWR sky130_fd_sc_hd__fill_2
XFILLER_0_19_233 VPWR VGND VPWR VGND sky130_ef_sc_hd__decap_12
X_4939_ _1968_ _1971_ _1972_ VGND VGND VPWR VPWR _1973_ sky130_fd_sc_hd__a21o_1
XFILLER_0_93_169 VGND VGND VPWR VPWR sky130_fd_sc_hd__decap_8
XFILLER_0_81_309 VGND VGND VPWR VPWR sky130_fd_sc_hd__fill_2
X_7727_ _0635_ VGND VGND VPWR VPWR _0034_ sky130_fd_sc_hd__buf_1
XFILLER_0_117_430 VGND VGND VPWR VPWR sky130_fd_sc_hd__fill_2
X_7658_ net324 _4185_ VGND VGND VPWR VPWR _0088_ sky130_fd_sc_hd__nand2_1
XFILLER_0_19_277 VGND VGND VPWR VPWR sky130_fd_sc_hd__decap_3
XFILLER_0_34_214 VGND VGND VPWR VPWR sky130_fd_sc_hd__fill_1
X_6609_ sh4\[4\] _3289_ VGND VGND VPWR VPWR _3604_ sky130_fd_sc_hd__nor2_1
XFILLER_0_62_545 VPWR VGND VPWR VGND sky130_ef_sc_hd__decap_12
XFILLER_0_15_461 VGND VGND VPWR VPWR sky130_fd_sc_hd__decap_4
X_7589_ _4166_ VGND VGND VPWR VPWR _0580_ sky130_fd_sc_hd__inv_2
XFILLER_0_50_729 VGND VGND VPWR VPWR sky130_fd_sc_hd__decap_6
XFILLER_0_15_483 VGND VGND VPWR VPWR sky130_fd_sc_hd__fill_1
XFILLER_0_100_363 VGND VGND VPWR VPWR sky130_fd_sc_hd__fill_1
XFILLER_0_69_111 VGND VGND VPWR VPWR sky130_fd_sc_hd__fill_1
XFILLER_0_57_317 VGND VGND VPWR VPWR sky130_fd_sc_hd__decap_8
XPHY_8 VGND VGND VPWR VPWR sky130_fd_sc_hd__decap_3
XFILLER_0_72_309 VPWR VGND VPWR VGND sky130_ef_sc_hd__decap_12
XFILLER_0_65_383 VGND VGND VPWR VPWR sky130_fd_sc_hd__decap_8
XFILLER_0_65_372 VGND VGND VPWR VPWR sky130_fd_sc_hd__decap_8
XFILLER_0_123_433 VPWR VGND VPWR VGND sky130_ef_sc_hd__decap_12
XFILLER_0_123_477 VGND VGND VPWR VPWR sky130_fd_sc_hd__fill_2
XFILLER_0_111_617 VGND VGND VPWR VPWR sky130_fd_sc_hd__decap_8
XFILLER_0_123_499 VGND VGND VPWR VPWR sky130_fd_sc_hd__decap_4
XFILLER_0_21_486 VPWR VGND VPWR VGND sky130_ef_sc_hd__decap_12
XTAP_615 VGND VPWR sky130_fd_sc_hd__tapvpwrvgnd_1
XTAP_604 VGND VPWR sky130_fd_sc_hd__tapvpwrvgnd_1
XTAP_626 VGND VPWR sky130_fd_sc_hd__tapvpwrvgnd_1
XTAP_637 VGND VPWR sky130_fd_sc_hd__tapvpwrvgnd_1
XTAP_648 VGND VPWR sky130_fd_sc_hd__tapvpwrvgnd_1
XTAP_659 VGND VPWR sky130_fd_sc_hd__tapvpwrvgnd_1
X_6960_ _3878_ _3944_ _3945_ _3946_ VGND VGND VPWR VPWR _3947_ sky130_fd_sc_hd__o211ai_4
X_5911_ _2917_ _2909_ _2910_ VGND VGND VPWR VPWR _2920_ sky130_fd_sc_hd__o21ai_1
XFILLER_0_75_103 VGND VGND VPWR VPWR sky130_fd_sc_hd__decap_8
X_6891_ _3869_ _3874_ _3876_ _3878_ VGND VGND VPWR VPWR _3879_ sky130_fd_sc_hd__o22ai_1
XFILLER_0_48_306 VGND VGND VPWR VPWR sky130_fd_sc_hd__fill_2
XFILLER_0_75_125 VGND VGND VPWR VPWR sky130_fd_sc_hd__decap_8
X_8630_ clknet_leaf_54_clk net60 _0381_ VGND VGND VPWR VPWR s4\[4\] sky130_fd_sc_hd__dfrtp_1
X_5842_ _2853_ _2854_ VGND VGND VPWR VPWR _2855_ sky130_fd_sc_hd__nor2_1
XFILLER_0_118_238 VPWR VGND VPWR VGND sky130_ef_sc_hd__decap_12
X_8561_ clknet_leaf_27_clk _0081_ _0312_ VGND VGND VPWR VPWR sum4\[11\] sky130_fd_sc_hd__dfrtp_1
XFILLER_0_75_169 VGND VGND VPWR VPWR sky130_fd_sc_hd__decap_6
XFILLER_0_8_436 VGND VGND VPWR VPWR sky130_fd_sc_hd__decap_4
X_5773_ _2734_ _2745_ VGND VGND VPWR VPWR _2788_ sky130_fd_sc_hd__nand2_2
X_4724_ _1760_ _1761_ _1669_ _1671_ VGND VGND VPWR VPWR _1762_ sky130_fd_sc_hd__a211oi_1
XFILLER_0_90_139 VGND VGND VPWR VPWR sky130_fd_sc_hd__fill_1
X_7512_ _4159_ VGND VGND VPWR VPWR _0510_ sky130_fd_sc_hd__inv_2
XFILLER_0_29_597 VGND VGND VPWR VPWR sky130_fd_sc_hd__decap_3
X_8492_ clknet_leaf_20_clk net181 _0243_ VGND VGND VPWR VPWR net15 sky130_fd_sc_hd__dfrtp_1
X_4655_ _1680_ _1689_ _1692_ VGND VGND VPWR VPWR _1693_ sky130_fd_sc_hd__a21boi_4
X_7443_ _4147_ VGND VGND VPWR VPWR _4152_ sky130_fd_sc_hd__buf_4
X_4586_ _1626_ _1627_ VGND VGND VPWR VPWR _1628_ sky130_fd_sc_hd__and2_1
X_7374_ _4144_ VGND VGND VPWR VPWR _0387_ sky130_fd_sc_hd__inv_2
XFILLER_0_101_105 VGND VGND VPWR VPWR sky130_fd_sc_hd__decap_6
X_6325_ _3293_ _3322_ _3324_ VGND VGND VPWR VPWR _3325_ sky130_fd_sc_hd__o21a_2
X_6256_ sh15\[6\] _2906_ _2922_ _3253_ _3259_ VGND VGND VPWR VPWR _3260_ sky130_fd_sc_hd__a32o_1
XFILLER_0_110_694 VGND VGND VPWR VPWR sky130_fd_sc_hd__decap_6
X_6187_ sh13\[6\] sh9\[6\] VGND VGND VPWR VPWR _3192_ sky130_fd_sc_hd__and2_1
X_5207_ _2229_ _2233_ _2163_ VGND VGND VPWR VPWR _2235_ sky130_fd_sc_hd__and3_1
XFILLER_0_99_729 VGND VGND VPWR VPWR sky130_fd_sc_hd__decap_6
X_5138_ _2154_ _2158_ _2166_ VGND VGND VPWR VPWR _2167_ sky130_fd_sc_hd__o21ai_2
X_5069_ _2094_ _2090_ _2095_ VGND VGND VPWR VPWR _2098_ sky130_fd_sc_hd__o21ai_2
XFILLER_0_66_125 VPWR VGND VPWR VGND sky130_ef_sc_hd__decap_12
X_8828_ clknet_leaf_50_clk net279 _0579_ VGND VGND VPWR VPWR sh10\[0\] sky130_fd_sc_hd__dfrtp_2
XFILLER_0_82_618 VGND VGND VPWR VPWR sky130_fd_sc_hd__fill_1
X_8759_ clknet_leaf_5_clk net42 _0510_ VGND VGND VPWR VPWR sh1\[3\] sky130_fd_sc_hd__dfrtp_1
XFILLER_0_54_309 VPWR VGND VPWR VGND sky130_ef_sc_hd__decap_12
XFILLER_0_109_249 VGND VGND VPWR VPWR sky130_fd_sc_hd__fill_1
XFILLER_0_35_501 VGND VGND VPWR VPWR sky130_fd_sc_hd__decap_3
XFILLER_0_105_400 VGND VGND VPWR VPWR sky130_fd_sc_hd__decap_6
XFILLER_0_90_640 VGND VGND VPWR VPWR sky130_fd_sc_hd__fill_1
XFILLER_0_105_444 VGND VGND VPWR VPWR sky130_fd_sc_hd__decap_4
XFILLER_0_105_422 VPWR VGND VPWR VGND sky130_ef_sc_hd__decap_12
XFILLER_0_23_729 VGND VGND VPWR VPWR sky130_fd_sc_hd__decap_6
XFILLER_0_35_589 VGND VGND VPWR VPWR sky130_fd_sc_hd__decap_4
XFILLER_0_22_239 VPWR VGND VPWR VGND sky130_ef_sc_hd__decap_12
XFILLER_0_38_18 VGND VGND VPWR VPWR sky130_fd_sc_hd__decap_8
XFILLER_0_38_29 VPWR VGND VPWR VGND sky130_ef_sc_hd__decap_12
XFILLER_0_58_659 VGND VGND VPWR VPWR sky130_fd_sc_hd__decap_3
XFILLER_0_57_169 VGND VGND VPWR VPWR sky130_fd_sc_hd__decap_6
XFILLER_0_73_629 VGND VGND VPWR VPWR sky130_fd_sc_hd__decap_3
XFILLER_0_66_692 VGND VGND VPWR VPWR sky130_fd_sc_hd__decap_8
XFILLER_0_81_673 VGND VGND VPWR VPWR sky130_fd_sc_hd__decap_8
X_4440_ _1425_ _1436_ VGND VGND VPWR VPWR _1485_ sky130_fd_sc_hd__nand2_1
XFILLER_0_110_33 VGND VGND VPWR VPWR sky130_fd_sc_hd__fill_1
Xhold107 bit_sum5\[9\] VGND VGND VPWR VPWR net149 sky130_fd_sc_hd__dlygate4sd3_1
XFILLER_0_80_194 VGND VGND VPWR VPWR sky130_fd_sc_hd__fill_2
XFILLER_0_80_183 VGND VGND VPWR VPWR sky130_fd_sc_hd__decap_4
XFILLER_0_79_69 VPWR VGND VPWR VGND sky130_ef_sc_hd__decap_12
XFILLER_0_41_559 VGND VGND VPWR VPWR sky130_fd_sc_hd__fill_1
Xhold118 sh13\[6\] VGND VGND VPWR VPWR net160 sky130_fd_sc_hd__dlygate4sd3_1
Xhold129 final_sum\[4\] VGND VGND VPWR VPWR net171 sky130_fd_sc_hd__dlygate4sd3_1
X_6110_ _3105_ _3108_ _3112_ VGND VGND VPWR VPWR _3117_ sky130_fd_sc_hd__a21oi_2
X_4371_ _1352_ _1413_ _1415_ VGND VGND VPWR VPWR _1417_ sky130_fd_sc_hd__nand3_2
XFILLER_0_21_272 VGND VGND VPWR VPWR sky130_fd_sc_hd__decap_8
XTAP_423 VGND VPWR sky130_fd_sc_hd__tapvpwrvgnd_1
XTAP_412 VGND VPWR sky130_fd_sc_hd__tapvpwrvgnd_1
XTAP_401 VGND VPWR sky130_fd_sc_hd__tapvpwrvgnd_1
X_7090_ _3797_ _3740_ _4022_ _4032_ _4067_ VGND VGND VPWR VPWR _4074_ sky130_fd_sc_hd__o2111ai_2
XFILLER_0_21_294 VGND VGND VPWR VPWR sky130_fd_sc_hd__fill_2
X_6041_ _2970_ _2961_ _3048_ _2913_ VGND VGND VPWR VPWR _3049_ sky130_fd_sc_hd__a22oi_2
XTAP_445 VGND VPWR sky130_fd_sc_hd__tapvpwrvgnd_1
XTAP_434 VGND VPWR sky130_fd_sc_hd__tapvpwrvgnd_1
XTAP_456 VGND VPWR sky130_fd_sc_hd__tapvpwrvgnd_1
XTAP_467 VGND VPWR sky130_fd_sc_hd__tapvpwrvgnd_1
XTAP_478 VGND VPWR sky130_fd_sc_hd__tapvpwrvgnd_1
XTAP_489 VGND VPWR sky130_fd_sc_hd__tapvpwrvgnd_1
X_7992_ sh11\[3\] _0726_ VGND VGND VPWR VPWR _0841_ sky130_fd_sc_hd__and2_1
XFILLER_0_88_261 VGND VGND VPWR VPWR sky130_fd_sc_hd__decap_4
XFILLER_0_88_250 VGND VGND VPWR VPWR sky130_fd_sc_hd__fill_2
X_6943_ _3929_ VGND VGND VPWR VPWR _3930_ sky130_fd_sc_hd__clkbuf_2
X_6874_ _3861_ _3751_ VGND VGND VPWR VPWR _3862_ sky130_fd_sc_hd__nand2_4
XFILLER_0_44_83 VGND VGND VPWR VPWR sky130_fd_sc_hd__fill_1
XFILLER_0_48_125 VPWR VGND VPWR VGND sky130_ef_sc_hd__decap_12
X_5825_ _2796_ _2793_ _2831_ _2834_ VGND VGND VPWR VPWR _2839_ sky130_fd_sc_hd__a22o_1
XFILLER_0_36_309 VGND VGND VPWR VPWR sky130_fd_sc_hd__decap_6
X_8613_ clknet_leaf_57_clk net127 _0364_ VGND VGND VPWR VPWR s2\[5\] sky130_fd_sc_hd__dfrtp_1
XFILLER_0_48_169 VGND VGND VPWR VPWR sky130_fd_sc_hd__fill_1
XFILLER_0_63_117 VGND VGND VPWR VPWR sky130_fd_sc_hd__fill_1
XFILLER_0_29_361 VPWR VGND VPWR VGND sky130_ef_sc_hd__decap_12
X_8544_ clknet_leaf_33_clk net395 _0295_ VGND VGND VPWR VPWR carry2\[6\] sky130_fd_sc_hd__dfrtp_1
XFILLER_0_17_556 VGND VGND VPWR VPWR sky130_fd_sc_hd__decap_4
X_5756_ _2664_ _2721_ _2722_ _2767_ VGND VGND VPWR VPWR _2771_ sky130_fd_sc_hd__o211ai_4
X_4707_ _1636_ _1637_ sh14\[7\] _1744_ VGND VGND VPWR VPWR _1745_ sky130_fd_sc_hd__a211o_1
XFILLER_0_72_673 VGND VGND VPWR VPWR sky130_fd_sc_hd__decap_6
XFILLER_0_8_299 VGND VGND VPWR VPWR sky130_fd_sc_hd__fill_1
X_5687_ _2699_ _2700_ _2694_ _2697_ VGND VGND VPWR VPWR _2704_ sky130_fd_sc_hd__o211ai_1
X_8475_ clknet_leaf_42_clk net106 _0226_ VGND VGND VPWR VPWR s0\[7\] sky130_fd_sc_hd__dfrtp_2
X_4638_ _1638_ net31 VGND VGND VPWR VPWR _1676_ sky130_fd_sc_hd__and2_1
X_7426_ _4150_ VGND VGND VPWR VPWR _0433_ sky130_fd_sc_hd__inv_2
XFILLER_0_102_425 VPWR VGND VPWR VGND sky130_ef_sc_hd__decap_12
XFILLER_0_8_83 VGND VGND VPWR VPWR sky130_fd_sc_hd__fill_1
X_4569_ _1575_ _1573_ VGND VGND VPWR VPWR _1612_ sky130_fd_sc_hd__nor2_1
X_7357_ _4143_ VGND VGND VPWR VPWR _0371_ sky130_fd_sc_hd__inv_2
X_6308_ _3306_ _3307_ VGND VGND VPWR VPWR _3308_ sky130_fd_sc_hd__nor2_1
X_7288_ _4136_ VGND VGND VPWR VPWR _4137_ sky130_fd_sc_hd__clkbuf_8
X_6239_ _3240_ _3243_ VGND VGND VPWR VPWR _3244_ sky130_fd_sc_hd__and2_1
XTAP_990 VGND VPWR sky130_fd_sc_hd__tapvpwrvgnd_1
XFILLER_0_95_732 VGND VGND VPWR VPWR sky130_fd_sc_hd__decap_3
XFILLER_0_94_253 VGND VGND VPWR VPWR sky130_fd_sc_hd__decap_4
XFILLER_0_94_275 VPWR VGND VPWR VGND sky130_ef_sc_hd__decap_12
XFILLER_0_82_437 VGND VGND VPWR VPWR sky130_fd_sc_hd__fill_1
XFILLER_0_54_139 VGND VGND VPWR VPWR sky130_fd_sc_hd__fill_1
XFILLER_0_50_301 VGND VGND VPWR VPWR sky130_fd_sc_hd__decap_6
XFILLER_0_105_241 VGND VGND VPWR VPWR sky130_fd_sc_hd__fill_1
XFILLER_0_62_194 VGND VGND VPWR VPWR sky130_fd_sc_hd__fill_2
XFILLER_0_35_386 VGND VGND VPWR VPWR sky130_fd_sc_hd__decap_6
XFILLER_0_10_209 VGND VGND VPWR VPWR sky130_fd_sc_hd__decap_4
XFILLER_0_49_39 VPWR VGND VPWR VGND sky130_ef_sc_hd__decap_12
XFILLER_0_120_288 VGND VGND VPWR VPWR sky130_fd_sc_hd__decap_4
XFILLER_0_81_15 VPWR VGND VPWR VGND sky130_ef_sc_hd__decap_12
XFILLER_0_105_11 VGND VGND VPWR VPWR sky130_fd_sc_hd__decap_3
XFILLER_0_105_55 VGND VGND VPWR VPWR sky130_fd_sc_hd__fill_1
XFILLER_0_18_309 VPWR VGND VPWR VGND sky130_ef_sc_hd__decap_12
XFILLER_0_116_528 VGND VGND VPWR VPWR sky130_fd_sc_hd__decap_4
X_6590_ _3579_ _3578_ VGND VGND VPWR VPWR _3586_ sky130_fd_sc_hd__nand2_1
X_5610_ _2623_ _2626_ _2627_ VGND VGND VPWR VPWR _2628_ sky130_fd_sc_hd__a21oi_2
XFILLER_0_5_225 VGND VGND VPWR VPWR sky130_fd_sc_hd__decap_3
X_5541_ sh5\[0\] net36 sh8\[0\] VGND VGND VPWR VPWR _2560_ sky130_fd_sc_hd__o21ai_2
XFILLER_0_112_701 VPWR VGND VPWR VGND sky130_ef_sc_hd__decap_12
X_8260_ _1064_ _1102_ _1101_ VGND VGND VPWR VPWR _1104_ sky130_fd_sc_hd__and3_1
X_7211_ _4129_ VGND VGND VPWR VPWR _0239_ sky130_fd_sc_hd__inv_2
X_5472_ _2489_ _2491_ VGND VGND VPWR VPWR _2492_ sky130_fd_sc_hd__and2_1
XFILLER_0_30_85 VPWR VGND VPWR VGND sky130_ef_sc_hd__decap_12
X_4423_ _1468_ _1463_ _1464_ VGND VGND VPWR VPWR _1469_ sky130_fd_sc_hd__a21oi_1
X_8191_ _0969_ VGND VGND VPWR VPWR _1037_ sky130_fd_sc_hd__inv_2
X_4354_ _1377_ _1380_ _1395_ VGND VGND VPWR VPWR _1401_ sky130_fd_sc_hd__o21bai_1
X_7142_ net447 s1\[6\] VGND VGND VPWR VPWR _4116_ sky130_fd_sc_hd__xnor2_1
XFILLER_0_1_497 VGND VGND VPWR VPWR sky130_fd_sc_hd__decap_6
X_7073_ _4054_ _4052_ _4057_ VGND VGND VPWR VPWR _4058_ sky130_fd_sc_hd__a21o_1
X_4285_ _1331_ _1330_ _1329_ VGND VGND VPWR VPWR _1333_ sky130_fd_sc_hd__nand3b_1
X_6024_ sh8\[6\] sh9\[6\] net28 VGND VGND VPWR VPWR _3032_ sky130_fd_sc_hd__o21ai_4
XTAP_253 VGND VPWR sky130_fd_sc_hd__tapvpwrvgnd_1
XTAP_275 VGND VPWR sky130_fd_sc_hd__tapvpwrvgnd_1
XTAP_264 VGND VPWR sky130_fd_sc_hd__tapvpwrvgnd_1
XTAP_286 VGND VPWR sky130_fd_sc_hd__tapvpwrvgnd_1
XTAP_297 VGND VPWR sky130_fd_sc_hd__tapvpwrvgnd_1
XFILLER_0_55_93 VPWR VGND VPWR VGND sky130_ef_sc_hd__decap_12
X_7975_ _0750_ net35 VGND VGND VPWR VPWR _0824_ sky130_fd_sc_hd__and2_1
XTAP_1419 VGND VPWR sky130_fd_sc_hd__tapvpwrvgnd_1
XTAP_1408 VGND VPWR sky130_fd_sc_hd__tapvpwrvgnd_1
X_6926_ _3717_ _3704_ _3840_ VGND VGND VPWR VPWR _3913_ sky130_fd_sc_hd__a21oi_1
XFILLER_0_76_253 VGND VGND VPWR VPWR sky130_fd_sc_hd__decap_4
XFILLER_0_49_467 VGND VGND VPWR VPWR sky130_fd_sc_hd__decap_6
XFILLER_0_92_713 VPWR VGND VPWR VGND sky130_ef_sc_hd__decap_12
XFILLER_0_76_275 VGND VGND VPWR VPWR sky130_fd_sc_hd__decap_8
Xfanout35 sh7\[3\] VGND VGND VPWR VPWR net35 sky130_fd_sc_hd__buf_2
XFILLER_0_64_404 VPWR VGND VPWR VGND sky130_ef_sc_hd__decap_12
X_6857_ _3717_ _3703_ _3710_ VGND VGND VPWR VPWR _3845_ sky130_fd_sc_hd__o21ai_2
XFILLER_0_37_629 VGND VGND VPWR VPWR sky130_fd_sc_hd__decap_4
XFILLER_0_91_223 VGND VGND VPWR VPWR sky130_fd_sc_hd__fill_1
X_6788_ _3755_ _3775_ _3776_ VGND VGND VPWR VPWR _3777_ sky130_fd_sc_hd__nand3_2
X_5808_ _2810_ _2811_ _2812_ _2765_ VGND VGND VPWR VPWR _2822_ sky130_fd_sc_hd__a31o_1
XFILLER_0_91_256 VGND VGND VPWR VPWR sky130_fd_sc_hd__fill_1
X_5739_ _2743_ _2747_ _2754_ VGND VGND VPWR VPWR _2755_ sky130_fd_sc_hd__nand3_1
XFILLER_0_45_662 VGND VGND VPWR VPWR sky130_fd_sc_hd__decap_8
XFILLER_0_45_673 VPWR VGND VPWR VGND sky130_ef_sc_hd__decap_12
X_8527_ clknet_leaf_37_clk net105 _0278_ VGND VGND VPWR VPWR sum3\[1\] sky130_fd_sc_hd__dfrtp_1
XFILLER_0_32_323 VGND VGND VPWR VPWR sky130_fd_sc_hd__fill_1
XFILLER_0_44_161 VPWR VGND VPWR VGND sky130_ef_sc_hd__decap_12
X_8458_ clknet_leaf_39_clk _0045_ _0209_ VGND VGND VPWR VPWR carry5\[5\] sky130_fd_sc_hd__dfrtp_1
XFILLER_0_32_345 VGND VGND VPWR VPWR sky130_fd_sc_hd__decap_3
X_7409_ _4148_ VGND VGND VPWR VPWR _0418_ sky130_fd_sc_hd__inv_2
X_8389_ _1219_ _1220_ VGND VGND VPWR VPWR _1221_ sky130_fd_sc_hd__xnor2_1
XFILLER_0_60_698 VGND VGND VPWR VPWR sky130_fd_sc_hd__fill_2
XFILLER_0_99_323 VPWR VGND VPWR VGND sky130_ef_sc_hd__decap_12
XFILLER_0_99_367 VPWR VGND VPWR VGND sky130_ef_sc_hd__decap_12
XFILLER_0_67_231 VGND VGND VPWR VPWR sky130_fd_sc_hd__fill_1
XFILLER_0_95_573 VPWR VGND VPWR VGND sky130_ef_sc_hd__decap_12
XFILLER_0_27_139 VGND VGND VPWR VPWR sky130_fd_sc_hd__fill_2
XFILLER_0_70_418 VGND VGND VPWR VPWR sky130_fd_sc_hd__fill_2
XFILLER_0_23_301 VGND VGND VPWR VPWR sky130_fd_sc_hd__decap_8
XFILLER_0_3_729 VGND VGND VPWR VPWR sky130_fd_sc_hd__decap_6
XFILLER_0_23_334 VGND VGND VPWR VPWR sky130_fd_sc_hd__fill_2
XFILLER_0_23_389 VGND VGND VPWR VPWR sky130_fd_sc_hd__decap_3
XFILLER_0_76_15 VPWR VGND VPWR VGND sky130_ef_sc_hd__decap_12
XFILLER_0_116_65 VGND VGND VPWR VPWR sky130_fd_sc_hd__decap_8
X_4972_ _2003_ _2000_ _2001_ VGND VGND VPWR VPWR _2005_ sky130_fd_sc_hd__and3_1
X_7760_ _0660_ _0661_ net346 VGND VGND VPWR VPWR _0662_ sky130_fd_sc_hd__o21ai_1
XFILLER_0_25_74 VGND VGND VPWR VPWR sky130_fd_sc_hd__decap_8
XFILLER_0_86_573 VGND VGND VPWR VPWR sky130_fd_sc_hd__decap_3
XFILLER_0_58_253 VPWR VGND VPWR VGND sky130_ef_sc_hd__decap_12
X_6711_ sh10\[1\] sh11\[1\] VGND VGND VPWR VPWR _3701_ sky130_fd_sc_hd__nand2_2
X_7691_ carry1\[3\] net391 _4209_ VGND VGND VPWR VPWR _0014_ sky130_fd_sc_hd__o21a_1
X_6642_ _3335_ _3575_ _3634_ _3635_ _3361_ VGND VGND VPWR VPWR _3637_ sky130_fd_sc_hd__o2111ai_4
XFILLER_0_46_448 VGND VGND VPWR VPWR sky130_fd_sc_hd__fill_1
XFILLER_0_6_523 VGND VGND VPWR VPWR sky130_fd_sc_hd__decap_8
XFILLER_0_6_512 VGND VGND VPWR VPWR sky130_fd_sc_hd__fill_2
XFILLER_0_27_673 VPWR VGND VPWR VGND sky130_ef_sc_hd__decap_12
XFILLER_0_41_51 VGND VGND VPWR VPWR sky130_fd_sc_hd__decap_4
X_6573_ _3559_ _3564_ _3567_ VGND VGND VPWR VPWR _3569_ sky130_fd_sc_hd__a21o_1
X_8312_ _1150_ _1145_ net438 VGND VGND VPWR VPWR _1151_ sky130_fd_sc_hd__o21bai_1
XFILLER_0_6_589 VGND VGND VPWR VPWR sky130_fd_sc_hd__decap_8
X_5524_ _2475_ _2501_ _2474_ VGND VGND VPWR VPWR _2543_ sky130_fd_sc_hd__o21bai_1
XFILLER_0_112_531 VGND VGND VPWR VPWR sky130_fd_sc_hd__fill_1
X_8243_ _1075_ _1079_ _1080_ VGND VGND VPWR VPWR _1088_ sky130_fd_sc_hd__a21o_1
X_5455_ _2470_ _2472_ _2473_ VGND VGND VPWR VPWR _2475_ sky130_fd_sc_hd__a21oi_1
XFILLER_0_112_586 VGND VGND VPWR VPWR sky130_fd_sc_hd__fill_2
X_4406_ _1450_ _1435_ _1439_ VGND VGND VPWR VPWR _1452_ sky130_fd_sc_hd__nand3_2
XFILLER_0_67_3 VPWR VGND VPWR VGND sky130_ef_sc_hd__decap_12
X_8174_ _0797_ _0826_ VGND VGND VPWR VPWR _1020_ sky130_fd_sc_hd__xor2_1
XFILLER_0_1_261 VPWR VGND VPWR VGND sky130_ef_sc_hd__decap_12
X_7125_ _4099_ VGND VGND VPWR VPWR _4107_ sky130_fd_sc_hd__inv_2
X_5386_ _2368_ _2405_ _2410_ VGND VGND VPWR VPWR _2411_ sky130_fd_sc_hd__nand3b_2
X_4337_ sh9\[5\] VGND VGND VPWR VPWR _1384_ sky130_fd_sc_hd__clkbuf_4
XFILLER_0_5_51 VGND VGND VPWR VPWR sky130_fd_sc_hd__decap_4
X_4268_ _1274_ VGND VGND VPWR VPWR _1316_ sky130_fd_sc_hd__inv_2
X_7056_ _4033_ _4029_ _4032_ VGND VGND VPWR VPWR _4041_ sky130_fd_sc_hd__nand3_1
X_6007_ _2890_ _2883_ VGND VGND VPWR VPWR _3015_ sky130_fd_sc_hd__or2_1
XTAP_1205 VGND VPWR sky130_fd_sc_hd__tapvpwrvgnd_1
XTAP_1238 VGND VPWR sky130_fd_sc_hd__tapvpwrvgnd_1
XTAP_1227 VGND VPWR sky130_fd_sc_hd__tapvpwrvgnd_1
XTAP_1216 VGND VPWR sky130_fd_sc_hd__tapvpwrvgnd_1
X_7958_ _0806_ VGND VGND VPWR VPWR _0807_ sky130_fd_sc_hd__inv_2
XTAP_1249 VGND VPWR sky130_fd_sc_hd__tapvpwrvgnd_1
X_7889_ _0731_ _0738_ _0734_ VGND VGND VPWR VPWR _0739_ sky130_fd_sc_hd__nand3b_2
X_6909_ _3895_ _3896_ _3766_ VGND VGND VPWR VPWR _3897_ sky130_fd_sc_hd__o21ai_1
XFILLER_0_64_223 VPWR VGND VPWR VGND sky130_ef_sc_hd__decap_12
XFILLER_0_52_407 VGND VGND VPWR VPWR sky130_fd_sc_hd__fill_2
XFILLER_0_18_684 VPWR VGND VPWR VGND sky130_ef_sc_hd__decap_12
XFILLER_0_60_473 VGND VGND VPWR VPWR sky130_fd_sc_hd__decap_3
XFILLER_0_103_586 VGND VGND VPWR VPWR sky130_fd_sc_hd__decap_4
XFILLER_0_103_575 VGND VGND VPWR VPWR sky130_fd_sc_hd__decap_6
XFILLER_0_32_197 VPWR VGND VPWR VGND sky130_ef_sc_hd__decap_12
XFILLER_0_20_359 VGND VGND VPWR VPWR sky130_fd_sc_hd__fill_1
Xhold290 _4110_ VGND VGND VPWR VPWR net332 sky130_fd_sc_hd__dlygate4sd3_1
XFILLER_0_46_29 VGND VGND VPWR VPWR sky130_fd_sc_hd__decap_8
XFILLER_0_99_153 VPWR VGND VPWR VGND sky130_ef_sc_hd__decap_12
XTAP_1761 VGND VPWR sky130_fd_sc_hd__tapvpwrvgnd_1
XTAP_1750 VGND VPWR sky130_fd_sc_hd__tapvpwrvgnd_1
XFILLER_0_56_724 VGND VGND VPWR VPWR sky130_fd_sc_hd__decap_8
XTAP_1794 VGND VPWR sky130_fd_sc_hd__tapvpwrvgnd_1
XTAP_1783 VGND VPWR sky130_fd_sc_hd__tapvpwrvgnd_1
XTAP_1772 VGND VPWR sky130_fd_sc_hd__tapvpwrvgnd_1
XFILLER_0_55_212 VPWR VGND VPWR VGND sky130_ef_sc_hd__decap_12
XFILLER_0_70_226 VPWR VGND VPWR VGND sky130_ef_sc_hd__decap_12
XFILLER_0_43_429 VGND VGND VPWR VPWR sky130_fd_sc_hd__fill_1
XFILLER_0_102_67 VGND VGND VPWR VPWR sky130_fd_sc_hd__fill_2
XFILLER_0_3_526 VGND VGND VPWR VPWR sky130_fd_sc_hd__fill_1
XFILLER_0_11_315 VGND VGND VPWR VPWR sky130_fd_sc_hd__decap_4
XFILLER_0_23_153 VGND VGND VPWR VPWR sky130_fd_sc_hd__decap_3
XFILLER_0_51_462 VGND VGND VPWR VPWR sky130_fd_sc_hd__decap_4
XFILLER_0_121_350 VGND VGND VPWR VPWR sky130_fd_sc_hd__fill_1
XFILLER_0_11_337 VGND VGND VPWR VPWR sky130_fd_sc_hd__fill_2
X_5240_ _2252_ _2261_ _2266_ VGND VGND VPWR VPWR _2267_ sky130_fd_sc_hd__o21ai_2
XFILLER_0_87_69 VGND VGND VPWR VPWR sky130_fd_sc_hd__decap_8
X_5171_ _2161_ _2043_ _2195_ _2198_ VGND VGND VPWR VPWR _2199_ sky130_fd_sc_hd__o22ai_2
Xinput3 x[1] VGND VGND VPWR VPWR net3 sky130_fd_sc_hd__buf_1
X_8861_ clknet_leaf_57_clk net321 _0612_ VGND VGND VPWR VPWR sh14\[1\] sky130_fd_sc_hd__dfrtp_4
X_8792_ clknet_leaf_3_clk net432 _0543_ VGND VGND VPWR VPWR sh5\[4\] sky130_fd_sc_hd__dfrtp_4
X_7812_ net227 _0691_ VGND VGND VPWR VPWR _0075_ sky130_fd_sc_hd__xnor2_1
X_4955_ _1942_ _1939_ _1987_ _1988_ VGND VGND VPWR VPWR _1989_ sky130_fd_sc_hd__o211a_2
XFILLER_0_93_329 VGND VGND VPWR VPWR sky130_fd_sc_hd__decap_3
X_7743_ carry4\[8\] s6\[9\] VGND VGND VPWR VPWR _0648_ sky130_fd_sc_hd__and2_1
XFILLER_0_52_61 VPWR VGND VPWR VGND sky130_ef_sc_hd__decap_12
XFILLER_0_46_201 VGND VGND VPWR VPWR sky130_fd_sc_hd__decap_8
X_4886_ _1650_ _1651_ _1835_ VGND VGND VPWR VPWR _1921_ sky130_fd_sc_hd__o21ai_2
XFILLER_0_117_623 VGND VGND VPWR VPWR sky130_fd_sc_hd__decap_8
X_7674_ sum3\[12\] carry3\[11\] VGND VGND VPWR VPWR _4198_ sky130_fd_sc_hd__and2_1
X_6625_ _3615_ _3616_ _3619_ VGND VGND VPWR VPWR _3620_ sky130_fd_sc_hd__nand3_2
XFILLER_0_61_204 VPWR VGND VPWR VGND sky130_ef_sc_hd__decap_12
XFILLER_0_116_177 VPWR VGND VPWR VGND sky130_ef_sc_hd__decap_12
X_6556_ _3495_ _3498_ VGND VGND VPWR VPWR _3552_ sky130_fd_sc_hd__nand2_1
X_5507_ _2522_ _2525_ VGND VGND VPWR VPWR _2526_ sky130_fd_sc_hd__and2_1
X_6487_ _3426_ _3432_ _3427_ VGND VGND VPWR VPWR _3484_ sky130_fd_sc_hd__o21ai_1
X_8226_ _0797_ _0826_ sh15\[3\] VGND VGND VPWR VPWR _1071_ sky130_fd_sc_hd__a21oi_1
XFILLER_0_14_197 VGND VGND VPWR VPWR sky130_fd_sc_hd__decap_6
XFILLER_0_2_581 VGND VGND VPWR VPWR sky130_fd_sc_hd__decap_6
X_5438_ _2454_ _2460_ VGND VGND VPWR VPWR _2461_ sky130_fd_sc_hd__and2_1
XFILLER_0_100_545 VGND VGND VPWR VPWR sky130_fd_sc_hd__decap_8
X_8157_ sh1\[3\] sh5\[3\] VGND VGND VPWR VPWR _1003_ sky130_fd_sc_hd__and2_1
X_5369_ _2392_ _2393_ VGND VGND VPWR VPWR _2394_ sky130_fd_sc_hd__or2_2
X_8088_ _0730_ net42 _0772_ VGND VGND VPWR VPWR _0935_ sky130_fd_sc_hd__o21ba_1
X_7108_ _4086_ _4084_ _4085_ VGND VGND VPWR VPWR _4092_ sky130_fd_sc_hd__nand3_1
X_7039_ sh13\[1\] _3858_ VGND VGND VPWR VPWR _4024_ sky130_fd_sc_hd__nor2_1
XFILLER_0_69_337 VGND VGND VPWR VPWR sky130_fd_sc_hd__decap_3
XTAP_1013 VGND VPWR sky130_fd_sc_hd__tapvpwrvgnd_1
XTAP_1002 VGND VPWR sky130_fd_sc_hd__tapvpwrvgnd_1
XFILLER_0_96_189 VGND VGND VPWR VPWR sky130_fd_sc_hd__decap_6
XFILLER_0_96_178 VGND VGND VPWR VPWR sky130_fd_sc_hd__fill_1
XTAP_1035 VGND VPWR sky130_fd_sc_hd__tapvpwrvgnd_1
XTAP_1046 VGND VPWR sky130_fd_sc_hd__tapvpwrvgnd_1
XTAP_1024 VGND VPWR sky130_fd_sc_hd__tapvpwrvgnd_1
XFILLER_0_38_713 VPWR VGND VPWR VGND sky130_ef_sc_hd__decap_12
XFILLER_0_108_601 VGND VGND VPWR VPWR sky130_fd_sc_hd__decap_4
XTAP_1079 VGND VPWR sky130_fd_sc_hd__tapvpwrvgnd_1
XTAP_1068 VGND VPWR sky130_fd_sc_hd__tapvpwrvgnd_1
XTAP_1057 VGND VPWR sky130_fd_sc_hd__tapvpwrvgnd_1
XFILLER_0_53_716 VPWR VGND VPWR VGND sky130_ef_sc_hd__decap_12
XFILLER_0_108_645 VPWR VGND VPWR VGND sky130_ef_sc_hd__decap_12
XFILLER_0_92_373 VPWR VGND VPWR VGND sky130_ef_sc_hd__decap_12
XFILLER_0_123_615 VGND VGND VPWR VPWR sky130_fd_sc_hd__fill_1
XFILLER_0_18_492 VPWR VGND VPWR VGND sky130_ef_sc_hd__decap_12
XFILLER_0_110_309 VPWR VGND VPWR VGND sky130_ef_sc_hd__decap_12
XFILLER_0_103_350 VGND VGND VPWR VPWR sky130_fd_sc_hd__fill_1
XFILLER_0_0_529 VGND VGND VPWR VPWR sky130_fd_sc_hd__decap_3
XFILLER_0_103_372 VGND VGND VPWR VPWR sky130_fd_sc_hd__decap_8
XTAP_808 VGND VPWR sky130_fd_sc_hd__tapvpwrvgnd_1
XTAP_819 VGND VPWR sky130_fd_sc_hd__tapvpwrvgnd_1
XFILLER_0_87_101 VGND VGND VPWR VPWR sky130_fd_sc_hd__fill_1
XFILLER_0_28_223 VGND VGND VPWR VPWR sky130_fd_sc_hd__decap_3
X_4740_ net41 _1668_ net40 VGND VGND VPWR VPWR _1777_ sky130_fd_sc_hd__o21a_1
XFILLER_0_113_55 VGND VGND VPWR VPWR sky130_fd_sc_hd__fill_1
XTAP_1591 VGND VPWR sky130_fd_sc_hd__tapvpwrvgnd_1
XTAP_1580 VGND VPWR sky130_fd_sc_hd__tapvpwrvgnd_1
XFILLER_0_56_554 VGND VGND VPWR VPWR sky130_fd_sc_hd__decap_4
X_4671_ _1651_ _1682_ _1683_ VGND VGND VPWR VPWR _1709_ sky130_fd_sc_hd__o21a_1
XFILLER_0_113_77 VGND VGND VPWR VPWR sky130_fd_sc_hd__decap_4
XFILLER_0_56_587 VGND VGND VPWR VPWR sky130_fd_sc_hd__fill_1
XFILLER_0_22_53 VGND VGND VPWR VPWR sky130_fd_sc_hd__fill_2
X_7390_ _4146_ VGND VGND VPWR VPWR _0401_ sky130_fd_sc_hd__inv_2
X_6410_ _3318_ _3321_ _3293_ VGND VGND VPWR VPWR _3409_ sky130_fd_sc_hd__a21oi_2
XFILLER_0_22_97 VPWR VGND VPWR VGND sky130_ef_sc_hd__decap_12
XFILLER_0_113_125 VPWR VGND VPWR VGND sky130_ef_sc_hd__decap_12
X_6341_ _3337_ _3338_ _3339_ VGND VGND VPWR VPWR _3340_ sky130_fd_sc_hd__nand3_1
XFILLER_0_51_281 VPWR VGND VPWR VGND sky130_ef_sc_hd__decap_12
XFILLER_0_122_670 VPWR VGND VPWR VGND sky130_ef_sc_hd__decap_12
X_6272_ _3271_ _3273_ _3264_ VGND VGND VPWR VPWR _3275_ sky130_fd_sc_hd__a21oi_1
XFILLER_0_11_167 VGND VGND VPWR VPWR sky130_fd_sc_hd__fill_1
X_5223_ _2060_ _2061_ _2037_ VGND VGND VPWR VPWR _2250_ sky130_fd_sc_hd__o21ai_2
X_8011_ _0858_ _0859_ VGND VGND VPWR VPWR _0110_ sky130_fd_sc_hd__nor2_1
X_5154_ _2133_ _2134_ _2180_ _2182_ VGND VGND VPWR VPWR _2183_ sky130_fd_sc_hd__a22oi_4
X_5085_ _2089_ _2092_ _2069_ VGND VGND VPWR VPWR _2114_ sky130_fd_sc_hd__a21oi_2
XFILLER_0_47_94 VGND VGND VPWR VPWR sky130_fd_sc_hd__decap_4
XFILLER_0_2_41 VPWR VGND VPWR VGND sky130_ef_sc_hd__decap_12
XFILLER_0_2_85 VPWR VGND VPWR VGND sky130_ef_sc_hd__decap_12
X_8844_ clknet_leaf_50_clk net30 _0595_ VGND VGND VPWR VPWR sh12\[0\] sky130_fd_sc_hd__dfrtp_4
XPHY_107 VGND VGND VPWR VPWR sky130_fd_sc_hd__decap_3
XFILLER_0_109_409 VGND VGND VPWR VPWR sky130_fd_sc_hd__fill_2
XFILLER_0_93_137 VPWR VGND VPWR VGND sky130_ef_sc_hd__decap_12
X_5987_ _2995_ _2947_ _2948_ VGND VGND VPWR VPWR _2996_ sky130_fd_sc_hd__o21a_1
X_8775_ clknet_leaf_5_clk net223 _0526_ VGND VGND VPWR VPWR sh3\[3\] sky130_fd_sc_hd__dfrtp_2
XPHY_129 VGND VGND VPWR VPWR sky130_fd_sc_hd__decap_3
XPHY_118 VGND VGND VPWR VPWR sky130_fd_sc_hd__decap_3
XFILLER_0_47_521 VGND VGND VPWR VPWR sky130_fd_sc_hd__fill_1
X_4938_ _1911_ _1925_ _1917_ VGND VGND VPWR VPWR _1972_ sky130_fd_sc_hd__o21ai_4
X_7726_ carry3\[3\] sum3\[4\] VGND VGND VPWR VPWR _0635_ sky130_fd_sc_hd__and2_1
XFILLER_0_19_245 VGND VGND VPWR VPWR sky130_fd_sc_hd__decap_8
X_4869_ _1899_ _1902_ _1904_ VGND VGND VPWR VPWR _1905_ sky130_fd_sc_hd__a21oi_2
X_7657_ net323 _4182_ _4183_ VGND VGND VPWR VPWR _4185_ sky130_fd_sc_hd__or3_1
XFILLER_0_35_727 VGND VGND VPWR VPWR sky130_fd_sc_hd__fill_1
XFILLER_0_105_615 VGND VGND VPWR VPWR sky130_fd_sc_hd__fill_1
X_6608_ sh4\[4\] _3326_ VGND VGND VPWR VPWR _3603_ sky130_fd_sc_hd__and2_2
XFILLER_0_62_557 VGND VGND VPWR VPWR sky130_fd_sc_hd__decap_8
XFILLER_0_7_673 VPWR VGND VPWR VGND sky130_ef_sc_hd__decap_12
X_7588_ _4166_ VGND VGND VPWR VPWR _0579_ sky130_fd_sc_hd__inv_2
X_6539_ sh15\[4\] VGND VGND VPWR VPWR _3536_ sky130_fd_sc_hd__inv_2
XFILLER_0_30_410 VGND VGND VPWR VPWR sky130_fd_sc_hd__fill_1
XFILLER_0_30_421 VGND VGND VPWR VPWR sky130_fd_sc_hd__fill_2
XFILLER_0_100_331 VGND VGND VPWR VPWR sky130_fd_sc_hd__fill_1
X_8209_ sh13\[3\] _0892_ VGND VGND VPWR VPWR _1054_ sky130_fd_sc_hd__nor2_1
XFILLER_0_69_167 VGND VGND VPWR VPWR sky130_fd_sc_hd__fill_1
XPHY_9 VGND VGND VPWR VPWR sky130_fd_sc_hd__decap_3
XFILLER_0_38_521 VGND VGND VPWR VPWR sky130_fd_sc_hd__decap_6
XFILLER_0_93_671 VGND VGND VPWR VPWR sky130_fd_sc_hd__fill_1
XFILLER_0_26_727 VGND VGND VPWR VPWR sky130_fd_sc_hd__decap_8
XFILLER_0_38_576 VPWR VGND VPWR VGND sky130_ef_sc_hd__decap_12
XFILLER_0_80_321 VPWR VGND VPWR VGND sky130_ef_sc_hd__decap_12
XFILLER_0_4_109 VPWR VGND VPWR VGND sky130_ef_sc_hd__decap_12
XFILLER_0_25_248 VGND VGND VPWR VPWR sky130_fd_sc_hd__decap_6
XFILLER_0_123_445 VGND VGND VPWR VPWR sky130_fd_sc_hd__decap_3
XFILLER_0_80_365 VPWR VGND VPWR VGND sky130_ef_sc_hd__decap_12
XFILLER_0_25_259 VGND VGND VPWR VPWR sky130_fd_sc_hd__fill_1
XFILLER_0_33_281 VGND VGND VPWR VPWR sky130_fd_sc_hd__decap_4
XFILLER_0_0_337 VGND VGND VPWR VPWR sky130_fd_sc_hd__decap_8
XFILLER_0_103_180 VPWR VGND VPWR VGND sky130_ef_sc_hd__decap_12
XFILLER_0_21_498 VGND VGND VPWR VPWR sky130_fd_sc_hd__decap_6
XTAP_616 VGND VPWR sky130_fd_sc_hd__tapvpwrvgnd_1
XTAP_605 VGND VPWR sky130_fd_sc_hd__tapvpwrvgnd_1
XTAP_627 VGND VPWR sky130_fd_sc_hd__tapvpwrvgnd_1
XTAP_638 VGND VPWR sky130_fd_sc_hd__tapvpwrvgnd_1
XTAP_649 VGND VPWR sky130_fd_sc_hd__tapvpwrvgnd_1
XFILLER_0_84_15 VPWR VGND VPWR VGND sky130_ef_sc_hd__decap_12
XFILLER_0_108_44 VPWR VGND VPWR VGND sky130_ef_sc_hd__decap_12
X_5910_ _2909_ _2913_ _2915_ _2918_ VGND VGND VPWR VPWR _2919_ sky130_fd_sc_hd__o211ai_2
X_6890_ _3780_ _3877_ _3847_ _3852_ VGND VGND VPWR VPWR _3878_ sky130_fd_sc_hd__o211a_2
X_5841_ _2839_ _2841_ _2852_ VGND VGND VPWR VPWR _2854_ sky130_fd_sc_hd__a21oi_1
XFILLER_0_119_729 VGND VGND VPWR VPWR sky130_fd_sc_hd__decap_6
X_8560_ clknet_leaf_30_clk _0080_ _0311_ VGND VGND VPWR VPWR sum4\[10\] sky130_fd_sc_hd__dfrtp_1
X_5772_ _2785_ _2777_ _2786_ VGND VGND VPWR VPWR _2787_ sky130_fd_sc_hd__o21ai_2
X_8491_ clknet_leaf_20_clk net172 _0242_ VGND VGND VPWR VPWR net14 sky130_fd_sc_hd__dfrtp_1
X_4723_ _1759_ _1742_ _1749_ VGND VGND VPWR VPWR _1761_ sky130_fd_sc_hd__a21o_1
XFILLER_0_56_384 VGND VGND VPWR VPWR sky130_fd_sc_hd__decap_6
XFILLER_0_17_727 VGND VGND VPWR VPWR sky130_fd_sc_hd__fill_1
X_7511_ _4159_ VGND VGND VPWR VPWR _0509_ sky130_fd_sc_hd__inv_2
XFILLER_0_71_321 VGND VGND VPWR VPWR sky130_fd_sc_hd__decap_8
X_7442_ _4151_ VGND VGND VPWR VPWR _0448_ sky130_fd_sc_hd__inv_2
X_4654_ _1653_ _1646_ _1687_ _1683_ _1691_ VGND VGND VPWR VPWR _1692_ sky130_fd_sc_hd__o221ai_4
XFILLER_0_4_621 VPWR VGND VPWR VGND sky130_ef_sc_hd__decap_12
X_4585_ _1593_ _1588_ _1611_ _1615_ VGND VGND VPWR VPWR _1627_ sky130_fd_sc_hd__o211ai_2
X_7373_ _4144_ VGND VGND VPWR VPWR _0386_ sky130_fd_sc_hd__inv_2
XFILLER_0_12_421 VPWR VGND VPWR VGND sky130_ef_sc_hd__decap_12
X_6324_ _3293_ _3317_ _3321_ _3323_ VGND VGND VPWR VPWR _3324_ sky130_fd_sc_hd__a2bb2o_1
X_6255_ _3219_ _3214_ _3254_ _3257_ _3258_ VGND VGND VPWR VPWR _3259_ sky130_fd_sc_hd__o2111ai_2
XFILLER_0_12_498 VGND VGND VPWR VPWR sky130_fd_sc_hd__fill_1
X_5206_ _2229_ _2233_ _2163_ VGND VGND VPWR VPWR _2234_ sky130_fd_sc_hd__a21oi_1
X_6186_ _3145_ _3148_ _3151_ VGND VGND VPWR VPWR _3191_ sky130_fd_sc_hd__a21oi_4
X_5137_ _2165_ VGND VGND VPWR VPWR _2166_ sky130_fd_sc_hd__inv_2
X_5068_ _2088_ _2093_ _2096_ VGND VGND VPWR VPWR _2097_ sky130_fd_sc_hd__nand3_2
X_8827_ clknet_leaf_19_clk net31 _0578_ VGND VGND VPWR VPWR sh9\[7\] sky130_fd_sc_hd__dfrtp_2
XFILLER_0_66_137 VGND VGND VPWR VPWR sky130_fd_sc_hd__decap_3
X_8758_ clknet_leaf_64_clk net404 _0509_ VGND VGND VPWR VPWR sh1\[2\] sky130_fd_sc_hd__dfrtp_1
XFILLER_0_47_340 VPWR VGND VPWR VGND sky130_ef_sc_hd__decap_12
X_7709_ net284 _4218_ VGND VGND VPWR VPWR _0063_ sky130_fd_sc_hd__xnor2_1
XFILLER_0_117_250 VGND VGND VPWR VPWR sky130_fd_sc_hd__decap_4
X_8689_ clknet_leaf_57_clk _0105_ _0440_ VGND VGND VPWR VPWR bit_sum2\[0\] sky130_fd_sc_hd__dfrtp_1
XFILLER_0_105_434 VGND VGND VPWR VPWR sky130_fd_sc_hd__fill_2
XFILLER_0_15_281 VGND VGND VPWR VPWR sky130_fd_sc_hd__decap_4
XFILLER_0_50_527 VGND VGND VPWR VPWR sky130_fd_sc_hd__decap_4
XFILLER_0_15_292 VGND VGND VPWR VPWR sky130_fd_sc_hd__decap_8
XFILLER_0_54_29 VGND VGND VPWR VPWR sky130_fd_sc_hd__decap_6
XFILLER_0_97_240 VGND VGND VPWR VPWR sky130_fd_sc_hd__decap_4
XFILLER_0_58_627 VPWR VGND VPWR VGND sky130_ef_sc_hd__decap_12
XFILLER_0_57_148 VGND VGND VPWR VPWR sky130_fd_sc_hd__decap_4
XFILLER_0_38_362 VGND VGND VPWR VPWR sky130_fd_sc_hd__fill_2
XFILLER_0_108_261 VGND VGND VPWR VPWR sky130_fd_sc_hd__decap_3
XFILLER_0_79_15 VPWR VGND VPWR VGND sky130_ef_sc_hd__decap_12
XFILLER_0_41_505 VGND VGND VPWR VPWR sky130_fd_sc_hd__fill_2
Xhold108 final_sum\[6\] VGND VGND VPWR VPWR net150 sky130_fd_sc_hd__dlygate4sd3_1
XFILLER_0_41_527 VGND VGND VPWR VPWR sky130_fd_sc_hd__decap_4
XFILLER_0_111_404 VGND VGND VPWR VPWR sky130_fd_sc_hd__decap_3
X_4370_ _1352_ _1416_ VGND VGND VPWR VPWR _0129_ sky130_fd_sc_hd__xnor2_1
Xhold119 sh8\[2\] VGND VGND VPWR VPWR net161 sky130_fd_sc_hd__dlygate4sd3_1
XTAP_424 VGND VPWR sky130_fd_sc_hd__tapvpwrvgnd_1
XTAP_413 VGND VPWR sky130_fd_sc_hd__tapvpwrvgnd_1
XTAP_402 VGND VPWR sky130_fd_sc_hd__tapvpwrvgnd_1
X_6040_ _2951_ _2954_ _2956_ VGND VGND VPWR VPWR _3048_ sky130_fd_sc_hd__o21ai_1
XTAP_446 VGND VPWR sky130_fd_sc_hd__tapvpwrvgnd_1
XTAP_435 VGND VPWR sky130_fd_sc_hd__tapvpwrvgnd_1
XTAP_457 VGND VPWR sky130_fd_sc_hd__tapvpwrvgnd_1
XFILLER_0_28_41 VPWR VGND VPWR VGND sky130_ef_sc_hd__decap_12
XTAP_468 VGND VPWR sky130_fd_sc_hd__tapvpwrvgnd_1
XTAP_479 VGND VPWR sky130_fd_sc_hd__tapvpwrvgnd_1
XFILLER_0_28_85 VGND VGND VPWR VPWR sky130_fd_sc_hd__decap_8
X_7991_ _0797_ _0726_ VGND VGND VPWR VPWR _0840_ sky130_fd_sc_hd__nor2_1
X_6942_ _3700_ _3702_ _3928_ VGND VGND VPWR VPWR _3929_ sky130_fd_sc_hd__and3_1
XFILLER_0_76_435 VGND VGND VPWR VPWR sky130_fd_sc_hd__decap_8
X_6873_ _3750_ _3768_ VGND VGND VPWR VPWR _3861_ sky130_fd_sc_hd__nand2_1
XFILLER_0_49_638 VGND VGND VPWR VPWR sky130_fd_sc_hd__fill_1
X_5824_ _2835_ _2837_ _2791_ VGND VGND VPWR VPWR _2838_ sky130_fd_sc_hd__o21bai_1
X_8612_ clknet_leaf_57_clk net84 _0363_ VGND VGND VPWR VPWR s2\[4\] sky130_fd_sc_hd__dfrtp_1
XFILLER_0_48_137 VGND VGND VPWR VPWR sky130_fd_sc_hd__decap_3
XFILLER_0_29_373 VGND VGND VPWR VPWR sky130_fd_sc_hd__decap_6
XFILLER_0_91_449 VGND VGND VPWR VPWR sky130_fd_sc_hd__decap_4
XFILLER_0_60_83 VGND VGND VPWR VPWR sky130_fd_sc_hd__fill_1
X_8543_ clknet_leaf_34_clk net406 _0294_ VGND VGND VPWR VPWR carry2\[5\] sky130_fd_sc_hd__dfrtp_1
X_5755_ _2769_ _2770_ VGND VGND VPWR VPWR _0176_ sky130_fd_sc_hd__xor2_1
XFILLER_0_115_721 VGND VGND VPWR VPWR sky130_fd_sc_hd__decap_6
X_4706_ _1636_ _1641_ _1638_ VGND VGND VPWR VPWR _1744_ sky130_fd_sc_hd__o21a_1
XFILLER_0_97_3 VPWR VGND VPWR VGND sky130_ef_sc_hd__decap_12
X_5686_ _2615_ _2641_ _2639_ VGND VGND VPWR VPWR _2703_ sky130_fd_sc_hd__o21a_1
X_8474_ clknet_leaf_43_clk net97 _0225_ VGND VGND VPWR VPWR s0\[6\] sky130_fd_sc_hd__dfrtp_1
XFILLER_0_44_365 VGND VGND VPWR VPWR sky130_fd_sc_hd__decap_4
XFILLER_0_114_253 VGND VGND VPWR VPWR sky130_fd_sc_hd__fill_1
X_4637_ _1638_ net31 _1674_ VGND VGND VPWR VPWR _1675_ sky130_fd_sc_hd__o21ai_2
X_7425_ _4150_ VGND VGND VPWR VPWR _0432_ sky130_fd_sc_hd__inv_2
XFILLER_0_4_484 VPWR VGND VPWR VGND sky130_ef_sc_hd__decap_12
XFILLER_0_114_297 VGND VGND VPWR VPWR sky130_fd_sc_hd__fill_1
X_4568_ _1575_ _1573_ _1609_ _1610_ _1576_ VGND VGND VPWR VPWR _1611_ sky130_fd_sc_hd__o221ai_4
XFILLER_0_102_437 VPWR VGND VPWR VGND sky130_ef_sc_hd__decap_12
XFILLER_0_69_70 VGND VGND VPWR VPWR sky130_fd_sc_hd__decap_3
X_7356_ _4143_ VGND VGND VPWR VPWR _0370_ sky130_fd_sc_hd__inv_2
X_4499_ _1541_ _1542_ VGND VGND VPWR VPWR _1543_ sky130_fd_sc_hd__or2_1
X_6307_ sh7\[4\] VGND VGND VPWR VPWR _3307_ sky130_fd_sc_hd__buf_2
X_7287_ _4121_ VGND VGND VPWR VPWR _4136_ sky130_fd_sc_hd__buf_4
X_6238_ _3120_ _3185_ _3242_ _3238_ VGND VGND VPWR VPWR _3243_ sky130_fd_sc_hd__o211ai_2
X_6169_ _3073_ _3117_ _3115_ VGND VGND VPWR VPWR _3175_ sky130_fd_sc_hd__o21ai_2
XTAP_980 VGND VPWR sky130_fd_sc_hd__tapvpwrvgnd_1
XFILLER_0_99_516 VGND VGND VPWR VPWR sky130_fd_sc_hd__fill_2
XTAP_991 VGND VPWR sky130_fd_sc_hd__tapvpwrvgnd_1
XFILLER_0_94_210 VGND VGND VPWR VPWR sky130_fd_sc_hd__decap_4
XFILLER_0_79_273 VGND VGND VPWR VPWR sky130_fd_sc_hd__decap_6
XFILLER_0_67_446 VGND VGND VPWR VPWR sky130_fd_sc_hd__fill_2
XFILLER_0_39_137 VPWR VGND VPWR VGND sky130_ef_sc_hd__decap_12
XFILLER_0_94_287 VPWR VGND VPWR VGND sky130_ef_sc_hd__decap_12
Xclkbuf_leaf_20_clk clknet_3_7__leaf_clk VGND VGND VPWR VPWR clknet_leaf_20_clk sky130_fd_sc_hd__clkbuf_16
XFILLER_0_23_505 VGND VGND VPWR VPWR sky130_fd_sc_hd__decap_6
XFILLER_0_98_571 VGND VGND VPWR VPWR sky130_fd_sc_hd__fill_2
XFILLER_0_81_27 VPWR VGND VPWR VGND sky130_ef_sc_hd__decap_12
XFILLER_0_58_424 VPWR VGND VPWR VGND sky130_ef_sc_hd__decap_12
XFILLER_0_105_34 VGND VGND VPWR VPWR sky130_fd_sc_hd__fill_2
XFILLER_0_73_427 VGND VGND VPWR VPWR sky130_fd_sc_hd__decap_8
XFILLER_0_73_405 VGND VGND VPWR VPWR sky130_fd_sc_hd__fill_2
XFILLER_0_39_671 VGND VGND VPWR VPWR sky130_fd_sc_hd__fill_1
XFILLER_0_14_98 VGND VGND VPWR VPWR sky130_fd_sc_hd__fill_2
XFILLER_0_26_321 VPWR VGND VPWR VGND sky130_ef_sc_hd__decap_12
Xclkbuf_leaf_11_clk clknet_3_3__leaf_clk VGND VGND VPWR VPWR clknet_leaf_11_clk sky130_fd_sc_hd__clkbuf_16
X_5540_ _2490_ net36 VGND VGND VPWR VPWR _2559_ sky130_fd_sc_hd__and2_1
XFILLER_0_26_365 VGND VGND VPWR VPWR sky130_fd_sc_hd__decap_8
XFILLER_0_121_55 VGND VGND VPWR VPWR sky130_fd_sc_hd__fill_1
X_5471_ _2490_ VGND VGND VPWR VPWR _2491_ sky130_fd_sc_hd__clkbuf_4
XFILLER_0_30_64 VGND VGND VPWR VPWR sky130_fd_sc_hd__decap_4
XFILLER_0_112_713 VPWR VGND VPWR VGND sky130_ef_sc_hd__decap_12
XFILLER_0_111_201 VGND VGND VPWR VPWR sky130_fd_sc_hd__fill_2
X_4422_ _1466_ _1467_ _1452_ VGND VGND VPWR VPWR _1468_ sky130_fd_sc_hd__nand3_1
X_7210_ _4125_ VGND VGND VPWR VPWR _4129_ sky130_fd_sc_hd__clkbuf_8
XFILLER_0_30_97 VPWR VGND VPWR VGND sky130_ef_sc_hd__decap_12
XFILLER_0_41_335 VGND VGND VPWR VPWR sky130_fd_sc_hd__fill_1
X_8190_ _0959_ _0954_ _1030_ _1035_ _0960_ VGND VGND VPWR VPWR _1036_ sky130_fd_sc_hd__o2111ai_4
X_4353_ _1311_ _1397_ _1377_ _1399_ VGND VGND VPWR VPWR _1400_ sky130_fd_sc_hd__o2bb2ai_4
XFILLER_0_10_733 VGND VGND VPWR VPWR sky130_fd_sc_hd__fill_2
XFILLER_0_39_51 VGND VGND VPWR VPWR sky130_fd_sc_hd__decap_4
X_7141_ net254 _4115_ VGND VGND VPWR VPWR _0055_ sky130_fd_sc_hd__xnor2_1
X_4284_ _1329_ _1330_ _1331_ VGND VGND VPWR VPWR _1332_ sky130_fd_sc_hd__a21bo_1
X_7072_ _4006_ _3994_ _3999_ VGND VGND VPWR VPWR _4057_ sky130_fd_sc_hd__a21bo_1
X_6023_ sh8\[6\] sh9\[6\] VGND VGND VPWR VPWR _3031_ sky130_fd_sc_hd__and2_2
XTAP_254 VGND VPWR sky130_fd_sc_hd__tapvpwrvgnd_1
XTAP_265 VGND VPWR sky130_fd_sc_hd__tapvpwrvgnd_1
XTAP_276 VGND VPWR sky130_fd_sc_hd__tapvpwrvgnd_1
XTAP_287 VGND VPWR sky130_fd_sc_hd__tapvpwrvgnd_1
XTAP_298 VGND VPWR sky130_fd_sc_hd__tapvpwrvgnd_1
X_7974_ _0747_ _0748_ _0822_ VGND VGND VPWR VPWR _0823_ sky130_fd_sc_hd__a21oi_1
XTAP_1409 VGND VPWR sky130_fd_sc_hd__tapvpwrvgnd_1
XFILLER_0_12_3 VPWR VGND VPWR VGND sky130_ef_sc_hd__decap_12
X_6925_ _3717_ _3712_ _3740_ VGND VGND VPWR VPWR _3912_ sky130_fd_sc_hd__o21ai_2
XFILLER_0_76_221 VPWR VGND VPWR VGND sky130_ef_sc_hd__decap_12
XFILLER_0_49_446 VGND VGND VPWR VPWR sky130_fd_sc_hd__fill_2
XFILLER_0_92_725 VGND VGND VPWR VPWR sky130_fd_sc_hd__decap_8
XFILLER_0_64_416 VGND VGND VPWR VPWR sky130_fd_sc_hd__decap_4
XFILLER_0_9_543 VGND VGND VPWR VPWR sky130_fd_sc_hd__fill_1
X_6856_ _3839_ _3842_ _3843_ VGND VGND VPWR VPWR _3844_ sky130_fd_sc_hd__a21oi_2
Xfanout36 net445 VGND VGND VPWR VPWR net36 sky130_fd_sc_hd__clkbuf_4
XFILLER_0_76_287 VPWR VGND VPWR VGND sky130_ef_sc_hd__decap_12
X_6787_ _3754_ _3743_ _3749_ VGND VGND VPWR VPWR _3776_ sky130_fd_sc_hd__nand3_1
X_5807_ _2821_ VGND VGND VPWR VPWR _0177_ sky130_fd_sc_hd__clkbuf_1
X_5738_ _2749_ _2750_ VGND VGND VPWR VPWR _2754_ sky130_fd_sc_hd__nor2_1
X_8526_ clknet_leaf_37_clk net103 _0277_ VGND VGND VPWR VPWR sum3\[0\] sky130_fd_sc_hd__dfrtp_1
XFILLER_0_44_173 VPWR VGND VPWR VGND sky130_ef_sc_hd__decap_12
XFILLER_0_45_685 VPWR VGND VPWR VGND sky130_ef_sc_hd__decap_12
X_8457_ clknet_leaf_31_clk net431 _0208_ VGND VGND VPWR VPWR carry3\[12\] sky130_fd_sc_hd__dfrtp_1
X_5669_ _2484_ _2477_ _2506_ VGND VGND VPWR VPWR _2686_ sky130_fd_sc_hd__o21ba_1
X_7408_ _4148_ VGND VGND VPWR VPWR _0417_ sky130_fd_sc_hd__inv_2
X_8388_ sum5\[15\] s7\[15\] VGND VGND VPWR VPWR _1220_ sky130_fd_sc_hd__xor2_1
XFILLER_0_4_292 VPWR VGND VPWR VGND sky130_ef_sc_hd__decap_12
XFILLER_0_4_281 VGND VGND VPWR VPWR sky130_fd_sc_hd__decap_4
XFILLER_0_20_519 VGND VGND VPWR VPWR sky130_fd_sc_hd__fill_1
X_7339_ _4141_ VGND VGND VPWR VPWR _0355_ sky130_fd_sc_hd__inv_2
XFILLER_0_99_335 VGND VGND VPWR VPWR sky130_fd_sc_hd__fill_1
XFILLER_0_99_379 VGND VGND VPWR VPWR sky130_fd_sc_hd__decap_4
XFILLER_0_87_508 VGND VGND VPWR VPWR sky130_fd_sc_hd__fill_2
XFILLER_0_95_585 VGND VGND VPWR VPWR sky130_fd_sc_hd__decap_8
XFILLER_0_83_703 VPWR VGND VPWR VGND sky130_ef_sc_hd__decap_12
XFILLER_0_55_449 VGND VGND VPWR VPWR sky130_fd_sc_hd__fill_1
XFILLER_0_82_279 VPWR VGND VPWR VGND sky130_ef_sc_hd__decap_12
XFILLER_0_82_268 VGND VGND VPWR VPWR sky130_fd_sc_hd__decap_6
XFILLER_0_51_611 VGND VGND VPWR VPWR sky130_fd_sc_hd__decap_4
XFILLER_0_50_110 VGND VGND VPWR VPWR sky130_fd_sc_hd__fill_2
XFILLER_0_23_379 VGND VGND VPWR VPWR sky130_fd_sc_hd__decap_3
XFILLER_0_31_390 VGND VGND VPWR VPWR sky130_fd_sc_hd__fill_2
XFILLER_0_76_27 VGND VGND VPWR VPWR sky130_fd_sc_hd__fill_1
XFILLER_0_92_26 VGND VGND VPWR VPWR sky130_fd_sc_hd__fill_2
Xclkbuf_leaf_0_clk clknet_3_1__leaf_clk VGND VGND VPWR VPWR clknet_leaf_0_clk sky130_fd_sc_hd__clkbuf_16
XFILLER_0_25_53 VGND VGND VPWR VPWR sky130_fd_sc_hd__decap_3
X_4971_ _2000_ _2001_ _2003_ VGND VGND VPWR VPWR _2004_ sky130_fd_sc_hd__a21oi_2
X_6710_ _3698_ _3699_ net29 VGND VGND VPWR VPWR _3700_ sky130_fd_sc_hd__o21bai_4
X_7690_ carry1\[3\] sum1\[4\] net305 VGND VGND VPWR VPWR _4209_ sky130_fd_sc_hd__a21o_1
X_6641_ _3634_ _3635_ _3576_ VGND VGND VPWR VPWR _3636_ sky130_fd_sc_hd__a21o_1
XFILLER_0_27_641 VGND VGND VPWR VPWR sky130_fd_sc_hd__decap_8
XFILLER_0_27_663 VGND VGND VPWR VPWR sky130_fd_sc_hd__decap_8
X_6572_ _3559_ _3564_ _3567_ VGND VGND VPWR VPWR _3568_ sky130_fd_sc_hd__nand3_1
XFILLER_0_73_279 VGND VGND VPWR VPWR sky130_fd_sc_hd__fill_1
X_8311_ sum5\[7\] s7\[7\] VGND VGND VPWR VPWR _1150_ sky130_fd_sc_hd__and2_1
XFILLER_0_26_173 VGND VGND VPWR VPWR sky130_fd_sc_hd__fill_2
XFILLER_0_27_685 VPWR VGND VPWR VGND sky130_ef_sc_hd__decap_12
XFILLER_0_42_622 VGND VGND VPWR VPWR sky130_fd_sc_hd__fill_2
X_5523_ _2540_ _2541_ _2532_ VGND VGND VPWR VPWR _2542_ sky130_fd_sc_hd__or3b_1
X_8242_ _1050_ _1084_ _1086_ VGND VGND VPWR VPWR _1087_ sky130_fd_sc_hd__nand3b_4
X_5454_ _2470_ _2472_ _2473_ VGND VGND VPWR VPWR _2474_ sky130_fd_sc_hd__and3_1
XFILLER_0_41_143 VPWR VGND VPWR VGND sky130_ef_sc_hd__decap_12
X_4405_ _1435_ _1439_ _1450_ VGND VGND VPWR VPWR _1451_ sky130_fd_sc_hd__a21oi_2
X_8173_ _1005_ _1008_ _1009_ VGND VGND VPWR VPWR _1019_ sky130_fd_sc_hd__nand3_2
X_5385_ _2407_ _2409_ _2403_ VGND VGND VPWR VPWR _2410_ sky130_fd_sc_hd__o21ai_1
X_4336_ net32 sh9\[5\] sh12\[5\] VGND VGND VPWR VPWR _1383_ sky130_fd_sc_hd__o21ai_4
XFILLER_0_1_273 VGND VGND VPWR VPWR sky130_fd_sc_hd__fill_2
X_7124_ _4098_ _4104_ _4106_ VGND VGND VPWR VPWR _0152_ sky130_fd_sc_hd__a21oi_1
X_4267_ _1312_ _1275_ _1313_ _1314_ VGND VGND VPWR VPWR _1315_ sky130_fd_sc_hd__a211oi_4
X_7055_ _4021_ _4023_ _4039_ VGND VGND VPWR VPWR _4040_ sky130_fd_sc_hd__o21ai_2
X_6006_ _2886_ _2936_ _3009_ VGND VGND VPWR VPWR _3014_ sky130_fd_sc_hd__a21o_1
XFILLER_0_66_82 VGND VGND VPWR VPWR sky130_fd_sc_hd__fill_2
XFILLER_0_96_316 VGND VGND VPWR VPWR sky130_fd_sc_hd__fill_1
XFILLER_0_89_390 VGND VGND VPWR VPWR sky130_fd_sc_hd__fill_2
XTAP_1239 VGND VPWR sky130_fd_sc_hd__tapvpwrvgnd_1
XTAP_1228 VGND VPWR sky130_fd_sc_hd__tapvpwrvgnd_1
XTAP_1206 VGND VPWR sky130_fd_sc_hd__tapvpwrvgnd_1
XTAP_1217 VGND VPWR sky130_fd_sc_hd__tapvpwrvgnd_1
X_7957_ _0803_ _0804_ _0805_ VGND VGND VPWR VPWR _0806_ sky130_fd_sc_hd__o21a_1
XFILLER_0_49_210 VGND VGND VPWR VPWR sky130_fd_sc_hd__decap_4
X_7888_ _0736_ _0737_ VGND VGND VPWR VPWR _0738_ sky130_fd_sc_hd__nand2_1
X_6908_ _3894_ _3889_ _3892_ VGND VGND VPWR VPWR _3896_ sky130_fd_sc_hd__and3_1
XFILLER_0_92_544 VPWR VGND VPWR VGND sky130_ef_sc_hd__decap_12
XFILLER_0_92_522 VGND VGND VPWR VPWR sky130_fd_sc_hd__decap_8
XFILLER_0_64_235 VPWR VGND VPWR VGND sky130_ef_sc_hd__decap_12
X_6839_ _3818_ _3819_ _3826_ _3827_ VGND VGND VPWR VPWR _3828_ sky130_fd_sc_hd__a2bb2oi_2
XFILLER_0_119_175 VPWR VGND VPWR VGND sky130_ef_sc_hd__decap_12
XFILLER_0_18_696 VGND VGND VPWR VPWR sky130_fd_sc_hd__decap_4
XFILLER_0_122_318 VGND VGND VPWR VPWR sky130_fd_sc_hd__decap_8
X_8509_ clknet_leaf_24_clk _0169_ _0260_ VGND VGND VPWR VPWR final_sum\[15\] sky130_fd_sc_hd__dfrtp_1
XFILLER_0_60_441 VGND VGND VPWR VPWR sky130_fd_sc_hd__decap_3
XFILLER_0_32_110 VGND VGND VPWR VPWR sky130_fd_sc_hd__decap_8
XFILLER_0_60_496 VGND VGND VPWR VPWR sky130_fd_sc_hd__decap_8
XFILLER_0_20_316 VGND VGND VPWR VPWR sky130_fd_sc_hd__fill_1
XFILLER_0_32_176 VGND VGND VPWR VPWR sky130_fd_sc_hd__fill_1
Xhold280 sh0\[5\] VGND VGND VPWR VPWR net322 sky130_fd_sc_hd__dlygate4sd3_1
XFILLER_0_13_390 VGND VGND VPWR VPWR sky130_fd_sc_hd__fill_2
Xhold291 s5\[9\] VGND VGND VPWR VPWR net333 sky130_fd_sc_hd__dlygate4sd3_1
XFILLER_0_1_3 VPWR VGND VPWR VGND sky130_ef_sc_hd__decap_12
XFILLER_0_99_176 VPWR VGND VPWR VGND sky130_ef_sc_hd__decap_12
XFILLER_0_99_165 VGND VGND VPWR VPWR sky130_fd_sc_hd__decap_3
XFILLER_0_87_349 VGND VGND VPWR VPWR sky130_fd_sc_hd__decap_8
XFILLER_0_62_29 VGND VGND VPWR VPWR sky130_fd_sc_hd__fill_2
XTAP_1751 VGND VPWR sky130_fd_sc_hd__tapvpwrvgnd_1
XTAP_1740 VGND VPWR sky130_fd_sc_hd__tapvpwrvgnd_1
XTAP_1784 VGND VPWR sky130_fd_sc_hd__tapvpwrvgnd_1
XTAP_1773 VGND VPWR sky130_fd_sc_hd__tapvpwrvgnd_1
XTAP_1762 VGND VPWR sky130_fd_sc_hd__tapvpwrvgnd_1
XFILLER_0_95_393 VGND VGND VPWR VPWR sky130_fd_sc_hd__decap_3
XTAP_1795 VGND VPWR sky130_fd_sc_hd__tapvpwrvgnd_1
XFILLER_0_83_599 VPWR VGND VPWR VGND sky130_ef_sc_hd__decap_12
XFILLER_0_24_622 VGND VGND VPWR VPWR sky130_fd_sc_hd__decap_8
XFILLER_0_70_238 VPWR VGND VPWR VGND sky130_ef_sc_hd__decap_12
XFILLER_0_11_55 VGND VGND VPWR VPWR sky130_fd_sc_hd__fill_1
XFILLER_0_87_15 VPWR VGND VPWR VGND sky130_ef_sc_hd__decap_12
X_5170_ _2197_ _2194_ _2192_ VGND VGND VPWR VPWR _2198_ sky130_fd_sc_hd__a21oi_1
XFILLER_0_36_41 VGND VGND VPWR VPWR sky130_fd_sc_hd__fill_2
Xinput4 x[2] VGND VGND VPWR VPWR net4 sky130_fd_sc_hd__clkbuf_1
X_8860_ clknet_leaf_51_clk net186 _0611_ VGND VGND VPWR VPWR sh14\[0\] sky130_fd_sc_hd__dfrtp_4
XFILLER_0_36_85 VGND VGND VPWR VPWR sky130_fd_sc_hd__decap_4
X_8791_ clknet_leaf_5_clk net393 _0542_ VGND VGND VPWR VPWR sh5\[3\] sky130_fd_sc_hd__dfrtp_4
X_7811_ carry2\[4\] sum2\[5\] VGND VGND VPWR VPWR _0691_ sky130_fd_sc_hd__xnor2_1
X_4954_ _1985_ _1986_ _1929_ VGND VGND VPWR VPWR _1988_ sky130_fd_sc_hd__a21o_1
X_7742_ _0646_ _0647_ VGND VGND VPWR VPWR _0098_ sky130_fd_sc_hd__nand2_1
XFILLER_0_19_405 VGND VGND VPWR VPWR sky130_fd_sc_hd__decap_4
XFILLER_0_47_714 VPWR VGND VPWR VGND sky130_ef_sc_hd__decap_12
XFILLER_0_59_596 VGND VGND VPWR VPWR sky130_fd_sc_hd__fill_2
XFILLER_0_52_73 VGND VGND VPWR VPWR sky130_fd_sc_hd__decap_8
XFILLER_0_19_416 VPWR VGND VPWR VGND sky130_ef_sc_hd__decap_12
XFILLER_0_19_449 VGND VGND VPWR VPWR sky130_fd_sc_hd__decap_4
X_4885_ _1652_ _1637_ _1914_ VGND VGND VPWR VPWR _1920_ sky130_fd_sc_hd__a21o_1
X_7673_ _4196_ _4197_ VGND VGND VPWR VPWR _0081_ sky130_fd_sc_hd__nand2_1
XFILLER_0_74_577 VGND VGND VPWR VPWR sky130_fd_sc_hd__decap_3
X_6624_ _3611_ _3613_ _3617_ _3618_ VGND VGND VPWR VPWR _3619_ sky130_fd_sc_hd__o211ai_1
X_6555_ _3513_ _3548_ _3549_ _3550_ VGND VGND VPWR VPWR _3551_ sky130_fd_sc_hd__a22oi_2
XFILLER_0_6_387 VPWR VGND VPWR VGND sky130_ef_sc_hd__decap_12
XFILLER_0_6_365 VPWR VGND VPWR VGND sky130_ef_sc_hd__decap_12
XFILLER_0_116_189 VGND VGND VPWR VPWR sky130_fd_sc_hd__decap_6
X_5506_ _2523_ _2524_ _2521_ VGND VGND VPWR VPWR _2525_ sky130_fd_sc_hd__nand3_2
XFILLER_0_30_603 VGND VGND VPWR VPWR sky130_fd_sc_hd__fill_1
X_8225_ _1065_ _1069_ VGND VGND VPWR VPWR _1070_ sky130_fd_sc_hd__nand2_1
X_6486_ _3483_ VGND VGND VPWR VPWR _0120_ sky130_fd_sc_hd__clkbuf_1
X_5437_ _2455_ _2459_ VGND VGND VPWR VPWR _2460_ sky130_fd_sc_hd__xnor2_1
XFILLER_0_77_81 VPWR VGND VPWR VGND sky130_ef_sc_hd__decap_12
X_8156_ _0730_ _0750_ _0746_ VGND VGND VPWR VPWR _1002_ sky130_fd_sc_hd__o21ai_4
X_5368_ sh15\[2\] _2040_ _2104_ VGND VGND VPWR VPWR _2393_ sky130_fd_sc_hd__and3_1
X_4319_ _1364_ _1365_ VGND VGND VPWR VPWR _1366_ sky130_fd_sc_hd__nand2_1
X_8087_ _0869_ _0870_ _0874_ VGND VGND VPWR VPWR _0934_ sky130_fd_sc_hd__o21a_1
X_7107_ _4065_ _4066_ _4089_ _4090_ VGND VGND VPWR VPWR _4091_ sky130_fd_sc_hd__o2bb2ai_1
X_5299_ _2052_ net38 VGND VGND VPWR VPWR _2325_ sky130_fd_sc_hd__or2_1
X_7038_ _4022_ _4020_ _3973_ VGND VGND VPWR VPWR _4023_ sky130_fd_sc_hd__a21oi_2
XTAP_1003 VGND VPWR sky130_fd_sc_hd__tapvpwrvgnd_1
XFILLER_0_65_500 VGND VGND VPWR VPWR sky130_fd_sc_hd__decap_4
XTAP_1036 VGND VPWR sky130_fd_sc_hd__tapvpwrvgnd_1
XTAP_1047 VGND VPWR sky130_fd_sc_hd__tapvpwrvgnd_1
XTAP_1025 VGND VPWR sky130_fd_sc_hd__tapvpwrvgnd_1
XTAP_1014 VGND VPWR sky130_fd_sc_hd__tapvpwrvgnd_1
XFILLER_0_77_382 VGND VGND VPWR VPWR sky130_fd_sc_hd__decap_8
XTAP_1069 VGND VPWR sky130_fd_sc_hd__tapvpwrvgnd_1
XTAP_1058 VGND VPWR sky130_fd_sc_hd__tapvpwrvgnd_1
XFILLER_0_38_725 VGND VGND VPWR VPWR sky130_fd_sc_hd__decap_8
XFILLER_0_108_624 VPWR VGND VPWR VGND sky130_ef_sc_hd__decap_12
XFILLER_0_37_257 VGND VGND VPWR VPWR sky130_fd_sc_hd__decap_3
XFILLER_0_108_657 VGND VGND VPWR VPWR sky130_fd_sc_hd__decap_4
XFILLER_0_92_385 VGND VGND VPWR VPWR sky130_fd_sc_hd__decap_3
XFILLER_0_9_181 VPWR VGND VPWR VGND sky130_ef_sc_hd__decap_12
XFILLER_0_25_419 VPWR VGND VPWR VGND sky130_ef_sc_hd__decap_12
XFILLER_0_52_227 VPWR VGND VPWR VGND sky130_ef_sc_hd__decap_12
XFILLER_0_33_474 VGND VGND VPWR VPWR sky130_fd_sc_hd__decap_3
XFILLER_0_21_647 VGND VGND VPWR VPWR sky130_fd_sc_hd__decap_6
XFILLER_0_20_146 VGND VGND VPWR VPWR sky130_fd_sc_hd__decap_8
XTAP_809 VGND VPWR sky130_fd_sc_hd__tapvpwrvgnd_1
XFILLER_0_68_382 VPWR VGND VPWR VGND sky130_ef_sc_hd__decap_12
XFILLER_0_56_533 VGND VGND VPWR VPWR sky130_fd_sc_hd__fill_1
XTAP_1592 VGND VPWR sky130_fd_sc_hd__tapvpwrvgnd_1
XTAP_1581 VGND VPWR sky130_fd_sc_hd__tapvpwrvgnd_1
XTAP_1570 VGND VPWR sky130_fd_sc_hd__tapvpwrvgnd_1
X_4670_ _1706_ _1707_ _1700_ VGND VGND VPWR VPWR _1708_ sky130_fd_sc_hd__nand3_1
XFILLER_0_118_3 VPWR VGND VPWR VGND sky130_ef_sc_hd__decap_12
XFILLER_0_71_558 VGND VGND VPWR VPWR sky130_fd_sc_hd__fill_2
XFILLER_0_113_137 VGND VGND VPWR VPWR sky130_fd_sc_hd__decap_4
X_6340_ _3307_ net33 VGND VGND VPWR VPWR _3339_ sky130_fd_sc_hd__nand2_2
XFILLER_0_11_113 VGND VGND VPWR VPWR sky130_fd_sc_hd__fill_2
XFILLER_0_24_485 VPWR VGND VPWR VGND sky130_ef_sc_hd__decap_12
XFILLER_0_122_682 VPWR VGND VPWR VGND sky130_ef_sc_hd__decap_12
X_6271_ _3264_ _3271_ _3273_ VGND VGND VPWR VPWR _3274_ sky130_fd_sc_hd__and3_1
XFILLER_0_11_146 VGND VGND VPWR VPWR sky130_fd_sc_hd__fill_1
XFILLER_0_51_293 VGND VGND VPWR VPWR sky130_fd_sc_hd__decap_3
XFILLER_0_121_181 VPWR VGND VPWR VGND sky130_ef_sc_hd__decap_12
X_5222_ _2216_ _2217_ _2248_ _2212_ VGND VGND VPWR VPWR _2249_ sky130_fd_sc_hd__o22a_1
X_8010_ _0807_ _0810_ _0856_ _0857_ VGND VGND VPWR VPWR _0859_ sky130_fd_sc_hd__and4_1
X_5153_ _2179_ _2176_ _2177_ VGND VGND VPWR VPWR _2182_ sky130_fd_sc_hd__nand3_2
X_5084_ _2087_ _2086_ _2098_ VGND VGND VPWR VPWR _2113_ sky130_fd_sc_hd__o21ai_2
X_8843_ clknet_leaf_16_clk net255 _0594_ VGND VGND VPWR VPWR sh11\[7\] sky130_fd_sc_hd__dfrtp_1
XFILLER_0_2_53 VPWR VGND VPWR VGND sky130_ef_sc_hd__decap_12
XFILLER_0_78_179 VGND VGND VPWR VPWR sky130_fd_sc_hd__decap_3
XFILLER_0_2_97 VPWR VGND VPWR VGND sky130_ef_sc_hd__decap_12
X_5986_ _2993_ _2902_ _2994_ VGND VGND VPWR VPWR _2995_ sky130_fd_sc_hd__o21ai_1
XPHY_119 VGND VGND VPWR VPWR sky130_fd_sc_hd__decap_3
XPHY_108 VGND VGND VPWR VPWR sky130_fd_sc_hd__decap_3
X_8774_ clknet_leaf_63_clk net308 _0525_ VGND VGND VPWR VPWR sh3\[2\] sky130_fd_sc_hd__dfrtp_4
XFILLER_0_47_500 VGND VGND VPWR VPWR sky130_fd_sc_hd__decap_4
X_4937_ _1965_ _1966_ _1969_ _1970_ VGND VGND VPWR VPWR _1971_ sky130_fd_sc_hd__o211ai_4
XFILLER_0_93_149 VGND VGND VPWR VPWR sky130_fd_sc_hd__decap_8
XFILLER_0_59_393 VGND VGND VPWR VPWR sky130_fd_sc_hd__decap_6
X_7725_ net250 _0634_ VGND VGND VPWR VPWR _0061_ sky130_fd_sc_hd__xnor2_1
X_4868_ _1822_ _1903_ VGND VGND VPWR VPWR _1904_ sky130_fd_sc_hd__nand2_1
XFILLER_0_74_363 VGND VGND VPWR VPWR sky130_fd_sc_hd__fill_1
X_7656_ _4182_ _4183_ net323 VGND VGND VPWR VPWR _4184_ sky130_fd_sc_hd__o21ai_1
XFILLER_0_7_641 VPWR VGND VPWR VGND sky130_ef_sc_hd__decap_12
X_6607_ sh4\[4\] _3326_ sh6\[4\] VGND VGND VPWR VPWR _3602_ sky130_fd_sc_hd__o21ai_4
XFILLER_0_7_685 VPWR VGND VPWR VGND sky130_ef_sc_hd__decap_12
X_4799_ _1652_ _1643_ _1668_ VGND VGND VPWR VPWR _1835_ sky130_fd_sc_hd__o21ai_4
XFILLER_0_105_649 VGND VGND VPWR VPWR sky130_fd_sc_hd__fill_1
X_7587_ _4158_ VGND VGND VPWR VPWR _4166_ sky130_fd_sc_hd__buf_8
XFILLER_0_6_195 VGND VGND VPWR VPWR sky130_fd_sc_hd__fill_1
X_6538_ _3530_ _3534_ _3527_ _3529_ VGND VGND VPWR VPWR _3535_ sky130_fd_sc_hd__o211a_1
XFILLER_0_42_260 VPWR VGND VPWR VGND sky130_ef_sc_hd__decap_12
XFILLER_0_113_671 VGND VGND VPWR VPWR sky130_fd_sc_hd__fill_1
X_6469_ _3383_ _3385_ _3386_ _3382_ _3394_ VGND VGND VPWR VPWR _3467_ sky130_fd_sc_hd__a32oi_4
X_8208_ sh13\[3\] _0892_ sh14\[3\] VGND VGND VPWR VPWR _1053_ sky130_fd_sc_hd__o21ai_2
XFILLER_0_30_477 VGND VGND VPWR VPWR sky130_fd_sc_hd__decap_8
X_8139_ _0830_ _0893_ _0889_ _0891_ VGND VGND VPWR VPWR _0986_ sky130_fd_sc_hd__a31o_1
XFILLER_0_85_628 VGND VGND VPWR VPWR sky130_fd_sc_hd__decap_3
XFILLER_0_78_691 VGND VGND VPWR VPWR sky130_fd_sc_hd__decap_8
XFILLER_0_108_421 VGND VGND VPWR VPWR sky130_fd_sc_hd__decap_4
XFILLER_0_25_205 VPWR VGND VPWR VGND sky130_ef_sc_hd__decap_12
XFILLER_0_80_333 VGND VGND VPWR VPWR sky130_fd_sc_hd__fill_1
XFILLER_0_53_547 VGND VGND VPWR VPWR sky130_fd_sc_hd__decap_8
XFILLER_0_80_377 VGND VGND VPWR VPWR sky130_fd_sc_hd__decap_8
XFILLER_0_41_709 VPWR VGND VPWR VGND sky130_ef_sc_hd__decap_12
XFILLER_0_111_608 VGND VGND VPWR VPWR sky130_fd_sc_hd__decap_8
XFILLER_0_0_305 VGND VGND VPWR VPWR sky130_fd_sc_hd__decap_3
XFILLER_0_103_192 VPWR VGND VPWR VGND sky130_ef_sc_hd__decap_12
XTAP_606 VGND VPWR sky130_fd_sc_hd__tapvpwrvgnd_1
XTAP_617 VGND VPWR sky130_fd_sc_hd__tapvpwrvgnd_1
XTAP_628 VGND VPWR sky130_fd_sc_hd__tapvpwrvgnd_1
XTAP_639 VGND VPWR sky130_fd_sc_hd__tapvpwrvgnd_1
XFILLER_0_84_27 VGND VGND VPWR VPWR sky130_fd_sc_hd__fill_1
XFILLER_0_108_56 VGND VGND VPWR VPWR sky130_fd_sc_hd__decap_6
XFILLER_0_88_477 VGND VGND VPWR VPWR sky130_fd_sc_hd__decap_6
X_5840_ _2839_ _2841_ _2852_ VGND VGND VPWR VPWR _2853_ sky130_fd_sc_hd__and3_1
XFILLER_0_8_405 VPWR VGND VPWR VGND sky130_ef_sc_hd__decap_12
X_5771_ _2778_ _2779_ _2781_ VGND VGND VPWR VPWR _2786_ sky130_fd_sc_hd__a21o_2
X_8490_ clknet_leaf_20_clk net165 _0241_ VGND VGND VPWR VPWR net13 sky130_fd_sc_hd__dfrtp_1
X_4722_ _1742_ _1749_ _1759_ VGND VGND VPWR VPWR _1760_ sky130_fd_sc_hd__nand3_1
X_7510_ _4158_ VGND VGND VPWR VPWR _4159_ sky130_fd_sc_hd__clkbuf_16
XFILLER_0_16_205 VGND VGND VPWR VPWR sky130_fd_sc_hd__fill_2
XFILLER_0_29_577 VGND VGND VPWR VPWR sky130_fd_sc_hd__decap_8
XFILLER_0_71_311 VGND VGND VPWR VPWR sky130_fd_sc_hd__fill_1
X_7441_ _4151_ VGND VGND VPWR VPWR _0447_ sky130_fd_sc_hd__inv_2
X_4653_ _1687_ _1681_ _1690_ VGND VGND VPWR VPWR _1691_ sky130_fd_sc_hd__o21ai_1
XFILLER_0_4_633 VGND VGND VPWR VPWR sky130_fd_sc_hd__decap_8
X_4584_ _1615_ _1625_ VGND VGND VPWR VPWR _1626_ sky130_fd_sc_hd__xor2_1
X_7372_ _4144_ VGND VGND VPWR VPWR _0385_ sky130_fd_sc_hd__inv_2
XFILLER_0_12_400 VGND VGND VPWR VPWR sky130_fd_sc_hd__decap_6
XFILLER_0_24_271 VPWR VGND VPWR VGND sky130_ef_sc_hd__decap_12
X_6323_ _3314_ _3316_ VGND VGND VPWR VPWR _3323_ sky130_fd_sc_hd__nand2_1
XFILLER_0_12_433 VPWR VGND VPWR VGND sky130_ef_sc_hd__decap_12
XFILLER_0_4_699 VGND VGND VPWR VPWR sky130_fd_sc_hd__fill_1
X_6254_ _3191_ _3211_ VGND VGND VPWR VPWR _3258_ sky130_fd_sc_hd__or2_1
XFILLER_0_110_663 VPWR VGND VPWR VGND sky130_ef_sc_hd__decap_12
XFILLER_0_58_72 VGND VGND VPWR VPWR sky130_fd_sc_hd__decap_8
X_5205_ _2230_ _2231_ _2232_ VGND VGND VPWR VPWR _2233_ sky130_fd_sc_hd__nand3_2
X_6185_ _3135_ _3100_ _3136_ _3168_ VGND VGND VPWR VPWR _3190_ sky130_fd_sc_hd__o22a_1
XFILLER_0_42_3 VPWR VGND VPWR VGND sky130_ef_sc_hd__decap_12
XFILLER_0_99_709 VPWR VGND VPWR VGND sky130_ef_sc_hd__decap_12
X_5136_ _2163_ _2164_ VGND VGND VPWR VPWR _2165_ sky130_fd_sc_hd__nor2_1
X_5067_ _2094_ _2090_ _2095_ VGND VGND VPWR VPWR _2096_ sky130_fd_sc_hd__o21a_1
XFILLER_0_79_477 VGND VGND VPWR VPWR sky130_fd_sc_hd__fill_1
X_8826_ clknet_leaf_6_clk net410 _0577_ VGND VGND VPWR VPWR sh9\[6\] sky130_fd_sc_hd__dfrtp_4
XFILLER_0_66_116 VGND VGND VPWR VPWR sky130_fd_sc_hd__decap_3
X_5969_ _2923_ VGND VGND VPWR VPWR _2978_ sky130_fd_sc_hd__inv_2
XFILLER_0_66_149 VPWR VGND VPWR VGND sky130_ef_sc_hd__decap_12
X_8757_ clknet_leaf_61_clk net427 _0508_ VGND VGND VPWR VPWR sh1\[1\] sky130_fd_sc_hd__dfrtp_4
XFILLER_0_75_661 VGND VGND VPWR VPWR sky130_fd_sc_hd__decap_8
XFILLER_0_47_352 VPWR VGND VPWR VGND sky130_ef_sc_hd__decap_12
X_7708_ carry1\[2\] sum1\[3\] VGND VGND VPWR VPWR _4218_ sky130_fd_sc_hd__xnor2_1
XFILLER_0_35_547 VPWR VGND VPWR VGND sky130_ef_sc_hd__decap_12
X_8688_ clknet_leaf_57_clk _0153_ _0439_ VGND VGND VPWR VPWR bit_sum1\[9\] sky130_fd_sc_hd__dfrtp_1
XFILLER_0_47_396 VGND VGND VPWR VPWR sky130_fd_sc_hd__decap_8
XFILLER_0_117_295 VGND VGND VPWR VPWR sky130_fd_sc_hd__fill_1
X_7639_ sum3\[5\] carry3\[4\] VGND VGND VPWR VPWR _4170_ sky130_fd_sc_hd__and2_1
XFILLER_0_22_208 VGND VGND VPWR VPWR sky130_fd_sc_hd__fill_1
XFILLER_0_23_709 VPWR VGND VPWR VGND sky130_ef_sc_hd__decap_12
XFILLER_0_101_641 VGND VGND VPWR VPWR sky130_fd_sc_hd__decap_6
XFILLER_0_30_241 VGND VGND VPWR VPWR sky130_fd_sc_hd__decap_8
XFILLER_0_89_208 VPWR VGND VPWR VGND sky130_ef_sc_hd__decap_12
XFILLER_0_58_639 VGND VGND VPWR VPWR sky130_fd_sc_hd__decap_4
XFILLER_0_38_330 VGND VGND VPWR VPWR sky130_fd_sc_hd__decap_4
XFILLER_0_38_374 VGND VGND VPWR VPWR sky130_fd_sc_hd__decap_4
XFILLER_0_80_141 VPWR VGND VPWR VGND sky130_ef_sc_hd__decap_12
XFILLER_0_79_27 VPWR VGND VPWR VGND sky130_ef_sc_hd__decap_12
XFILLER_0_123_221 VGND VGND VPWR VPWR sky130_fd_sc_hd__decap_3
XFILLER_0_111_427 VGND VGND VPWR VPWR sky130_fd_sc_hd__decap_4
Xhold109 bit_sum3\[4\] VGND VGND VPWR VPWR net151 sky130_fd_sc_hd__dlygate4sd3_1
XFILLER_0_111_449 VGND VGND VPWR VPWR sky130_fd_sc_hd__fill_2
XFILLER_0_0_113 VPWR VGND VPWR VGND sky130_ef_sc_hd__decap_12
XFILLER_0_95_15 VGND VGND VPWR VPWR sky130_fd_sc_hd__decap_8
XTAP_414 VGND VPWR sky130_fd_sc_hd__tapvpwrvgnd_1
XTAP_403 VGND VPWR sky130_fd_sc_hd__tapvpwrvgnd_1
XTAP_425 VGND VPWR sky130_fd_sc_hd__tapvpwrvgnd_1
XTAP_447 VGND VPWR sky130_fd_sc_hd__tapvpwrvgnd_1
XTAP_436 VGND VPWR sky130_fd_sc_hd__tapvpwrvgnd_1
XTAP_458 VGND VPWR sky130_fd_sc_hd__tapvpwrvgnd_1
XFILLER_0_119_55 VGND VGND VPWR VPWR sky130_fd_sc_hd__fill_1
XTAP_469 VGND VPWR sky130_fd_sc_hd__tapvpwrvgnd_1
XFILLER_0_28_53 VPWR VGND VPWR VGND sky130_ef_sc_hd__decap_12
X_7990_ _0767_ _0763_ _0769_ VGND VGND VPWR VPWR _0839_ sky130_fd_sc_hd__o21a_1
X_6941_ _3927_ _3835_ VGND VGND VPWR VPWR _3928_ sky130_fd_sc_hd__nand2_1
XFILLER_0_44_41 VPWR VGND VPWR VGND sky130_ef_sc_hd__decap_12
XFILLER_0_76_403 VPWR VGND VPWR VGND sky130_ef_sc_hd__decap_12
X_6872_ sh8\[1\] sh9\[1\] VGND VGND VPWR VPWR _3860_ sky130_fd_sc_hd__and2_2
X_5823_ _2799_ _2836_ _2796_ _2834_ _2831_ VGND VGND VPWR VPWR _2837_ sky130_fd_sc_hd__o2111a_1
XFILLER_0_29_330 VGND VGND VPWR VPWR sky130_fd_sc_hd__fill_1
X_8611_ clknet_leaf_57_clk net87 _0362_ VGND VGND VPWR VPWR s2\[3\] sky130_fd_sc_hd__dfrtp_1
XFILLER_0_91_428 VGND VGND VPWR VPWR sky130_fd_sc_hd__fill_1
X_8542_ clknet_leaf_34_clk net392 _0293_ VGND VGND VPWR VPWR carry2\[4\] sky130_fd_sc_hd__dfrtp_1
XFILLER_0_17_514 VGND VGND VPWR VPWR sky130_fd_sc_hd__fill_1
X_5754_ _2664_ _2721_ _2722_ VGND VGND VPWR VPWR _2770_ sky130_fd_sc_hd__o21a_1
X_4705_ sh10\[7\] _1662_ _1663_ VGND VGND VPWR VPWR _1743_ sky130_fd_sc_hd__a21bo_2
X_5685_ _2666_ _2698_ _2701_ VGND VGND VPWR VPWR _2702_ sky130_fd_sc_hd__nand3_1
X_8473_ clknet_leaf_43_clk net130 _0224_ VGND VGND VPWR VPWR s0\[5\] sky130_fd_sc_hd__dfrtp_2
X_4636_ sh13\[7\] VGND VGND VPWR VPWR _1674_ sky130_fd_sc_hd__clkbuf_4
XFILLER_0_8_41 VPWR VGND VPWR VGND sky130_ef_sc_hd__decap_12
X_7424_ _4150_ VGND VGND VPWR VPWR _0431_ sky130_fd_sc_hd__inv_2
XFILLER_0_44_388 VPWR VGND VPWR VGND sky130_ef_sc_hd__decap_12
X_7355_ _4143_ VGND VGND VPWR VPWR _0369_ sky130_fd_sc_hd__inv_2
X_4567_ _1608_ _1541_ _1605_ VGND VGND VPWR VPWR _1610_ sky130_fd_sc_hd__and3_1
XFILLER_0_102_449 VPWR VGND VPWR VGND sky130_ef_sc_hd__decap_12
X_6306_ sh5\[4\] VGND VGND VPWR VPWR _3306_ sky130_fd_sc_hd__clkbuf_4
XFILLER_0_8_85 VPWR VGND VPWR VGND sky130_ef_sc_hd__decap_12
XFILLER_0_4_496 VGND VGND VPWR VPWR sky130_fd_sc_hd__fill_2
X_4498_ _1227_ _1299_ sh15\[5\] VGND VGND VPWR VPWR _1542_ sky130_fd_sc_hd__a21oi_2
X_7286_ _4135_ VGND VGND VPWR VPWR _0308_ sky130_fd_sc_hd__inv_2
XFILLER_0_12_296 VPWR VGND VPWR VGND sky130_ef_sc_hd__decap_12
XFILLER_0_12_274 VPWR VGND VPWR VGND sky130_ef_sc_hd__decap_12
X_6237_ _3228_ _3241_ _3231_ VGND VGND VPWR VPWR _3242_ sky130_fd_sc_hd__o21a_1
X_6168_ _3170_ _3171_ _3173_ _3136_ VGND VGND VPWR VPWR _3174_ sky130_fd_sc_hd__o211a_2
XTAP_970 VGND VPWR sky130_fd_sc_hd__tapvpwrvgnd_1
XFILLER_0_85_81 VPWR VGND VPWR VGND sky130_ef_sc_hd__decap_12
XTAP_992 VGND VPWR sky130_fd_sc_hd__tapvpwrvgnd_1
XTAP_981 VGND VPWR sky130_fd_sc_hd__tapvpwrvgnd_1
X_5119_ _2061_ sh3\[2\] VGND VGND VPWR VPWR _2148_ sky130_fd_sc_hd__nor2_1
X_6099_ _3085_ _3089_ _3090_ VGND VGND VPWR VPWR _3106_ sky130_fd_sc_hd__a21o_1
XFILLER_0_67_425 VGND VGND VPWR VPWR sky130_fd_sc_hd__fill_1
X_8809_ clknet_leaf_9_clk net286 _0560_ VGND VGND VPWR VPWR sh7\[5\] sky130_fd_sc_hd__dfrtp_1
XFILLER_0_39_149 VGND VGND VPWR VPWR sky130_fd_sc_hd__fill_1
XFILLER_0_82_406 VGND VGND VPWR VPWR sky130_fd_sc_hd__decap_4
XFILLER_0_47_160 VGND VGND VPWR VPWR sky130_fd_sc_hd__decap_8
XFILLER_0_63_653 VPWR VGND VPWR VGND sky130_ef_sc_hd__decap_12
XFILLER_0_62_174 VGND VGND VPWR VPWR sky130_fd_sc_hd__decap_6
XFILLER_0_105_265 VGND VGND VPWR VPWR sky130_fd_sc_hd__fill_1
XFILLER_0_31_561 VPWR VGND VPWR VGND sky130_ef_sc_hd__decap_12
XFILLER_0_81_39 VPWR VGND VPWR VGND sky130_ef_sc_hd__decap_12
XFILLER_0_85_222 VGND VGND VPWR VPWR sky130_fd_sc_hd__fill_2
XFILLER_0_58_436 VPWR VGND VPWR VGND sky130_ef_sc_hd__decap_12
XFILLER_0_14_55 VGND VGND VPWR VPWR sky130_fd_sc_hd__fill_1
XFILLER_0_14_88 VGND VGND VPWR VPWR sky130_fd_sc_hd__fill_2
XFILLER_0_5_205 VPWR VGND VPWR VGND sky130_ef_sc_hd__decap_12
XFILLER_0_26_333 VPWR VGND VPWR VGND sky130_ef_sc_hd__decap_12
XFILLER_0_53_152 VGND VGND VPWR VPWR sky130_fd_sc_hd__fill_1
X_5470_ sh5\[0\] VGND VGND VPWR VPWR _2490_ sky130_fd_sc_hd__clkbuf_4
XFILLER_0_26_377 VPWR VGND VPWR VGND sky130_ef_sc_hd__decap_12
XFILLER_0_30_54 VGND VGND VPWR VPWR sky130_fd_sc_hd__decap_4
XFILLER_0_112_725 VGND VGND VPWR VPWR sky130_fd_sc_hd__decap_8
X_4421_ _1458_ _1459_ _1461_ VGND VGND VPWR VPWR _1467_ sky130_fd_sc_hd__o21ai_1
XFILLER_0_100_3 VPWR VGND VPWR VGND sky130_ef_sc_hd__decap_12
XFILLER_0_111_213 VGND VGND VPWR VPWR sky130_fd_sc_hd__decap_8
XFILLER_0_10_701 VPWR VGND VPWR VGND sky130_ef_sc_hd__decap_12
XFILLER_0_111_279 VGND VGND VPWR VPWR sky130_fd_sc_hd__fill_1
X_4352_ _1398_ _1393_ _1394_ VGND VGND VPWR VPWR _1399_ sky130_fd_sc_hd__nand3_1
X_7140_ s0\[5\] s1\[5\] VGND VGND VPWR VPWR _4115_ sky130_fd_sc_hd__xnor2_1
X_4283_ sh10\[5\] _1227_ _1228_ VGND VGND VPWR VPWR _1331_ sky130_fd_sc_hd__a21bo_2
X_7071_ _4002_ _4005_ _4007_ VGND VGND VPWR VPWR _4056_ sky130_fd_sc_hd__and3_1
X_6022_ _2894_ sh7\[6\] sh8\[6\] VGND VGND VPWR VPWR _3030_ sky130_fd_sc_hd__o21a_1
XTAP_255 VGND VPWR sky130_fd_sc_hd__tapvpwrvgnd_1
XTAP_266 VGND VPWR sky130_fd_sc_hd__tapvpwrvgnd_1
XTAP_277 VGND VPWR sky130_fd_sc_hd__tapvpwrvgnd_1
XTAP_288 VGND VPWR sky130_fd_sc_hd__tapvpwrvgnd_1
XTAP_299 VGND VPWR sky130_fd_sc_hd__tapvpwrvgnd_1
X_7973_ sh5\[3\] sh7\[3\] sh8\[3\] VGND VGND VPWR VPWR _0822_ sky130_fd_sc_hd__o21ai_4
XFILLER_0_89_561 VGND VGND VPWR VPWR sky130_fd_sc_hd__decap_6
X_6924_ _3909_ _3764_ _3858_ _3910_ VGND VGND VPWR VPWR _3911_ sky130_fd_sc_hd__o22a_1
XFILLER_0_76_233 VPWR VGND VPWR VGND sky130_ef_sc_hd__decap_12
Xfanout37 sh6\[6\] VGND VGND VPWR VPWR net37 sky130_fd_sc_hd__clkbuf_4
X_6855_ _3797_ _3747_ _3736_ VGND VGND VPWR VPWR _3843_ sky130_fd_sc_hd__o21ai_4
XFILLER_0_76_299 VGND VGND VPWR VPWR sky130_fd_sc_hd__decap_8
X_6786_ _3762_ _3771_ _3774_ VGND VGND VPWR VPWR _3775_ sky130_fd_sc_hd__a21boi_1
X_5806_ _2817_ _2820_ VGND VGND VPWR VPWR _2821_ sky130_fd_sc_hd__and2_1
X_8525_ clknet_leaf_22_clk net135 _0276_ VGND VGND VPWR VPWR sum5\[15\] sky130_fd_sc_hd__dfrtp_1
X_5737_ _2728_ _2751_ _2752_ VGND VGND VPWR VPWR _2753_ sky130_fd_sc_hd__nand3b_2
X_8456_ clknet_leaf_31_clk net244 _0207_ VGND VGND VPWR VPWR carry3\[11\] sky130_fd_sc_hd__dfrtp_1
XFILLER_0_60_623 VGND VGND VPWR VPWR sky130_fd_sc_hd__fill_1
XFILLER_0_45_697 VPWR VGND VPWR VGND sky130_ef_sc_hd__decap_12
X_7407_ _4148_ VGND VGND VPWR VPWR _0416_ sky130_fd_sc_hd__inv_2
X_5668_ _2478_ _2481_ _2473_ VGND VGND VPWR VPWR _2685_ sky130_fd_sc_hd__o21ai_1
XFILLER_0_44_185 VGND VGND VPWR VPWR sky130_fd_sc_hd__decap_8
X_4619_ _1642_ _1657_ _1639_ VGND VGND VPWR VPWR _1658_ sky130_fd_sc_hd__o21bai_2
X_8387_ carry5\[14\] _1218_ VGND VGND VPWR VPWR _1219_ sky130_fd_sc_hd__xor2_1
X_5599_ _2487_ _2491_ _2616_ VGND VGND VPWR VPWR _2617_ sky130_fd_sc_hd__a21oi_1
XFILLER_0_13_550 VGND VGND VPWR VPWR sky130_fd_sc_hd__decap_8
XFILLER_0_13_561 VGND VGND VPWR VPWR sky130_fd_sc_hd__decap_4
XFILLER_0_102_257 VGND VGND VPWR VPWR sky130_fd_sc_hd__decap_6
X_7338_ _4141_ VGND VGND VPWR VPWR _0354_ sky130_fd_sc_hd__inv_2
X_7269_ _4134_ VGND VGND VPWR VPWR _0292_ sky130_fd_sc_hd__inv_2
XFILLER_0_96_91 VGND VGND VPWR VPWR sky130_fd_sc_hd__fill_1
XFILLER_0_99_358 VGND VGND VPWR VPWR sky130_fd_sc_hd__fill_1
XFILLER_0_68_701 VGND VGND VPWR VPWR sky130_fd_sc_hd__decap_3
XFILLER_0_67_200 VGND VGND VPWR VPWR sky130_fd_sc_hd__decap_6
XFILLER_0_67_211 VPWR VGND VPWR VGND sky130_ef_sc_hd__decap_12
XFILLER_0_83_715 VPWR VGND VPWR VGND sky130_ef_sc_hd__decap_12
XFILLER_0_82_214 VGND VGND VPWR VPWR sky130_fd_sc_hd__fill_1
XFILLER_0_82_258 VGND VGND VPWR VPWR sky130_fd_sc_hd__fill_2
XFILLER_0_3_709 VPWR VGND VPWR VGND sky130_ef_sc_hd__decap_12
XFILLER_0_106_585 VGND VGND VPWR VPWR sky130_fd_sc_hd__decap_3
XFILLER_0_63_494 VGND VGND VPWR VPWR sky130_fd_sc_hd__fill_2
XFILLER_0_35_185 VGND VGND VPWR VPWR sky130_fd_sc_hd__decap_3
X_4970_ _1674_ _1791_ _2002_ VGND VGND VPWR VPWR _2003_ sky130_fd_sc_hd__a21o_1
XFILLER_0_74_726 VGND VGND VPWR VPWR sky130_fd_sc_hd__decap_8
XFILLER_0_86_597 VPWR VGND VPWR VGND sky130_ef_sc_hd__decap_12
X_6640_ _3633_ _3629_ _3631_ VGND VGND VPWR VPWR _3635_ sky130_fd_sc_hd__nand3_2
XFILLER_0_73_225 VGND VGND VPWR VPWR sky130_fd_sc_hd__decap_6
X_6571_ _3565_ _3566_ VGND VGND VPWR VPWR _3567_ sky130_fd_sc_hd__and2_1
X_8310_ _1141_ _1139_ _1143_ _1147_ VGND VGND VPWR VPWR _1149_ sky130_fd_sc_hd__o211ai_2
X_5522_ _2527_ _2528_ _2530_ VGND VGND VPWR VPWR _2541_ sky130_fd_sc_hd__a21oi_1
XFILLER_0_26_141 VGND VGND VPWR VPWR sky130_fd_sc_hd__decap_8
XFILLER_0_27_697 VPWR VGND VPWR VGND sky130_ef_sc_hd__decap_12
XFILLER_0_41_111 VGND VGND VPWR VPWR sky130_fd_sc_hd__fill_1
XFILLER_0_42_656 VPWR VGND VPWR VGND sky130_ef_sc_hd__decap_12
XFILLER_0_112_533 VPWR VGND VPWR VGND sky130_ef_sc_hd__decap_12
XFILLER_0_74_6 VGND VGND VPWR VPWR sky130_fd_sc_hd__fill_2
X_8241_ _1085_ _1081_ _1001_ VGND VGND VPWR VPWR _1086_ sky130_fd_sc_hd__o21ai_2
X_5453_ sh2\[0\] VGND VGND VPWR VPWR _2473_ sky130_fd_sc_hd__clkbuf_4
XFILLER_0_41_155 VPWR VGND VPWR VGND sky130_ef_sc_hd__decap_12
X_4404_ _1442_ _1445_ _1389_ _1449_ VGND VGND VPWR VPWR _1450_ sky130_fd_sc_hd__o2bb2ai_4
X_8172_ _0733_ _1012_ _1004_ _1002_ _1014_ VGND VGND VPWR VPWR _1018_ sky130_fd_sc_hd__o221ai_4
X_5384_ _2396_ _2401_ _2408_ VGND VGND VPWR VPWR _2409_ sky130_fd_sc_hd__a21oi_1
X_4335_ net32 sh9\[5\] VGND VGND VPWR VPWR _1382_ sky130_fd_sc_hd__and2_1
X_7123_ _4098_ _4103_ _4105_ VGND VGND VPWR VPWR _4106_ sky130_fd_sc_hd__a21oi_1
X_4266_ _1227_ sh12\[5\] VGND VGND VPWR VPWR _1314_ sky130_fd_sc_hd__and2_2
X_7054_ _4037_ _4038_ VGND VGND VPWR VPWR _4039_ sky130_fd_sc_hd__nand2_1
X_6005_ _3004_ _3007_ _3012_ VGND VGND VPWR VPWR _3013_ sky130_fd_sc_hd__nand3_2
XTAP_1229 VGND VPWR sky130_fd_sc_hd__tapvpwrvgnd_1
XTAP_1207 VGND VPWR sky130_fd_sc_hd__tapvpwrvgnd_1
XTAP_1218 VGND VPWR sky130_fd_sc_hd__tapvpwrvgnd_1
X_7956_ _0729_ _0757_ _0728_ VGND VGND VPWR VPWR _0805_ sky130_fd_sc_hd__o21bai_1
XFILLER_0_92_501 VGND VGND VPWR VPWR sky130_fd_sc_hd__fill_1
X_7887_ net42 VGND VGND VPWR VPWR _0737_ sky130_fd_sc_hd__buf_4
X_6907_ _3889_ _3892_ _3894_ VGND VGND VPWR VPWR _3895_ sky130_fd_sc_hd__a21oi_1
XFILLER_0_119_143 VGND VGND VPWR VPWR sky130_fd_sc_hd__fill_2
X_6838_ _3823_ _3824_ _3822_ VGND VGND VPWR VPWR _3827_ sky130_fd_sc_hd__a21o_1
XFILLER_0_37_417 VGND VGND VPWR VPWR sky130_fd_sc_hd__decap_3
XFILLER_0_119_187 VGND VGND VPWR VPWR sky130_fd_sc_hd__fill_1
XFILLER_0_64_247 VGND VGND VPWR VPWR sky130_fd_sc_hd__decap_4
X_8508_ clknet_leaf_24_clk _0168_ _0259_ VGND VGND VPWR VPWR final_sum\[14\] sky130_fd_sc_hd__dfrtp_1
X_6769_ _3739_ _3740_ VGND VGND VPWR VPWR _3758_ sky130_fd_sc_hd__nand2_1
XFILLER_0_72_280 VGND VGND VPWR VPWR sky130_fd_sc_hd__fill_1
XFILLER_0_33_656 VPWR VGND VPWR VGND sky130_ef_sc_hd__decap_12
X_8439_ clknet_leaf_38_clk net382 _0190_ VGND VGND VPWR VPWR carry4\[5\] sky130_fd_sc_hd__dfrtp_1
XFILLER_0_60_464 VGND VGND VPWR VPWR sky130_fd_sc_hd__fill_1
XFILLER_0_32_144 VGND VGND VPWR VPWR sky130_fd_sc_hd__decap_4
Xhold270 carry3\[6\] VGND VGND VPWR VPWR net312 sky130_fd_sc_hd__dlygate4sd3_1
Xhold281 s5\[8\] VGND VGND VPWR VPWR net323 sky130_fd_sc_hd__dlygate4sd3_1
Xhold292 sum1\[3\] VGND VGND VPWR VPWR net334 sky130_fd_sc_hd__dlygate4sd3_1
XFILLER_0_99_188 VPWR VGND VPWR VGND sky130_ef_sc_hd__decap_12
XFILLER_0_68_531 VGND VGND VPWR VPWR sky130_fd_sc_hd__fill_1
XTAP_1752 VGND VPWR sky130_fd_sc_hd__tapvpwrvgnd_1
XTAP_1741 VGND VPWR sky130_fd_sc_hd__tapvpwrvgnd_1
XTAP_1730 VGND VPWR sky130_fd_sc_hd__tapvpwrvgnd_1
XTAP_1785 VGND VPWR sky130_fd_sc_hd__tapvpwrvgnd_1
XTAP_1774 VGND VPWR sky130_fd_sc_hd__tapvpwrvgnd_1
XTAP_1763 VGND VPWR sky130_fd_sc_hd__tapvpwrvgnd_1
XFILLER_0_83_512 VGND VGND VPWR VPWR sky130_fd_sc_hd__decap_4
XFILLER_0_55_225 VPWR VGND VPWR VGND sky130_ef_sc_hd__decap_12
XFILLER_0_55_203 VGND VGND VPWR VPWR sky130_fd_sc_hd__fill_1
XTAP_1796 VGND VPWR sky130_fd_sc_hd__tapvpwrvgnd_1
XFILLER_0_71_729 VGND VGND VPWR VPWR sky130_fd_sc_hd__decap_6
XFILLER_0_24_601 VGND VGND VPWR VPWR sky130_fd_sc_hd__fill_1
XFILLER_0_43_409 VGND VGND VPWR VPWR sky130_fd_sc_hd__fill_2
XFILLER_0_102_58 VGND VGND VPWR VPWR sky130_fd_sc_hd__decap_4
XFILLER_0_24_645 VGND VGND VPWR VPWR sky130_fd_sc_hd__decap_8
XFILLER_0_3_539 VGND VGND VPWR VPWR sky130_fd_sc_hd__fill_2
XFILLER_0_23_133 VPWR VGND VPWR VGND sky130_ef_sc_hd__decap_12
XFILLER_0_87_27 VPWR VGND VPWR VGND sky130_ef_sc_hd__decap_12
XFILLER_0_23_188 VGND VGND VPWR VPWR sky130_fd_sc_hd__fill_1
XFILLER_0_51_486 VGND VGND VPWR VPWR sky130_fd_sc_hd__fill_1
Xinput5 x[3] VGND VGND VPWR VPWR net5 sky130_fd_sc_hd__clkbuf_1
X_7810_ net220 _0690_ VGND VGND VPWR VPWR _0074_ sky130_fd_sc_hd__xnor2_1
XFILLER_0_78_339 VGND VGND VPWR VPWR sky130_fd_sc_hd__decap_8
XFILLER_0_59_520 VGND VGND VPWR VPWR sky130_fd_sc_hd__decap_6
X_8790_ clknet_leaf_64_clk net341 _0541_ VGND VGND VPWR VPWR sh5\[2\] sky130_fd_sc_hd__dfrtp_1
X_4953_ _1677_ _1848_ _1985_ _1986_ _1743_ VGND VGND VPWR VPWR _1987_ sky130_fd_sc_hd__o2111ai_4
XFILLER_0_93_309 VPWR VGND VPWR VGND sky130_ef_sc_hd__decap_12
X_7741_ net258 _0644_ _0645_ VGND VGND VPWR VPWR _0647_ sky130_fd_sc_hd__or3_1
XFILLER_0_59_564 VGND VGND VPWR VPWR sky130_fd_sc_hd__decap_3
XFILLER_0_47_704 VGND VGND VPWR VPWR sky130_fd_sc_hd__fill_1
X_7672_ net280 _4194_ _4195_ VGND VGND VPWR VPWR _4197_ sky130_fd_sc_hd__or3_1
XFILLER_0_19_428 VGND VGND VPWR VPWR sky130_fd_sc_hd__decap_6
XFILLER_0_47_726 VGND VGND VPWR VPWR sky130_fd_sc_hd__fill_2
X_4884_ _1915_ _1918_ _1690_ VGND VGND VPWR VPWR _1919_ sky130_fd_sc_hd__o21ai_1
XFILLER_0_117_636 VPWR VGND VPWR VGND sky130_ef_sc_hd__decap_12
X_6623_ _3607_ _3605_ _3561_ VGND VGND VPWR VPWR _3618_ sky130_fd_sc_hd__a21o_1
XFILLER_0_52_85 VPWR VGND VPWR VGND sky130_ef_sc_hd__decap_12
XFILLER_0_62_729 VGND VGND VPWR VPWR sky130_fd_sc_hd__decap_6
X_6554_ _3422_ _3424_ _3431_ _3436_ VGND VGND VPWR VPWR _3550_ sky130_fd_sc_hd__o31a_1
XFILLER_0_61_239 VPWR VGND VPWR VGND sky130_ef_sc_hd__decap_12
XFILLER_0_54_280 VGND VGND VPWR VPWR sky130_fd_sc_hd__fill_1
XFILLER_0_6_377 VGND VGND VPWR VPWR sky130_fd_sc_hd__decap_4
X_6485_ _3481_ _3482_ VGND VGND VPWR VPWR _3483_ sky130_fd_sc_hd__and2_1
XFILLER_0_14_133 VGND VGND VPWR VPWR sky130_fd_sc_hd__fill_1
XFILLER_0_6_399 VGND VGND VPWR VPWR sky130_fd_sc_hd__decap_4
X_5505_ net36 sh8\[0\] VGND VGND VPWR VPWR _2524_ sky130_fd_sc_hd__nand2_4
XFILLER_0_72_3 VPWR VGND VPWR VGND sky130_ef_sc_hd__decap_12
X_8224_ _1066_ _1067_ _1068_ VGND VGND VPWR VPWR _1069_ sky130_fd_sc_hd__o21ai_2
XFILLER_0_42_475 VGND VGND VPWR VPWR sky130_fd_sc_hd__fill_1
X_5436_ _2457_ _2458_ VGND VGND VPWR VPWR _2459_ sky130_fd_sc_hd__nand2_1
XFILLER_0_112_363 VGND VGND VPWR VPWR sky130_fd_sc_hd__fill_1
XFILLER_0_100_525 VGND VGND VPWR VPWR sky130_fd_sc_hd__decap_6
X_8155_ _0765_ _0999_ _0799_ VGND VGND VPWR VPWR _1001_ sky130_fd_sc_hd__o21ai_4
XFILLER_0_10_361 VGND VGND VPWR VPWR sky130_fd_sc_hd__decap_3
X_5367_ _2040_ _2104_ sh15\[2\] VGND VGND VPWR VPWR _2392_ sky130_fd_sc_hd__a21oi_1
X_4318_ _1237_ _1268_ VGND VGND VPWR VPWR _1365_ sky130_fd_sc_hd__nand2_1
XFILLER_0_77_93 VPWR VGND VPWR VGND sky130_ef_sc_hd__decap_12
X_8086_ _0731_ _0733_ _0723_ VGND VGND VPWR VPWR _0933_ sky130_fd_sc_hd__o21ai_2
X_7106_ _4060_ _4087_ _4088_ VGND VGND VPWR VPWR _4090_ sky130_fd_sc_hd__nor3_1
X_5298_ _2060_ _2071_ VGND VGND VPWR VPWR _2324_ sky130_fd_sc_hd__nand2_1
X_4249_ _1247_ net34 sh8\[5\] VGND VGND VPWR VPWR _1297_ sky130_fd_sc_hd__o21ai_2
X_7037_ _3715_ _3704_ _4017_ VGND VGND VPWR VPWR _4022_ sky130_fd_sc_hd__a21o_1
XFILLER_0_69_317 VPWR VGND VPWR VGND sky130_ef_sc_hd__decap_12
XFILLER_0_96_136 VGND VGND VPWR VPWR sky130_fd_sc_hd__decap_4
XTAP_1004 VGND VPWR sky130_fd_sc_hd__tapvpwrvgnd_1
XFILLER_0_84_309 VPWR VGND VPWR VGND sky130_ef_sc_hd__decap_12
XTAP_1037 VGND VPWR sky130_fd_sc_hd__tapvpwrvgnd_1
XTAP_1026 VGND VPWR sky130_fd_sc_hd__tapvpwrvgnd_1
XTAP_1015 VGND VPWR sky130_fd_sc_hd__tapvpwrvgnd_1
X_7939_ _0740_ _0735_ _0739_ _0745_ _0754_ VGND VGND VPWR VPWR _0788_ sky130_fd_sc_hd__a32o_1
XTAP_1059 VGND VPWR sky130_fd_sc_hd__tapvpwrvgnd_1
XTAP_1048 VGND VPWR sky130_fd_sc_hd__tapvpwrvgnd_1
XFILLER_0_37_214 VGND VGND VPWR VPWR sky130_fd_sc_hd__fill_1
XFILLER_0_108_614 VGND VGND VPWR VPWR sky130_fd_sc_hd__decap_4
XFILLER_0_92_342 VGND VGND VPWR VPWR sky130_fd_sc_hd__decap_6
XFILLER_0_108_636 VGND VGND VPWR VPWR sky130_fd_sc_hd__decap_8
XFILLER_0_107_135 VGND VGND VPWR VPWR sky130_fd_sc_hd__fill_1
XFILLER_0_107_113 VGND VGND VPWR VPWR sky130_fd_sc_hd__decap_4
XFILLER_0_92_353 VGND VGND VPWR VPWR sky130_fd_sc_hd__fill_1
XFILLER_0_80_504 VPWR VGND VPWR VGND sky130_ef_sc_hd__decap_12
XFILLER_0_9_193 VPWR VGND VPWR VGND sky130_ef_sc_hd__decap_12
XFILLER_0_80_548 VPWR VGND VPWR VGND sky130_ef_sc_hd__decap_12
XFILLER_0_52_239 VPWR VGND VPWR VGND sky130_ef_sc_hd__decap_12
XFILLER_0_21_604 VGND VGND VPWR VPWR sky130_fd_sc_hd__decap_4
XFILLER_0_33_453 VGND VGND VPWR VPWR sky130_fd_sc_hd__fill_1
XFILLER_0_103_330 VGND VGND VPWR VPWR sky130_fd_sc_hd__decap_3
XFILLER_0_20_103 VGND VGND VPWR VPWR sky130_fd_sc_hd__fill_1
XFILLER_0_21_615 VGND VGND VPWR VPWR sky130_fd_sc_hd__fill_1
XFILLER_0_20_125 VPWR VGND VPWR VGND sky130_ef_sc_hd__decap_12
XFILLER_0_88_648 VGND VGND VPWR VPWR sky130_fd_sc_hd__fill_2
XFILLER_0_88_637 VGND VGND VPWR VPWR sky130_fd_sc_hd__decap_6
XTAP_1560 VGND VPWR sky130_fd_sc_hd__tapvpwrvgnd_1
XFILLER_0_68_372 VGND VGND VPWR VPWR sky130_fd_sc_hd__decap_6
XTAP_1593 VGND VPWR sky130_fd_sc_hd__tapvpwrvgnd_1
XTAP_1582 VGND VPWR sky130_fd_sc_hd__tapvpwrvgnd_1
XTAP_1571 VGND VPWR sky130_fd_sc_hd__tapvpwrvgnd_1
XFILLER_0_68_394 VGND VGND VPWR VPWR sky130_fd_sc_hd__fill_2
XFILLER_0_56_567 VGND VGND VPWR VPWR sky130_fd_sc_hd__decap_3
XFILLER_0_28_247 VGND VGND VPWR VPWR sky130_fd_sc_hd__fill_2
XFILLER_0_113_57 VGND VGND VPWR VPWR sky130_fd_sc_hd__decap_8
XFILLER_0_56_589 VPWR VGND VPWR VGND sky130_ef_sc_hd__decap_12
XFILLER_0_114_617 VGND VGND VPWR VPWR sky130_fd_sc_hd__fill_1
XFILLER_0_98_15 VPWR VGND VPWR VGND sky130_ef_sc_hd__decap_12
XFILLER_0_43_239 VGND VGND VPWR VPWR sky130_fd_sc_hd__fill_2
XFILLER_0_114_628 VPWR VGND VPWR VGND sky130_ef_sc_hd__decap_12
XFILLER_0_24_497 VGND VGND VPWR VPWR sky130_fd_sc_hd__decap_8
X_6270_ _3253_ _3261_ _3272_ VGND VGND VPWR VPWR _3273_ sky130_fd_sc_hd__a21o_1
XFILLER_0_12_648 VPWR VGND VPWR VGND sky130_ef_sc_hd__decap_12
XFILLER_0_122_694 VGND VGND VPWR VPWR sky130_fd_sc_hd__decap_6
XFILLER_0_121_193 VPWR VGND VPWR VGND sky130_ef_sc_hd__decap_12
X_5221_ _2203_ _2201_ _2218_ VGND VGND VPWR VPWR _2248_ sky130_fd_sc_hd__o21ai_1
X_5152_ _2133_ _2134_ _2180_ VGND VGND VPWR VPWR _2181_ sky130_fd_sc_hd__and3_1
X_5083_ _2097_ _2101_ _2108_ _2111_ VGND VGND VPWR VPWR _2112_ sky130_fd_sc_hd__o2bb2ai_1
X_8842_ clknet_leaf_3_clk net191 _0593_ VGND VGND VPWR VPWR sh11\[6\] sky130_fd_sc_hd__dfrtp_4
XFILLER_0_79_648 VPWR VGND VPWR VGND sky130_ef_sc_hd__decap_12
XFILLER_0_79_637 VGND VGND VPWR VPWR sky130_fd_sc_hd__decap_3
XFILLER_0_2_65 VPWR VGND VPWR VGND sky130_ef_sc_hd__decap_12
XFILLER_0_66_309 VGND VGND VPWR VPWR sky130_fd_sc_hd__decap_3
X_8773_ clknet_leaf_61_clk net180 _0524_ VGND VGND VPWR VPWR sh3\[1\] sky130_fd_sc_hd__dfrtp_2
XFILLER_0_94_629 VGND VGND VPWR VPWR sky130_fd_sc_hd__fill_1
X_5985_ _2993_ _2902_ _2868_ VGND VGND VPWR VPWR _2994_ sky130_fd_sc_hd__a21oi_1
XFILLER_0_87_670 VGND VGND VPWR VPWR sky130_fd_sc_hd__fill_2
XFILLER_0_63_95 VGND VGND VPWR VPWR sky130_fd_sc_hd__fill_1
XPHY_109 VGND VGND VPWR VPWR sky130_fd_sc_hd__decap_3
X_7724_ carry1\[10\] net451 VGND VGND VPWR VPWR _0634_ sky130_fd_sc_hd__xnor2_1
XFILLER_0_19_203 VGND VGND VPWR VPWR sky130_fd_sc_hd__decap_6
X_4936_ _1915_ _1959_ _1956_ _1958_ VGND VGND VPWR VPWR _1970_ sky130_fd_sc_hd__o211ai_4
X_4867_ _1829_ _1674_ VGND VGND VPWR VPWR _1903_ sky130_fd_sc_hd__nand2_1
X_7655_ sum3\[8\] carry3\[7\] VGND VGND VPWR VPWR _4183_ sky130_fd_sc_hd__nor2_1
XFILLER_0_117_466 VGND VGND VPWR VPWR sky130_fd_sc_hd__decap_6
XFILLER_0_105_606 VGND VGND VPWR VPWR sky130_fd_sc_hd__fill_1
X_7586_ _4165_ VGND VGND VPWR VPWR _0578_ sky130_fd_sc_hd__inv_2
X_6606_ _3511_ _3547_ _3588_ VGND VGND VPWR VPWR _3601_ sky130_fd_sc_hd__o21a_1
XFILLER_0_7_653 VPWR VGND VPWR VGND sky130_ef_sc_hd__decap_12
XFILLER_0_6_141 VPWR VGND VPWR VGND sky130_ef_sc_hd__decap_12
X_4798_ _1834_ VGND VGND VPWR VPWR _0183_ sky130_fd_sc_hd__clkbuf_1
X_6537_ _3466_ _3467_ _3468_ _3533_ VGND VGND VPWR VPWR _3534_ sky130_fd_sc_hd__a31oi_2
XFILLER_0_7_697 VPWR VGND VPWR VGND sky130_ef_sc_hd__decap_12
XFILLER_0_15_431 VGND VGND VPWR VPWR sky130_fd_sc_hd__decap_8
XFILLER_0_15_442 VGND VGND VPWR VPWR sky130_fd_sc_hd__decap_6
XFILLER_0_42_272 VPWR VGND VPWR VGND sky130_ef_sc_hd__decap_12
X_6468_ _3459_ _3463_ _3455_ VGND VGND VPWR VPWR _3466_ sky130_fd_sc_hd__o21ai_2
XFILLER_0_30_456 VPWR VGND VPWR VGND sky130_ef_sc_hd__decap_12
X_8207_ sh13\[3\] sh9\[3\] VGND VGND VPWR VPWR _1052_ sky130_fd_sc_hd__and2_2
X_6399_ _3352_ _3314_ _3396_ _3397_ VGND VGND VPWR VPWR _3398_ sky130_fd_sc_hd__o211a_1
X_5419_ _2440_ _2442_ _2315_ _2328_ VGND VGND VPWR VPWR _2443_ sky130_fd_sc_hd__o2bb2ai_2
XFILLER_0_100_355 VGND VGND VPWR VPWR sky130_fd_sc_hd__fill_1
X_8138_ _0981_ _0984_ sh15\[3\] VGND VGND VPWR VPWR _0985_ sky130_fd_sc_hd__o21bai_2
XFILLER_0_100_399 VGND VGND VPWR VPWR sky130_fd_sc_hd__fill_1
X_8069_ _0846_ _0849_ VGND VGND VPWR VPWR _0917_ sky130_fd_sc_hd__nand2_1
XFILLER_0_97_434 VPWR VGND VPWR VGND sky130_ef_sc_hd__decap_12
XFILLER_0_69_169 VGND VGND VPWR VPWR sky130_fd_sc_hd__decap_4
XFILLER_0_93_651 VPWR VGND VPWR VGND sky130_ef_sc_hd__decap_12
XFILLER_0_84_139 VGND VGND VPWR VPWR sky130_fd_sc_hd__fill_1
XFILLER_0_77_180 VGND VGND VPWR VPWR sky130_fd_sc_hd__fill_2
XFILLER_0_93_684 VGND VGND VPWR VPWR sky130_fd_sc_hd__fill_2
XFILLER_0_38_589 VGND VGND VPWR VPWR sky130_fd_sc_hd__decap_4
XFILLER_0_108_477 VGND VGND VPWR VPWR sky130_fd_sc_hd__fill_2
XFILLER_0_25_217 VGND VGND VPWR VPWR sky130_fd_sc_hd__decap_6
XFILLER_0_68_29 VGND VGND VPWR VPWR sky130_fd_sc_hd__decap_6
XTAP_607 VGND VPWR sky130_fd_sc_hd__tapvpwrvgnd_1
XTAP_618 VGND VPWR sky130_fd_sc_hd__tapvpwrvgnd_1
XTAP_629 VGND VPWR sky130_fd_sc_hd__tapvpwrvgnd_1
XFILLER_0_88_401 VGND VGND VPWR VPWR sky130_fd_sc_hd__decap_4
XFILLER_0_76_607 VGND VGND VPWR VPWR sky130_fd_sc_hd__fill_1
XFILLER_0_48_309 VGND VGND VPWR VPWR sky130_fd_sc_hd__fill_1
XFILLER_0_119_709 VPWR VGND VPWR VGND sky130_ef_sc_hd__decap_12
XFILLER_0_69_681 VGND VGND VPWR VPWR sky130_fd_sc_hd__fill_2
XFILLER_0_29_501 VGND VGND VPWR VPWR sky130_fd_sc_hd__decap_3
XFILLER_0_56_331 VGND VGND VPWR VPWR sky130_fd_sc_hd__decap_4
X_5770_ _2772_ _2774_ _2736_ _2776_ VGND VGND VPWR VPWR _2785_ sky130_fd_sc_hd__o211a_1
XFILLER_0_8_417 VGND VGND VPWR VPWR sky130_fd_sc_hd__decap_3
XFILLER_0_29_556 VGND VGND VPWR VPWR sky130_fd_sc_hd__decap_4
X_4721_ _1738_ _1736_ _1737_ VGND VGND VPWR VPWR _1759_ sky130_fd_sc_hd__nand3_1
XTAP_1390 VGND VPWR sky130_fd_sc_hd__tapvpwrvgnd_1
XFILLER_0_84_673 VGND VGND VPWR VPWR sky130_fd_sc_hd__decap_4
XFILLER_0_56_375 VGND VGND VPWR VPWR sky130_fd_sc_hd__decap_6
X_4652_ _1636_ VGND VGND VPWR VPWR _1690_ sky130_fd_sc_hd__inv_2
XFILLER_0_83_161 VGND VGND VPWR VPWR sky130_fd_sc_hd__fill_1
X_7440_ _4151_ VGND VGND VPWR VPWR _0446_ sky130_fd_sc_hd__inv_2
XFILLER_0_3_111 VGND VGND VPWR VPWR sky130_fd_sc_hd__fill_1
X_4583_ _1623_ _1624_ VGND VGND VPWR VPWR _1625_ sky130_fd_sc_hd__xor2_1
X_7371_ _4144_ VGND VGND VPWR VPWR _0384_ sky130_fd_sc_hd__inv_2
XFILLER_0_4_645 VPWR VGND VPWR VGND sky130_ef_sc_hd__decap_12
X_6322_ _3318_ _3321_ VGND VGND VPWR VPWR _3322_ sky130_fd_sc_hd__nand2_1
XFILLER_0_24_283 VGND VGND VPWR VPWR sky130_fd_sc_hd__decap_3
X_6253_ _3248_ _3255_ _3256_ VGND VGND VPWR VPWR _3257_ sky130_fd_sc_hd__nand3b_1
XFILLER_0_110_642 VGND VGND VPWR VPWR sky130_fd_sc_hd__fill_2
XFILLER_0_110_675 VGND VGND VPWR VPWR sky130_fd_sc_hd__decap_4
X_5204_ _2200_ _2223_ _2224_ VGND VGND VPWR VPWR _2232_ sky130_fd_sc_hd__nand3_1
X_6184_ _3188_ _3189_ VGND VGND VPWR VPWR _0140_ sky130_fd_sc_hd__xor2_2
X_5135_ _2107_ _2105_ _2160_ _2162_ _2110_ VGND VGND VPWR VPWR _2164_ sky130_fd_sc_hd__o221a_1
XFILLER_0_35_3 VPWR VGND VPWR VGND sky130_ef_sc_hd__decap_12
X_5066_ _2060_ _2061_ sh3\[2\] VGND VGND VPWR VPWR _2095_ sky130_fd_sc_hd__o21ai_1
XFILLER_0_74_83 VGND VGND VPWR VPWR sky130_fd_sc_hd__fill_1
X_8825_ clknet_leaf_11_clk net32 _0576_ VGND VGND VPWR VPWR sh9\[5\] sky130_fd_sc_hd__dfrtp_4
XFILLER_0_94_404 VPWR VGND VPWR VGND sky130_ef_sc_hd__decap_12
X_5968_ _2974_ _2924_ _2975_ _2976_ VGND VGND VPWR VPWR _2977_ sky130_fd_sc_hd__a211oi_4
X_8756_ clknet_leaf_48_clk net168 _0507_ VGND VGND VPWR VPWR sh1\[0\] sky130_fd_sc_hd__dfrtp_4
X_4919_ _1833_ _1905_ _1906_ _1949_ VGND VGND VPWR VPWR _1953_ sky130_fd_sc_hd__o211ai_4
XFILLER_0_75_673 VPWR VGND VPWR VGND sky130_ef_sc_hd__decap_12
XFILLER_0_47_364 VGND VGND VPWR VPWR sky130_fd_sc_hd__fill_2
X_7707_ _0012_ net246 VGND VGND VPWR VPWR _0062_ sky130_fd_sc_hd__nor2_1
X_5899_ _2870_ _2907_ _2875_ _2871_ VGND VGND VPWR VPWR _2908_ sky130_fd_sc_hd__o211ai_1
XFILLER_0_90_610 VGND VGND VPWR VPWR sky130_fd_sc_hd__decap_8
XFILLER_0_74_161 VPWR VGND VPWR VGND sky130_ef_sc_hd__decap_12
X_8687_ clknet_leaf_53_clk _0152_ _0438_ VGND VGND VPWR VPWR bit_sum1\[8\] sky130_fd_sc_hd__dfrtp_1
X_7638_ _4122_ VGND VGND VPWR VPWR _0626_ sky130_fd_sc_hd__inv_2
XFILLER_0_35_559 VGND VGND VPWR VPWR sky130_fd_sc_hd__fill_1
X_7569_ _4164_ VGND VGND VPWR VPWR _0562_ sky130_fd_sc_hd__inv_2
XFILLER_0_62_389 VGND VGND VPWR VPWR sky130_fd_sc_hd__fill_1
XFILLER_0_31_721 VGND VGND VPWR VPWR sky130_fd_sc_hd__decap_6
XFILLER_0_30_253 VGND VGND VPWR VPWR sky130_fd_sc_hd__decap_8
XFILLER_0_100_141 VGND VGND VPWR VPWR sky130_fd_sc_hd__fill_1
XFILLER_0_97_297 VGND VGND VPWR VPWR sky130_fd_sc_hd__fill_1
XFILLER_0_65_150 VGND VGND VPWR VPWR sky130_fd_sc_hd__decap_4
XFILLER_0_81_687 VPWR VGND VPWR VGND sky130_ef_sc_hd__decap_12
XFILLER_0_80_153 VPWR VGND VPWR VGND sky130_ef_sc_hd__decap_12
XFILLER_0_79_39 VPWR VGND VPWR VGND sky130_ef_sc_hd__decap_12
XFILLER_0_1_615 VGND VGND VPWR VPWR sky130_fd_sc_hd__fill_1
XFILLER_0_0_125 VPWR VGND VPWR VGND sky130_ef_sc_hd__decap_12
XTAP_415 VGND VPWR sky130_fd_sc_hd__tapvpwrvgnd_1
XTAP_404 VGND VPWR sky130_fd_sc_hd__tapvpwrvgnd_1
XFILLER_0_0_169 VPWR VGND VPWR VGND sky130_ef_sc_hd__decap_12
XTAP_426 VGND VPWR sky130_fd_sc_hd__tapvpwrvgnd_1
XTAP_448 VGND VPWR sky130_fd_sc_hd__tapvpwrvgnd_1
XTAP_437 VGND VPWR sky130_fd_sc_hd__tapvpwrvgnd_1
XTAP_459 VGND VPWR sky130_fd_sc_hd__tapvpwrvgnd_1
XFILLER_0_28_65 VPWR VGND VPWR VGND sky130_ef_sc_hd__decap_12
XFILLER_0_89_721 VGND VGND VPWR VPWR sky130_fd_sc_hd__decap_6
X_6940_ sh4\[1\] sh5\[1\] VGND VGND VPWR VPWR _3927_ sky130_fd_sc_hd__nand2_1
XFILLER_0_88_231 VGND VGND VPWR VPWR sky130_fd_sc_hd__fill_1
XFILLER_0_44_53 VPWR VGND VPWR VGND sky130_ef_sc_hd__decap_12
XFILLER_0_88_286 VPWR VGND VPWR VGND sky130_ef_sc_hd__decap_12
XFILLER_0_76_415 VGND VGND VPWR VPWR sky130_fd_sc_hd__decap_4
X_6871_ _3752_ _3858_ net29 VGND VGND VPWR VPWR _3859_ sky130_fd_sc_hd__o21ai_2
X_5822_ _2784_ _2787_ _2788_ VGND VGND VPWR VPWR _2836_ sky130_fd_sc_hd__a21oi_1
X_8610_ clknet_leaf_57_clk net154 _0361_ VGND VGND VPWR VPWR s2\[2\] sky130_fd_sc_hd__dfrtp_1
X_8541_ clknet_leaf_38_clk net335 _0292_ VGND VGND VPWR VPWR carry2\[3\] sky130_fd_sc_hd__dfrtp_1
X_5753_ _2767_ _2768_ VGND VGND VPWR VPWR _2769_ sky130_fd_sc_hd__nand2_1
X_4704_ _1736_ _1740_ _1741_ VGND VGND VPWR VPWR _1742_ sky130_fd_sc_hd__nand3b_2
XFILLER_0_84_481 VGND VGND VPWR VPWR sky130_fd_sc_hd__fill_1
XFILLER_0_60_85 VGND VGND VPWR VPWR sky130_fd_sc_hd__decap_8
X_5684_ _2694_ _2697_ _2699_ _2700_ VGND VGND VPWR VPWR _2701_ sky130_fd_sc_hd__o2bb2ai_1
X_8472_ clknet_leaf_43_clk net78 _0223_ VGND VGND VPWR VPWR s0\[4\] sky130_fd_sc_hd__dfrtp_1
XFILLER_0_114_222 VGND VGND VPWR VPWR sky130_fd_sc_hd__fill_1
X_4635_ net441 _1673_ VGND VGND VPWR VPWR _0108_ sky130_fd_sc_hd__xor2_1
X_7423_ _4150_ VGND VGND VPWR VPWR _0430_ sky130_fd_sc_hd__inv_2
X_4566_ _1605_ _1608_ _1541_ VGND VGND VPWR VPWR _1609_ sky130_fd_sc_hd__a21oi_1
XFILLER_0_8_53 VPWR VGND VPWR VGND sky130_ef_sc_hd__decap_12
XFILLER_0_13_721 VGND VGND VPWR VPWR sky130_fd_sc_hd__decap_6
X_7354_ _4136_ VGND VGND VPWR VPWR _4143_ sky130_fd_sc_hd__buf_4
X_6305_ _3301_ _3304_ _3298_ VGND VGND VPWR VPWR _3305_ sky130_fd_sc_hd__o21ai_4
XFILLER_0_8_97 VPWR VGND VPWR VGND sky130_ef_sc_hd__decap_12
XFILLER_0_40_540 VGND VGND VPWR VPWR sky130_fd_sc_hd__decap_4
X_4497_ sh15\[5\] _1227_ _1299_ VGND VGND VPWR VPWR _1541_ sky130_fd_sc_hd__and3_2
X_7285_ _4135_ VGND VGND VPWR VPWR _0307_ sky130_fd_sc_hd__inv_2
XFILLER_0_12_286 VGND VGND VPWR VPWR sky130_fd_sc_hd__decap_6
XFILLER_0_40_595 VGND VGND VPWR VPWR sky130_fd_sc_hd__fill_1
X_6236_ _3232_ _3233_ VGND VGND VPWR VPWR _3241_ sky130_fd_sc_hd__nand2_1
X_6167_ _3170_ _3172_ _3162_ VGND VGND VPWR VPWR _3173_ sky130_fd_sc_hd__o21ai_2
XTAP_971 VGND VPWR sky130_fd_sc_hd__tapvpwrvgnd_1
XTAP_960 VGND VPWR sky130_fd_sc_hd__tapvpwrvgnd_1
XFILLER_0_85_93 VPWR VGND VPWR VGND sky130_ef_sc_hd__decap_12
XTAP_993 VGND VPWR sky130_fd_sc_hd__tapvpwrvgnd_1
XTAP_982 VGND VPWR sky130_fd_sc_hd__tapvpwrvgnd_1
X_5118_ _2090_ _2091_ _2086_ VGND VGND VPWR VPWR _2147_ sky130_fd_sc_hd__o21ai_2
X_6098_ _3091_ _3094_ _3104_ VGND VGND VPWR VPWR _3105_ sky130_fd_sc_hd__o21bai_4
XFILLER_0_79_242 VGND VGND VPWR VPWR sky130_fd_sc_hd__fill_1
XFILLER_0_79_220 VGND VGND VPWR VPWR sky130_fd_sc_hd__decap_4
X_5049_ _2057_ _2058_ _2056_ _2078_ VGND VGND VPWR VPWR _2079_ sky130_fd_sc_hd__a31o_1
X_8808_ clknet_leaf_3_clk net436 _0559_ VGND VGND VPWR VPWR sh7\[4\] sky130_fd_sc_hd__dfrtp_4
X_8739_ clknet_leaf_22_clk _0108_ _0490_ VGND VGND VPWR VPWR bit_sum7\[0\] sky130_fd_sc_hd__dfrtp_1
XFILLER_0_75_492 VGND VGND VPWR VPWR sky130_fd_sc_hd__fill_1
XFILLER_0_63_610 VGND VGND VPWR VPWR sky130_fd_sc_hd__decap_3
XFILLER_0_118_561 VGND VGND VPWR VPWR sky130_fd_sc_hd__fill_1
XFILLER_0_106_701 VPWR VGND VPWR VGND sky130_ef_sc_hd__decap_12
XFILLER_0_90_440 VPWR VGND VPWR VGND sky130_ef_sc_hd__decap_12
XFILLER_0_62_131 VGND VGND VPWR VPWR sky130_fd_sc_hd__decap_3
XFILLER_0_120_225 VGND VGND VPWR VPWR sky130_fd_sc_hd__fill_1
XFILLER_0_31_573 VGND VGND VPWR VPWR sky130_fd_sc_hd__decap_6
XFILLER_0_105_47 VGND VGND VPWR VPWR sky130_fd_sc_hd__fill_2
XFILLER_0_58_448 VPWR VGND VPWR VGND sky130_ef_sc_hd__decap_12
XFILLER_0_66_481 VPWR VGND VPWR VGND sky130_ef_sc_hd__decap_12
XFILLER_0_66_470 VGND VGND VPWR VPWR sky130_fd_sc_hd__decap_6
XFILLER_0_38_150 VPWR VGND VPWR VGND sky130_ef_sc_hd__decap_12
XFILLER_0_39_673 VPWR VGND VPWR VGND sky130_ef_sc_hd__decap_12
XFILLER_0_109_561 VPWR VGND VPWR VGND sky130_ef_sc_hd__decap_12
XFILLER_0_54_643 VGND VGND VPWR VPWR sky130_fd_sc_hd__fill_1
XFILLER_0_5_217 VGND VGND VPWR VPWR sky130_fd_sc_hd__decap_6
XFILLER_0_26_345 VGND VGND VPWR VPWR sky130_fd_sc_hd__decap_8
XFILLER_0_121_57 VPWR VGND VPWR VGND sky130_ef_sc_hd__decap_12
XFILLER_0_26_389 VPWR VGND VPWR VGND sky130_ef_sc_hd__decap_12
X_4420_ _1395_ _1377_ _1398_ VGND VGND VPWR VPWR _1466_ sky130_fd_sc_hd__o21a_1
XFILLER_0_1_401 VPWR VGND VPWR VGND sky130_ef_sc_hd__decap_12
XFILLER_0_111_236 VPWR VGND VPWR VGND sky130_ef_sc_hd__decap_12
XFILLER_0_111_225 VGND VGND VPWR VPWR sky130_fd_sc_hd__decap_6
XFILLER_0_22_540 VGND VGND VPWR VPWR sky130_fd_sc_hd__fill_1
X_4351_ _1374_ _1379_ _1375_ _1376_ VGND VGND VPWR VPWR _1398_ sky130_fd_sc_hd__o211ai_4
XFILLER_0_10_713 VPWR VGND VPWR VGND sky130_ef_sc_hd__decap_12
XFILLER_0_1_445 VGND VGND VPWR VPWR sky130_fd_sc_hd__decap_3
X_4282_ sh14\[5\] _1249_ _1328_ VGND VGND VPWR VPWR _1330_ sky130_fd_sc_hd__or3_1
X_7070_ _4015_ _4016_ _4052_ _4054_ VGND VGND VPWR VPWR _4055_ sky130_fd_sc_hd__o211a_1
XFILLER_0_39_75 VGND VGND VPWR VPWR sky130_fd_sc_hd__decap_4
X_6021_ _3020_ _3028_ _3021_ _3024_ VGND VGND VPWR VPWR _3029_ sky130_fd_sc_hd__o211ai_4
XTAP_256 VGND VPWR sky130_fd_sc_hd__tapvpwrvgnd_1
XTAP_278 VGND VPWR sky130_fd_sc_hd__tapvpwrvgnd_1
XTAP_267 VGND VPWR sky130_fd_sc_hd__tapvpwrvgnd_1
XTAP_289 VGND VPWR sky130_fd_sc_hd__tapvpwrvgnd_1
X_7972_ _0773_ _0819_ _0816_ _0813_ _0820_ VGND VGND VPWR VPWR _0821_ sky130_fd_sc_hd__o221ai_4
XFILLER_0_76_201 VGND VGND VPWR VPWR sky130_fd_sc_hd__fill_1
X_6923_ _3763_ _3764_ VGND VGND VPWR VPWR _3910_ sky130_fd_sc_hd__nor2_1
XFILLER_0_76_245 VGND VGND VPWR VPWR sky130_fd_sc_hd__decap_6
XFILLER_0_9_523 VPWR VGND VPWR VGND sky130_ef_sc_hd__decap_12
X_6854_ _3840_ _3841_ VGND VGND VPWR VPWR _3842_ sky130_fd_sc_hd__nand2_1
Xfanout38 sh5\[2\] VGND VGND VPWR VPWR net38 sky130_fd_sc_hd__clkbuf_4
X_6785_ _3708_ _3760_ _3745_ _3741_ _3773_ VGND VGND VPWR VPWR _3774_ sky130_fd_sc_hd__o221ai_4
X_5805_ _2818_ _2819_ _2768_ _2816_ VGND VGND VPWR VPWR _2820_ sky130_fd_sc_hd__o211ai_2
X_8524_ clknet_leaf_22_clk _0094_ _0275_ VGND VGND VPWR VPWR sum5\[14\] sky130_fd_sc_hd__dfrtp_1
XFILLER_0_17_334 VGND VGND VPWR VPWR sky130_fd_sc_hd__fill_2
X_5736_ _2749_ _2750_ _2743_ _2747_ VGND VGND VPWR VPWR _2752_ sky130_fd_sc_hd__o211ai_1
XFILLER_0_72_473 VGND VGND VPWR VPWR sky130_fd_sc_hd__decap_3
X_8455_ clknet_leaf_31_clk net249 _0206_ VGND VGND VPWR VPWR carry3\[10\] sky130_fd_sc_hd__dfrtp_1
X_5667_ _2484_ _2473_ _2624_ VGND VGND VPWR VPWR _2684_ sky130_fd_sc_hd__a21oi_1
XFILLER_0_32_315 VGND VGND VPWR VPWR sky130_fd_sc_hd__fill_1
X_4618_ _1636_ _1637_ VGND VGND VPWR VPWR _1657_ sky130_fd_sc_hd__nor2_1
X_7406_ _4148_ VGND VGND VPWR VPWR _0415_ sky130_fd_sc_hd__inv_2
XFILLER_0_44_197 VPWR VGND VPWR VGND sky130_ef_sc_hd__decap_12
X_8386_ sum5\[14\] s7\[14\] _1209_ VGND VGND VPWR VPWR _1218_ sky130_fd_sc_hd__a21bo_1
X_5598_ _2487_ _2490_ _2493_ VGND VGND VPWR VPWR _2616_ sky130_fd_sc_hd__o21ai_1
X_4549_ _1592_ VGND VGND VPWR VPWR _0132_ sky130_fd_sc_hd__clkbuf_1
X_7337_ _4141_ VGND VGND VPWR VPWR _0353_ sky130_fd_sc_hd__inv_2
X_7268_ _4134_ VGND VGND VPWR VPWR _0291_ sky130_fd_sc_hd__inv_2
X_6219_ _2926_ _3159_ _3221_ _3223_ _2986_ VGND VGND VPWR VPWR _3224_ sky130_fd_sc_hd__o2111ai_4
X_7199_ _4125_ VGND VGND VPWR VPWR _4128_ sky130_fd_sc_hd__clkbuf_8
XTAP_790 VGND VPWR sky130_fd_sc_hd__tapvpwrvgnd_1
XFILLER_0_68_713 VGND VGND VPWR VPWR sky130_fd_sc_hd__fill_2
XFILLER_0_67_223 VGND VGND VPWR VPWR sky130_fd_sc_hd__fill_1
XFILLER_0_95_598 VGND VGND VPWR VPWR sky130_fd_sc_hd__decap_3
XFILLER_0_83_727 VGND VGND VPWR VPWR sky130_fd_sc_hd__fill_1
XFILLER_0_48_481 VPWR VGND VPWR VGND sky130_ef_sc_hd__decap_12
XFILLER_0_2_209 VPWR VGND VPWR VGND sky130_ef_sc_hd__decap_12
XFILLER_0_23_337 VPWR VGND VPWR VGND sky130_ef_sc_hd__decap_12
XFILLER_0_35_197 VGND VGND VPWR VPWR sky130_fd_sc_hd__decap_8
XFILLER_0_121_523 VGND VGND VPWR VPWR sky130_fd_sc_hd__decap_4
XFILLER_0_50_167 VGND VGND VPWR VPWR sky130_fd_sc_hd__decap_4
XFILLER_0_76_29 VPWR VGND VPWR VGND sky130_ef_sc_hd__decap_12
XFILLER_0_116_79 VGND VGND VPWR VPWR sky130_fd_sc_hd__decap_4
XFILLER_0_86_587 VGND VGND VPWR VPWR sky130_fd_sc_hd__fill_1
X_6570_ _3286_ _3377_ VGND VGND VPWR VPWR _3566_ sky130_fd_sc_hd__nand2_1
XFILLER_0_6_559 VGND VGND VPWR VPWR sky130_fd_sc_hd__fill_2
XFILLER_0_14_304 VGND VGND VPWR VPWR sky130_fd_sc_hd__decap_4
X_5521_ _2533_ _2537_ VGND VGND VPWR VPWR _2540_ sky130_fd_sc_hd__xor2_1
XFILLER_0_26_153 VPWR VGND VPWR VGND sky130_ef_sc_hd__decap_12
XFILLER_0_81_281 VGND VGND VPWR VPWR sky130_fd_sc_hd__fill_1
X_8240_ _1080_ _1075_ _1079_ VGND VGND VPWR VPWR _1085_ sky130_fd_sc_hd__and3_1
XFILLER_0_14_337 VPWR VGND VPWR VGND sky130_ef_sc_hd__decap_12
X_5452_ sh10\[0\] net30 _2471_ VGND VGND VPWR VPWR _2472_ sky130_fd_sc_hd__a21o_1
XFILLER_0_41_167 VGND VGND VPWR VPWR sky130_fd_sc_hd__fill_1
XFILLER_0_42_668 VPWR VGND VPWR VGND sky130_ef_sc_hd__decap_12
XFILLER_0_112_545 VPWR VGND VPWR VGND sky130_ef_sc_hd__decap_12
X_4403_ _1447_ _1448_ VGND VGND VPWR VPWR _1449_ sky130_fd_sc_hd__nor2_1
X_8171_ _0939_ _0940_ _1016_ _0937_ _0944_ VGND VGND VPWR VPWR _1017_ sky130_fd_sc_hd__a32o_1
XFILLER_0_10_521 VGND VGND VPWR VPWR sky130_fd_sc_hd__fill_1
X_5383_ _2346_ _2342_ _2369_ VGND VGND VPWR VPWR _2408_ sky130_fd_sc_hd__a21o_1
X_4334_ sh5\[5\] net34 net32 VGND VGND VPWR VPWR _1381_ sky130_fd_sc_hd__o21a_1
X_7122_ _4099_ _4102_ _4092_ _4101_ VGND VGND VPWR VPWR _4105_ sky130_fd_sc_hd__o22a_1
XFILLER_0_10_587 VGND VGND VPWR VPWR sky130_fd_sc_hd__fill_1
X_7053_ _4024_ _4027_ sh14\[1\] VGND VGND VPWR VPWR _4038_ sky130_fd_sc_hd__o21bai_1
X_6004_ _3008_ _3009_ _3011_ VGND VGND VPWR VPWR _3012_ sky130_fd_sc_hd__o21a_1
X_4265_ _1227_ sh12\[5\] VGND VGND VPWR VPWR _1313_ sky130_fd_sc_hd__nor2_2
XFILLER_0_66_95 VPWR VGND VPWR VGND sky130_ef_sc_hd__decap_12
XFILLER_0_82_83 VGND VGND VPWR VPWR sky130_fd_sc_hd__fill_1
XTAP_1208 VGND VPWR sky130_fd_sc_hd__tapvpwrvgnd_1
XTAP_1219 VGND VPWR sky130_fd_sc_hd__tapvpwrvgnd_1
X_7955_ _0802_ _0787_ _0793_ VGND VGND VPWR VPWR _0804_ sky130_fd_sc_hd__and3b_1
XFILLER_0_49_223 VGND VGND VPWR VPWR sky130_fd_sc_hd__fill_1
XFILLER_0_119_100 VPWR VGND VPWR VGND sky130_ef_sc_hd__decap_12
XFILLER_0_77_576 VGND VGND VPWR VPWR sky130_fd_sc_hd__fill_2
X_7886_ _0730_ VGND VGND VPWR VPWR _0736_ sky130_fd_sc_hd__clkbuf_4
X_6906_ _3817_ _3893_ _3815_ VGND VGND VPWR VPWR _3894_ sky130_fd_sc_hd__o21ai_2
XFILLER_0_65_727 VGND VGND VPWR VPWR sky130_fd_sc_hd__fill_1
XFILLER_0_64_204 VGND VGND VPWR VPWR sky130_fd_sc_hd__fill_1
X_6837_ _3822_ _3823_ _3824_ _3825_ VGND VGND VPWR VPWR _3826_ sky130_fd_sc_hd__a31o_1
X_8507_ clknet_leaf_24_clk _0167_ _0258_ VGND VGND VPWR VPWR final_sum\[13\] sky130_fd_sc_hd__dfrtp_1
X_6768_ _3712_ _3704_ VGND VGND VPWR VPWR _3757_ sky130_fd_sc_hd__nand2_1
X_6699_ _3677_ _3641_ _3681_ VGND VGND VPWR VPWR _3692_ sky130_fd_sc_hd__a21o_1
XFILLER_0_72_292 VGND VGND VPWR VPWR sky130_fd_sc_hd__decap_4
X_5719_ _2484_ _2491_ VGND VGND VPWR VPWR _2735_ sky130_fd_sc_hd__nand2_1
XFILLER_0_115_383 VGND VGND VPWR VPWR sky130_fd_sc_hd__fill_1
X_8438_ clknet_leaf_39_clk _0034_ _0189_ VGND VGND VPWR VPWR carry4\[4\] sky130_fd_sc_hd__dfrtp_1
XFILLER_0_32_156 VGND VGND VPWR VPWR sky130_fd_sc_hd__fill_2
XFILLER_0_33_668 VGND VGND VPWR VPWR sky130_fd_sc_hd__decap_4
X_8369_ _1199_ _1200_ _1201_ VGND VGND VPWR VPWR _1203_ sky130_fd_sc_hd__a21oi_1
Xhold271 _0037_ VGND VGND VPWR VPWR net313 sky130_fd_sc_hd__dlygate4sd3_1
Xhold260 sum5\[6\] VGND VGND VPWR VPWR net302 sky130_fd_sc_hd__dlygate4sd3_1
Xhold282 _4184_ VGND VGND VPWR VPWR net324 sky130_fd_sc_hd__dlygate4sd3_1
Xhold293 _0013_ VGND VGND VPWR VPWR net335 sky130_fd_sc_hd__dlygate4sd3_1
XTAP_1742 VGND VPWR sky130_fd_sc_hd__tapvpwrvgnd_1
XTAP_1720 VGND VPWR sky130_fd_sc_hd__tapvpwrvgnd_1
XTAP_1731 VGND VPWR sky130_fd_sc_hd__tapvpwrvgnd_1
XTAP_1775 VGND VPWR sky130_fd_sc_hd__tapvpwrvgnd_1
XTAP_1764 VGND VPWR sky130_fd_sc_hd__tapvpwrvgnd_1
XTAP_1753 VGND VPWR sky130_fd_sc_hd__tapvpwrvgnd_1
XFILLER_0_83_502 VGND VGND VPWR VPWR sky130_fd_sc_hd__fill_2
XFILLER_0_28_418 VGND VGND VPWR VPWR sky130_fd_sc_hd__fill_2
XTAP_1797 VGND VPWR sky130_fd_sc_hd__tapvpwrvgnd_1
XTAP_1786 VGND VPWR sky130_fd_sc_hd__tapvpwrvgnd_1
XFILLER_0_83_557 VGND VGND VPWR VPWR sky130_fd_sc_hd__decap_3
XFILLER_0_83_546 VGND VGND VPWR VPWR sky130_fd_sc_hd__decap_8
XFILLER_0_71_708 VPWR VGND VPWR VGND sky130_ef_sc_hd__decap_12
XFILLER_0_55_237 VPWR VGND VPWR VGND sky130_ef_sc_hd__decap_12
XFILLER_0_102_15 VGND VGND VPWR VPWR sky130_fd_sc_hd__decap_8
XFILLER_0_70_218 VGND VGND VPWR VPWR sky130_fd_sc_hd__fill_2
XFILLER_0_63_281 VPWR VGND VPWR VGND sky130_ef_sc_hd__decap_12
XFILLER_0_11_57 VPWR VGND VPWR VGND sky130_ef_sc_hd__decap_12
XFILLER_0_106_361 VGND VGND VPWR VPWR sky130_fd_sc_hd__decap_3
XFILLER_0_23_145 VGND VGND VPWR VPWR sky130_fd_sc_hd__decap_8
XFILLER_0_87_39 VPWR VGND VPWR VGND sky130_ef_sc_hd__decap_12
XFILLER_0_23_167 VGND VGND VPWR VPWR sky130_fd_sc_hd__fill_1
XFILLER_0_121_397 VGND VGND VPWR VPWR sky130_fd_sc_hd__fill_1
Xinput6 x[4] VGND VGND VPWR VPWR net6 sky130_fd_sc_hd__clkbuf_1
XFILLER_0_59_532 VGND VGND VPWR VPWR sky130_fd_sc_hd__decap_8
X_4952_ _1984_ _1980_ _1983_ VGND VGND VPWR VPWR _1986_ sky130_fd_sc_hd__nand3_2
X_7740_ _0644_ _0645_ net258 VGND VGND VPWR VPWR _0646_ sky130_fd_sc_hd__o21ai_1
X_4883_ _1652_ _1637_ VGND VGND VPWR VPWR _1918_ sky130_fd_sc_hd__nor2_1
X_7671_ _4194_ _4195_ net280 VGND VGND VPWR VPWR _4196_ sky130_fd_sc_hd__o21ai_1
XFILLER_0_117_615 VGND VGND VPWR VPWR sky130_fd_sc_hd__fill_1
X_6622_ _3602_ _3603_ _3561_ _3605_ VGND VGND VPWR VPWR _3617_ sky130_fd_sc_hd__o211ai_4
XFILLER_0_52_97 VPWR VGND VPWR VGND sky130_ef_sc_hd__decap_12
XFILLER_0_46_226 VGND VGND VPWR VPWR sky130_fd_sc_hd__decap_3
XFILLER_0_117_648 VGND VGND VPWR VPWR sky130_fd_sc_hd__decap_6
XFILLER_0_116_147 VGND VGND VPWR VPWR sky130_fd_sc_hd__fill_1
X_6553_ _3499_ _3502_ VGND VGND VPWR VPWR _3549_ sky130_fd_sc_hd__nand2_1
XFILLER_0_15_646 VGND VGND VPWR VPWR sky130_fd_sc_hd__fill_2
X_6484_ _3477_ _3480_ _3413_ VGND VGND VPWR VPWR _3482_ sky130_fd_sc_hd__nand3_2
X_5504_ net36 sh8\[0\] VGND VGND VPWR VPWR _2523_ sky130_fd_sc_hd__or2_1
XFILLER_0_42_454 VGND VGND VPWR VPWR sky130_fd_sc_hd__fill_1
X_8223_ _1052_ _1053_ _1055_ VGND VGND VPWR VPWR _1068_ sky130_fd_sc_hd__o21ai_1
X_5435_ _2440_ _2444_ _2456_ _2437_ VGND VGND VPWR VPWR _2458_ sky130_fd_sc_hd__a22o_1
XFILLER_0_65_3 VPWR VGND VPWR VGND sky130_ef_sc_hd__decap_12
X_8154_ _0725_ _0798_ _0765_ _0999_ VGND VGND VPWR VPWR _1000_ sky130_fd_sc_hd__or4_2
X_5366_ _2386_ _2390_ VGND VGND VPWR VPWR _2391_ sky130_fd_sc_hd__nand2_1
X_4317_ _1231_ sh2\[5\] sh3\[5\] VGND VGND VPWR VPWR _1364_ sky130_fd_sc_hd__o21a_1
X_8085_ _0748_ _0826_ _0931_ VGND VGND VPWR VPWR _0932_ sky130_fd_sc_hd__a21oi_1
X_7105_ _4087_ _4088_ _4060_ VGND VGND VPWR VPWR _4089_ sky130_fd_sc_hd__o21a_1
X_5297_ _2319_ _2321_ _2322_ _2055_ VGND VGND VPWR VPWR _2323_ sky130_fd_sc_hd__o22ai_2
X_4248_ _1290_ _1293_ _1294_ _1295_ VGND VGND VPWR VPWR _1296_ sky130_fd_sc_hd__o211ai_4
X_7036_ _4017_ _4018_ _3973_ _4020_ VGND VGND VPWR VPWR _4021_ sky130_fd_sc_hd__o211a_1
XFILLER_0_69_329 VGND VGND VPWR VPWR sky130_fd_sc_hd__decap_6
XTAP_1038 VGND VPWR sky130_fd_sc_hd__tapvpwrvgnd_1
XTAP_1027 VGND VPWR sky130_fd_sc_hd__tapvpwrvgnd_1
XTAP_1016 VGND VPWR sky130_fd_sc_hd__tapvpwrvgnd_1
XTAP_1005 VGND VPWR sky130_fd_sc_hd__tapvpwrvgnd_1
X_7938_ _0761_ _0784_ _0786_ VGND VGND VPWR VPWR _0787_ sky130_fd_sc_hd__nand3_2
XTAP_1049 VGND VPWR sky130_fd_sc_hd__tapvpwrvgnd_1
XFILLER_0_65_535 VPWR VGND VPWR VGND sky130_ef_sc_hd__decap_12
X_7869_ _0720_ VGND VGND VPWR VPWR _0023_ sky130_fd_sc_hd__clkbuf_1
XFILLER_0_9_161 VGND VGND VPWR VPWR sky130_fd_sc_hd__decap_6
Xclkbuf_3_3__f_clk clknet_0_clk VGND VGND VPWR VPWR clknet_3_3__leaf_clk sky130_fd_sc_hd__clkbuf_16
XFILLER_0_92_365 VGND VGND VPWR VPWR sky130_fd_sc_hd__fill_2
XFILLER_0_80_516 VPWR VGND VPWR VGND sky130_ef_sc_hd__decap_12
XFILLER_0_107_169 VGND VGND VPWR VPWR sky130_fd_sc_hd__fill_1
XFILLER_0_80_538 VGND VGND VPWR VPWR sky130_fd_sc_hd__fill_2
XFILLER_0_33_410 VGND VGND VPWR VPWR sky130_fd_sc_hd__fill_1
XFILLER_0_45_281 VGND VGND VPWR VPWR sky130_fd_sc_hd__decap_8
XFILLER_0_122_139 VGND VGND VPWR VPWR sky130_fd_sc_hd__fill_1
XFILLER_0_60_251 VGND VGND VPWR VPWR sky130_fd_sc_hd__fill_1
XFILLER_0_20_137 VGND VGND VPWR VPWR sky130_fd_sc_hd__decap_3
XTAP_1550 VGND VPWR sky130_fd_sc_hd__tapvpwrvgnd_1
XFILLER_0_29_727 VGND VGND VPWR VPWR sky130_fd_sc_hd__fill_1
XTAP_1594 VGND VPWR sky130_fd_sc_hd__tapvpwrvgnd_1
XTAP_1583 VGND VPWR sky130_fd_sc_hd__tapvpwrvgnd_1
XTAP_1572 VGND VPWR sky130_fd_sc_hd__tapvpwrvgnd_1
XTAP_1561 VGND VPWR sky130_fd_sc_hd__tapvpwrvgnd_1
XFILLER_0_83_310 VGND VGND VPWR VPWR sky130_fd_sc_hd__decap_8
XPHY_90 VGND VGND VPWR VPWR sky130_fd_sc_hd__decap_3
XFILLER_0_71_516 VGND VGND VPWR VPWR sky130_fd_sc_hd__fill_2
XFILLER_0_56_579 VGND VGND VPWR VPWR sky130_fd_sc_hd__fill_1
XFILLER_0_24_421 VGND VGND VPWR VPWR sky130_fd_sc_hd__decap_6
XFILLER_0_98_27 VGND VGND VPWR VPWR sky130_fd_sc_hd__fill_1
XFILLER_0_3_337 VPWR VGND VPWR VGND sky130_ef_sc_hd__decap_12
XFILLER_0_51_273 VGND VGND VPWR VPWR sky130_fd_sc_hd__decap_6
XFILLER_0_121_161 VGND VGND VPWR VPWR sky130_fd_sc_hd__decap_6
X_5220_ _2247_ VGND VGND VPWR VPWR _0156_ sky130_fd_sc_hd__clkbuf_1
X_5151_ _2176_ _2177_ _2179_ VGND VGND VPWR VPWR _2180_ sky130_fd_sc_hd__a21o_1
X_5082_ _2109_ _2106_ _2110_ VGND VGND VPWR VPWR _2111_ sky130_fd_sc_hd__and3_1
XFILLER_0_47_42 VPWR VGND VPWR VGND sky130_ef_sc_hd__decap_12
X_8841_ clknet_leaf_11_clk net219 _0592_ VGND VGND VPWR VPWR sh11\[5\] sky130_fd_sc_hd__dfrtp_2
XFILLER_0_78_137 VGND VGND VPWR VPWR sky130_fd_sc_hd__decap_3
X_8772_ clknet_leaf_47_clk net325 _0523_ VGND VGND VPWR VPWR sh3\[0\] sky130_fd_sc_hd__dfrtp_1
XFILLER_0_2_77 VGND VGND VPWR VPWR sky130_fd_sc_hd__decap_6
X_5984_ _2876_ _2877_ VGND VGND VPWR VPWR _2993_ sky130_fd_sc_hd__or2_1
X_7723_ net253 _0633_ VGND VGND VPWR VPWR _0060_ sky130_fd_sc_hd__xnor2_1
X_4935_ _1956_ _1958_ _1960_ VGND VGND VPWR VPWR _1969_ sky130_fd_sc_hd__a21o_1
XFILLER_0_86_192 VGND VGND VPWR VPWR sky130_fd_sc_hd__fill_1
X_4866_ _1900_ _1901_ sh15\[7\] VGND VGND VPWR VPWR _1902_ sky130_fd_sc_hd__nand3_1
X_7654_ sum3\[8\] carry3\[7\] VGND VGND VPWR VPWR _4182_ sky130_fd_sc_hd__and2_1
X_4797_ _1832_ _1833_ VGND VGND VPWR VPWR _1834_ sky130_fd_sc_hd__and2_1
X_7585_ _4165_ VGND VGND VPWR VPWR _0577_ sky130_fd_sc_hd__inv_2
X_6605_ _3594_ _3593_ _3482_ _3543_ _3544_ VGND VGND VPWR VPWR _3600_ sky130_fd_sc_hd__o221ai_1
XFILLER_0_7_665 VGND VGND VPWR VPWR sky130_fd_sc_hd__decap_6
XFILLER_0_6_153 VPWR VGND VPWR VGND sky130_ef_sc_hd__decap_12
XFILLER_0_15_410 VPWR VGND VPWR VGND sky130_ef_sc_hd__decap_12
XFILLER_0_27_281 VGND VGND VPWR VPWR sky130_fd_sc_hd__decap_8
XFILLER_0_103_80 VGND VGND VPWR VPWR sky130_fd_sc_hd__decap_6
X_6536_ net27 VGND VGND VPWR VPWR _3533_ sky130_fd_sc_hd__inv_2
XFILLER_0_104_139 VGND VGND VPWR VPWR sky130_fd_sc_hd__fill_1
XFILLER_0_6_197 VPWR VGND VPWR VGND sky130_ef_sc_hd__decap_12
XFILLER_0_15_465 VGND VGND VPWR VPWR sky130_fd_sc_hd__fill_1
XFILLER_0_30_402 VGND VGND VPWR VPWR sky130_fd_sc_hd__decap_8
XFILLER_0_42_251 VGND VGND VPWR VPWR sky130_fd_sc_hd__fill_1
XFILLER_0_113_673 VPWR VGND VPWR VGND sky130_ef_sc_hd__decap_12
XFILLER_0_88_82 VGND VGND VPWR VPWR sky130_fd_sc_hd__fill_2
X_6467_ _3417_ _3419_ _3456_ _3464_ VGND VGND VPWR VPWR _3465_ sky130_fd_sc_hd__o211ai_2
XFILLER_0_42_284 VPWR VGND VPWR VGND sky130_ef_sc_hd__decap_12
XFILLER_0_88_93 VGND VGND VPWR VPWR sky130_fd_sc_hd__fill_1
X_6398_ _3350_ _3347_ _3341_ VGND VGND VPWR VPWR _3397_ sky130_fd_sc_hd__a21o_1
X_8206_ _1020_ _1019_ _1015_ VGND VGND VPWR VPWR _1051_ sky130_fd_sc_hd__a21oi_2
XFILLER_0_30_468 VGND VGND VPWR VPWR sky130_fd_sc_hd__decap_8
X_5418_ _2394_ _2400_ _2441_ _2438_ _2433_ VGND VGND VPWR VPWR _2442_ sky130_fd_sc_hd__o2111ai_4
X_5349_ _2106_ _2189_ sh14\[2\] VGND VGND VPWR VPWR _2374_ sky130_fd_sc_hd__o21ai_4
X_8137_ _0982_ _0983_ _0976_ _0980_ VGND VGND VPWR VPWR _0984_ sky130_fd_sc_hd__o211a_1
X_8068_ _0851_ _0846_ _0849_ VGND VGND VPWR VPWR _0916_ sky130_fd_sc_hd__and3_1
X_7019_ _3930_ _4004_ _3994_ _3999_ VGND VGND VPWR VPWR _4005_ sky130_fd_sc_hd__o211ai_1
XFILLER_0_97_446 VGND VGND VPWR VPWR sky130_fd_sc_hd__fill_2
XFILLER_0_69_159 VGND VGND VPWR VPWR sky130_fd_sc_hd__decap_8
XFILLER_0_108_401 VGND VGND VPWR VPWR sky130_fd_sc_hd__fill_1
XFILLER_0_93_663 VGND VGND VPWR VPWR sky130_fd_sc_hd__decap_8
XFILLER_0_53_505 VGND VGND VPWR VPWR sky130_fd_sc_hd__decap_4
Xclkbuf_leaf_50_clk clknet_3_4__leaf_clk VGND VGND VPWR VPWR clknet_leaf_50_clk sky130_fd_sc_hd__clkbuf_16
XFILLER_0_21_402 VGND VGND VPWR VPWR sky130_fd_sc_hd__decap_4
XFILLER_0_110_109 VPWR VGND VPWR VGND sky130_ef_sc_hd__decap_12
XFILLER_0_104_673 VPWR VGND VPWR VGND sky130_ef_sc_hd__decap_12
XTAP_619 VGND VPWR sky130_fd_sc_hd__tapvpwrvgnd_1
XTAP_608 VGND VPWR sky130_fd_sc_hd__tapvpwrvgnd_1
XFILLER_0_84_29 VPWR VGND VPWR VGND sky130_ef_sc_hd__decap_12
XFILLER_0_108_36 VGND VGND VPWR VPWR sky130_fd_sc_hd__fill_2
XFILLER_0_69_693 VGND VGND VPWR VPWR sky130_fd_sc_hd__fill_1
X_4720_ _1671_ _1672_ sh15\[7\] VGND VGND VPWR VPWR _1758_ sky130_fd_sc_hd__nand3b_1
XTAP_1391 VGND VPWR sky130_fd_sc_hd__tapvpwrvgnd_1
XTAP_1380 VGND VPWR sky130_fd_sc_hd__tapvpwrvgnd_1
XFILLER_0_56_365 VGND VGND VPWR VPWR sky130_fd_sc_hd__fill_2
XFILLER_0_33_99 VPWR VGND VPWR VGND sky130_ef_sc_hd__decap_12
Xclkbuf_leaf_41_clk clknet_3_5__leaf_clk VGND VGND VPWR VPWR clknet_leaf_41_clk sky130_fd_sc_hd__clkbuf_16
X_4651_ _1681_ _1684_ _1686_ _1688_ VGND VGND VPWR VPWR _1689_ sky130_fd_sc_hd__o211ai_4
XFILLER_0_84_685 VPWR VGND VPWR VGND sky130_ef_sc_hd__decap_12
XFILLER_0_114_404 VPWR VGND VPWR VGND sky130_ef_sc_hd__decap_12
X_4582_ _1606_ _1607_ _1614_ VGND VGND VPWR VPWR _1624_ sky130_fd_sc_hd__o21a_1
XFILLER_0_114_459 VPWR VGND VPWR VGND sky130_ef_sc_hd__decap_12
XFILLER_0_114_448 VGND VGND VPWR VPWR sky130_fd_sc_hd__fill_2
XFILLER_0_114_437 VGND VGND VPWR VPWR sky130_fd_sc_hd__decap_4
X_7370_ _4144_ VGND VGND VPWR VPWR _0383_ sky130_fd_sc_hd__inv_2
XFILLER_0_4_657 VPWR VGND VPWR VGND sky130_ef_sc_hd__decap_12
X_6321_ _3316_ _3319_ _3320_ VGND VGND VPWR VPWR _3321_ sky130_fd_sc_hd__a21o_1
XFILLER_0_3_167 VGND VGND VPWR VPWR sky130_fd_sc_hd__fill_1
XFILLER_0_40_733 VGND VGND VPWR VPWR sky130_fd_sc_hd__fill_2
X_6252_ _2923_ _3033_ _3245_ VGND VGND VPWR VPWR _3256_ sky130_fd_sc_hd__a21oi_2
XFILLER_0_110_632 VGND VGND VPWR VPWR sky130_fd_sc_hd__fill_1
X_6183_ _3123_ _3129_ _3069_ _3133_ VGND VGND VPWR VPWR _3189_ sky130_fd_sc_hd__o2bb2a_1
XFILLER_0_58_63 VGND VGND VPWR VPWR sky130_fd_sc_hd__decap_4
X_5203_ _2173_ _2165_ _2154_ VGND VGND VPWR VPWR _2231_ sky130_fd_sc_hd__a21oi_2
X_5134_ _2110_ _2159_ _2160_ _2162_ VGND VGND VPWR VPWR _2163_ sky130_fd_sc_hd__a211oi_4
X_5065_ _2052_ VGND VGND VPWR VPWR _2094_ sky130_fd_sc_hd__inv_2
XFILLER_0_28_3 VPWR VGND VPWR VGND sky130_ef_sc_hd__decap_12
X_8824_ clknet_leaf_11_clk net157 _0575_ VGND VGND VPWR VPWR sh9\[4\] sky130_fd_sc_hd__dfrtp_4
XFILLER_0_94_416 VGND VGND VPWR VPWR sky130_fd_sc_hd__decap_4
XFILLER_0_66_107 VGND VGND VPWR VPWR sky130_fd_sc_hd__fill_2
X_8755_ clknet_leaf_7_clk net9 _0506_ VGND VGND VPWR VPWR sh0\[7\] sky130_fd_sc_hd__dfrtp_4
X_5967_ _2906_ net28 VGND VGND VPWR VPWR _2976_ sky130_fd_sc_hd__and2_2
XFILLER_0_90_72 VGND VGND VPWR VPWR sky130_fd_sc_hd__decap_6
X_4918_ _1948_ _1950_ _1952_ VGND VGND VPWR VPWR _0185_ sky130_fd_sc_hd__a21o_1
XFILLER_0_75_652 VGND VGND VPWR VPWR sky130_fd_sc_hd__fill_1
Xclkbuf_leaf_32_clk clknet_3_1__leaf_clk VGND VGND VPWR VPWR clknet_leaf_32_clk sky130_fd_sc_hd__clkbuf_16
X_8686_ clknet_leaf_52_clk _0151_ _0437_ VGND VGND VPWR VPWR bit_sum1\[7\] sky130_fd_sc_hd__dfrtp_1
XFILLER_0_35_505 VPWR VGND VPWR VGND sky130_ef_sc_hd__decap_12
X_7706_ carry1\[1\] net245 VGND VGND VPWR VPWR _4217_ sky130_fd_sc_hd__nor2_1
X_5898_ sh10\[6\] _2906_ net28 VGND VGND VPWR VPWR _2907_ sky130_fd_sc_hd__o21ai_2
X_7637_ _4122_ VGND VGND VPWR VPWR _0625_ sky130_fd_sc_hd__inv_2
XFILLER_0_75_696 VGND VGND VPWR VPWR sky130_fd_sc_hd__fill_1
XFILLER_0_74_173 VPWR VGND VPWR VGND sky130_ef_sc_hd__decap_12
XFILLER_0_35_538 VGND VGND VPWR VPWR sky130_fd_sc_hd__decap_6
X_4849_ _1884_ _1850_ _1851_ VGND VGND VPWR VPWR _1885_ sky130_fd_sc_hd__a21oi_2
XFILLER_0_74_195 VGND VGND VPWR VPWR sky130_fd_sc_hd__fill_1
XFILLER_0_90_699 VGND VGND VPWR VPWR sky130_fd_sc_hd__fill_1
X_7568_ _4164_ VGND VGND VPWR VPWR _0561_ sky130_fd_sc_hd__inv_2
XFILLER_0_15_262 VPWR VGND VPWR VGND sky130_ef_sc_hd__decap_12
X_6519_ _3447_ _3450_ _3454_ VGND VGND VPWR VPWR _3516_ sky130_fd_sc_hd__o21ai_1
X_7499_ _4157_ VGND VGND VPWR VPWR _0499_ sky130_fd_sc_hd__inv_2
XFILLER_0_100_131 VGND VGND VPWR VPWR sky130_fd_sc_hd__fill_2
XFILLER_0_98_733 VGND VGND VPWR VPWR sky130_fd_sc_hd__fill_2
XFILLER_0_85_405 VGND VGND VPWR VPWR sky130_fd_sc_hd__decap_3
XFILLER_0_57_107 VGND VGND VPWR VPWR sky130_fd_sc_hd__fill_2
XFILLER_0_109_721 VGND VGND VPWR VPWR sky130_fd_sc_hd__decap_6
Xclkbuf_leaf_23_clk clknet_3_7__leaf_clk VGND VGND VPWR VPWR clknet_leaf_23_clk sky130_fd_sc_hd__clkbuf_16
XFILLER_0_38_365 VGND VGND VPWR VPWR sky130_fd_sc_hd__decap_6
XFILLER_0_80_121 VPWR VGND VPWR VGND sky130_ef_sc_hd__decap_12
XFILLER_0_19_590 VGND VGND VPWR VPWR sky130_fd_sc_hd__fill_1
XFILLER_0_81_699 VGND VGND VPWR VPWR sky130_fd_sc_hd__decap_8
XFILLER_0_80_165 VGND VGND VPWR VPWR sky130_fd_sc_hd__decap_6
XFILLER_0_22_733 VGND VGND VPWR VPWR sky130_fd_sc_hd__fill_2
XTAP_405 VGND VPWR sky130_fd_sc_hd__tapvpwrvgnd_1
XFILLER_0_0_137 VGND VGND VPWR VPWR sky130_fd_sc_hd__decap_3
XTAP_427 VGND VPWR sky130_fd_sc_hd__tapvpwrvgnd_1
XTAP_416 VGND VPWR sky130_fd_sc_hd__tapvpwrvgnd_1
XTAP_449 VGND VPWR sky130_fd_sc_hd__tapvpwrvgnd_1
XTAP_438 VGND VPWR sky130_fd_sc_hd__tapvpwrvgnd_1
XFILLER_0_119_57 VPWR VGND VPWR VGND sky130_ef_sc_hd__decap_12
XFILLER_0_28_77 VGND VGND VPWR VPWR sky130_fd_sc_hd__fill_1
X_6870_ sh9\[1\] VGND VGND VPWR VPWR _3858_ sky130_fd_sc_hd__clkbuf_4
XFILLER_0_44_65 VPWR VGND VPWR VGND sky130_ef_sc_hd__decap_12
XFILLER_0_88_298 VGND VGND VPWR VPWR sky130_fd_sc_hd__decap_3
XFILLER_0_9_727 VGND VGND VPWR VPWR sky130_fd_sc_hd__fill_1
X_5821_ _2796_ _2793_ _2831_ _2834_ VGND VGND VPWR VPWR _2835_ sky130_fd_sc_hd__a22oi_1
XFILLER_0_29_310 VGND VGND VPWR VPWR sky130_fd_sc_hd__fill_2
X_8540_ clknet_leaf_37_clk _0012_ _0291_ VGND VGND VPWR VPWR carry2\[2\] sky130_fd_sc_hd__dfrtp_1
XFILLER_0_8_215 VGND VGND VPWR VPWR sky130_fd_sc_hd__fill_1
X_5752_ _2761_ _2765_ _2766_ VGND VGND VPWR VPWR _2768_ sky130_fd_sc_hd__a21o_1
X_4703_ _1692_ _1689_ _1739_ VGND VGND VPWR VPWR _1741_ sky130_fd_sc_hd__a21o_1
Xclkbuf_leaf_14_clk clknet_3_6__leaf_clk VGND VGND VPWR VPWR clknet_leaf_14_clk sky130_fd_sc_hd__clkbuf_16
XFILLER_0_8_259 VPWR VGND VPWR VGND sky130_ef_sc_hd__decap_12
X_5683_ _2669_ _2671_ _2673_ VGND VGND VPWR VPWR _2700_ sky130_fd_sc_hd__a21oi_1
X_8471_ clknet_leaf_51_clk net91 _0222_ VGND VGND VPWR VPWR s0\[3\] sky130_fd_sc_hd__dfrtp_1
XFILLER_0_114_234 VPWR VGND VPWR VGND sky130_ef_sc_hd__decap_12
X_4634_ _1671_ _1672_ VGND VGND VPWR VPWR _1673_ sky130_fd_sc_hd__and2b_1
XFILLER_0_72_688 VPWR VGND VPWR VGND sky130_ef_sc_hd__decap_12
X_7422_ _4150_ VGND VGND VPWR VPWR _0429_ sky130_fd_sc_hd__inv_2
XFILLER_0_32_508 VPWR VGND VPWR VGND sky130_ef_sc_hd__decap_12
X_4565_ _1606_ _1607_ VGND VGND VPWR VPWR _1608_ sky130_fd_sc_hd__nand2_1
XFILLER_0_12_221 VGND VGND VPWR VPWR sky130_fd_sc_hd__fill_1
XFILLER_0_8_65 VPWR VGND VPWR VGND sky130_ef_sc_hd__decap_12
XFILLER_0_4_454 VGND VGND VPWR VPWR sky130_fd_sc_hd__decap_6
X_7353_ _4142_ VGND VGND VPWR VPWR _0368_ sky130_fd_sc_hd__inv_2
XFILLER_0_114_289 VGND VGND VPWR VPWR sky130_fd_sc_hd__decap_8
X_6304_ _3295_ _3297_ VGND VGND VPWR VPWR _3304_ sky130_fd_sc_hd__nor2_2
XFILLER_0_40_552 VGND VGND VPWR VPWR sky130_fd_sc_hd__decap_4
X_4496_ _1484_ _1518_ _1523_ VGND VGND VPWR VPWR _1540_ sky130_fd_sc_hd__a21oi_1
X_7284_ _4135_ VGND VGND VPWR VPWR _0306_ sky130_fd_sc_hd__inv_2
X_6235_ _3231_ _3235_ _3238_ _3239_ VGND VGND VPWR VPWR _3240_ sky130_fd_sc_hd__a22o_1
X_6166_ _3156_ _3153_ _3165_ VGND VGND VPWR VPWR _3172_ sky130_fd_sc_hd__a21oi_1
XFILLER_0_110_495 VGND VGND VPWR VPWR sky130_fd_sc_hd__fill_2
XTAP_961 VGND VPWR sky130_fd_sc_hd__tapvpwrvgnd_1
XTAP_950 VGND VPWR sky130_fd_sc_hd__tapvpwrvgnd_1
X_6097_ _3097_ _3100_ _3102_ _3103_ VGND VGND VPWR VPWR _3104_ sky130_fd_sc_hd__a22oi_2
XTAP_994 VGND VPWR sky130_fd_sc_hd__tapvpwrvgnd_1
XTAP_983 VGND VPWR sky130_fd_sc_hd__tapvpwrvgnd_1
XTAP_972 VGND VPWR sky130_fd_sc_hd__tapvpwrvgnd_1
X_5117_ _2137_ _2145_ VGND VGND VPWR VPWR _2146_ sky130_fd_sc_hd__nand2_1
X_5048_ _2065_ _2076_ VGND VGND VPWR VPWR _2078_ sky130_fd_sc_hd__nand2_1
XFILLER_0_67_405 VPWR VGND VPWR VGND sky130_ef_sc_hd__decap_12
XFILLER_0_79_287 VPWR VGND VPWR VGND sky130_ef_sc_hd__decap_12
X_8807_ clknet_leaf_5_clk net200 _0558_ VGND VGND VPWR VPWR sh7\[3\] sky130_fd_sc_hd__dfrtp_1
XFILLER_0_67_449 VGND VGND VPWR VPWR sky130_fd_sc_hd__fill_2
X_8738_ clknet_leaf_22_clk _0144_ _0489_ VGND VGND VPWR VPWR bit_sum6\[9\] sky130_fd_sc_hd__dfrtp_1
XFILLER_0_82_419 VGND VGND VPWR VPWR sky130_fd_sc_hd__fill_1
X_6999_ _3983_ _3984_ _3966_ VGND VGND VPWR VPWR _3985_ sky130_fd_sc_hd__nand3_2
XFILLER_0_75_460 VGND VGND VPWR VPWR sky130_fd_sc_hd__fill_1
XFILLER_0_118_584 VGND VGND VPWR VPWR sky130_fd_sc_hd__decap_4
XFILLER_0_118_573 VGND VGND VPWR VPWR sky130_fd_sc_hd__fill_1
XFILLER_0_106_713 VPWR VGND VPWR VGND sky130_ef_sc_hd__decap_12
XFILLER_0_62_110 VGND VGND VPWR VPWR sky130_fd_sc_hd__fill_2
X_8669_ clknet_leaf_36_clk _0107_ _0420_ VGND VGND VPWR VPWR bit_sum0\[0\] sky130_fd_sc_hd__dfrtp_1
XFILLER_0_105_223 VGND VGND VPWR VPWR sky130_fd_sc_hd__fill_1
XFILLER_0_90_452 VPWR VGND VPWR VGND sky130_ef_sc_hd__decap_12
XFILLER_0_7_281 VPWR VGND VPWR VGND sky130_ef_sc_hd__decap_12
XFILLER_0_7_270 VGND VGND VPWR VPWR sky130_fd_sc_hd__decap_4
XFILLER_0_98_530 VGND VGND VPWR VPWR sky130_fd_sc_hd__fill_2
XFILLER_0_85_235 VPWR VGND VPWR VGND sky130_ef_sc_hd__decap_12
XFILLER_0_39_630 VGND VGND VPWR VPWR sky130_fd_sc_hd__decap_6
XFILLER_0_85_279 VGND VGND VPWR VPWR sky130_fd_sc_hd__fill_1
XFILLER_0_54_622 VPWR VGND VPWR VGND sky130_ef_sc_hd__decap_12
XFILLER_0_39_685 VPWR VGND VPWR VGND sky130_ef_sc_hd__decap_12
XFILLER_0_109_573 VPWR VGND VPWR VGND sky130_ef_sc_hd__decap_12
XFILLER_0_66_493 VPWR VGND VPWR VGND sky130_ef_sc_hd__decap_12
XFILLER_0_38_195 VGND VGND VPWR VPWR sky130_fd_sc_hd__fill_1
XFILLER_0_121_69 VPWR VGND VPWR VGND sky130_ef_sc_hd__decap_12
XFILLER_0_54_699 VGND VGND VPWR VPWR sky130_fd_sc_hd__fill_1
XFILLER_0_30_78 VGND VGND VPWR VPWR sky130_fd_sc_hd__decap_6
XFILLER_0_41_327 VGND VGND VPWR VPWR sky130_fd_sc_hd__decap_4
X_4350_ _1305_ _1318_ VGND VGND VPWR VPWR _1397_ sky130_fd_sc_hd__nand2_1
XFILLER_0_1_413 VPWR VGND VPWR VGND sky130_ef_sc_hd__decap_12
XFILLER_0_111_248 VGND VGND VPWR VPWR sky130_fd_sc_hd__decap_6
XFILLER_0_10_725 VGND VGND VPWR VPWR sky130_fd_sc_hd__decap_8
XFILLER_0_22_585 VGND VGND VPWR VPWR sky130_fd_sc_hd__decap_3
X_4281_ _1249_ _1328_ sh14\[5\] VGND VGND VPWR VPWR _1329_ sky130_fd_sc_hd__o21ai_1
XFILLER_0_39_65 VGND VGND VPWR VPWR sky130_fd_sc_hd__decap_3
X_6020_ _3006_ _3026_ _3027_ VGND VGND VPWR VPWR _3028_ sky130_fd_sc_hd__a21o_1
Xclkbuf_leaf_3_clk clknet_3_2__leaf_clk VGND VGND VPWR VPWR clknet_leaf_3_clk sky130_fd_sc_hd__clkbuf_16
XTAP_257 VGND VPWR sky130_fd_sc_hd__tapvpwrvgnd_1
XTAP_279 VGND VPWR sky130_fd_sc_hd__tapvpwrvgnd_1
XTAP_268 VGND VPWR sky130_fd_sc_hd__tapvpwrvgnd_1
X_7971_ _0816_ _0811_ _0742_ VGND VGND VPWR VPWR _0820_ sky130_fd_sc_hd__o21ai_2
X_6922_ _3768_ _3752_ _3858_ VGND VGND VPWR VPWR _3909_ sky130_fd_sc_hd__o21ai_1
X_6853_ _3717_ _3704_ VGND VGND VPWR VPWR _3841_ sky130_fd_sc_hd__nand2_1
XFILLER_0_49_438 VGND VGND VPWR VPWR sky130_fd_sc_hd__decap_8
XFILLER_0_49_449 VGND VGND VPWR VPWR sky130_fd_sc_hd__decap_3
Xfanout28 sh12\[6\] VGND VGND VPWR VPWR net28 sky130_fd_sc_hd__clkbuf_4
XFILLER_0_9_535 VGND VGND VPWR VPWR sky130_fd_sc_hd__decap_8
XFILLER_0_9_502 VGND VGND VPWR VPWR sky130_fd_sc_hd__fill_2
X_5804_ _2664_ _2721_ VGND VGND VPWR VPWR _2819_ sky130_fd_sc_hd__nor2_1
XFILLER_0_119_337 VPWR VGND VPWR VGND sky130_ef_sc_hd__decap_12
Xfanout39 sh4\[6\] VGND VGND VPWR VPWR net39 sky130_fd_sc_hd__clkbuf_4
XFILLER_0_57_460 VPWR VGND VPWR VGND sky130_ef_sc_hd__decap_12
X_6784_ _3745_ _3772_ _3724_ VGND VGND VPWR VPWR _3773_ sky130_fd_sc_hd__o21bai_1
X_8523_ clknet_leaf_23_clk _0093_ _0274_ VGND VGND VPWR VPWR sum5\[13\] sky130_fd_sc_hd__dfrtp_1
X_5735_ _2743_ _2747_ _2749_ _2750_ VGND VGND VPWR VPWR _2751_ sky130_fd_sc_hd__a211o_1
XFILLER_0_44_121 VGND VGND VPWR VPWR sky130_fd_sc_hd__decap_4
XFILLER_0_95_3 VPWR VGND VPWR VGND sky130_ef_sc_hd__decap_12
X_8454_ clknet_leaf_31_clk net235 _0205_ VGND VGND VPWR VPWR carry3\[9\] sky130_fd_sc_hd__dfrtp_1
X_5666_ _2622_ _2624_ _2681_ _2682_ VGND VGND VPWR VPWR _2683_ sky130_fd_sc_hd__o211ai_4
X_4617_ _1654_ _1648_ _1649_ VGND VGND VPWR VPWR _1656_ sky130_fd_sc_hd__a21oi_2
X_7405_ _4148_ VGND VGND VPWR VPWR _0414_ sky130_fd_sc_hd__inv_2
XFILLER_0_4_251 VGND VGND VPWR VPWR sky130_fd_sc_hd__fill_1
XFILLER_0_103_727 VGND VGND VPWR VPWR sky130_fd_sc_hd__fill_1
XFILLER_0_102_204 VGND VGND VPWR VPWR sky130_fd_sc_hd__fill_2
X_8385_ _1209_ _1210_ _1211_ _1215_ VGND VGND VPWR VPWR _1217_ sky130_fd_sc_hd__a31o_1
XFILLER_0_25_390 VGND VGND VPWR VPWR sky130_fd_sc_hd__fill_2
X_5597_ _2610_ _2611_ _2614_ VGND VGND VPWR VPWR _2615_ sky130_fd_sc_hd__o21ai_4
X_4548_ _1590_ _1591_ VGND VGND VPWR VPWR _1592_ sky130_fd_sc_hd__and2_1
X_7336_ _4141_ VGND VGND VPWR VPWR _0352_ sky130_fd_sc_hd__inv_2
XFILLER_0_40_360 VGND VGND VPWR VPWR sky130_fd_sc_hd__decap_4
X_4479_ _1499_ _1500_ VGND VGND VPWR VPWR _1524_ sky130_fd_sc_hd__nand2_1
X_7267_ _4134_ VGND VGND VPWR VPWR _0290_ sky130_fd_sc_hd__inv_2
X_6218_ _3216_ _3220_ _3222_ VGND VGND VPWR VPWR _3223_ sky130_fd_sc_hd__a21o_1
X_7198_ _4127_ VGND VGND VPWR VPWR _0228_ sky130_fd_sc_hd__inv_2
X_6149_ _3142_ _3145_ _3148_ _3154_ VGND VGND VPWR VPWR _3155_ sky130_fd_sc_hd__a31o_1
XTAP_791 VGND VPWR sky130_fd_sc_hd__tapvpwrvgnd_1
XTAP_780 VGND VPWR sky130_fd_sc_hd__tapvpwrvgnd_1
XFILLER_0_67_257 VGND VGND VPWR VPWR sky130_fd_sc_hd__fill_1
XFILLER_0_67_235 VGND VGND VPWR VPWR sky130_fd_sc_hd__decap_4
XFILLER_0_35_121 VGND VGND VPWR VPWR sky130_fd_sc_hd__fill_1
XFILLER_0_35_154 VGND VGND VPWR VPWR sky130_fd_sc_hd__decap_3
XFILLER_0_106_554 VGND VGND VPWR VPWR sky130_fd_sc_hd__fill_2
XFILLER_0_90_293 VPWR VGND VPWR VGND sky130_ef_sc_hd__decap_12
XFILLER_0_23_327 VGND VGND VPWR VPWR sky130_fd_sc_hd__decap_3
XFILLER_0_36_699 VGND VGND VPWR VPWR sky130_fd_sc_hd__fill_1
XFILLER_0_23_349 VPWR VGND VPWR VGND sky130_ef_sc_hd__decap_12
XFILLER_0_51_658 VPWR VGND VPWR VGND sky130_ef_sc_hd__decap_12
XFILLER_0_121_546 VGND VGND VPWR VPWR sky130_fd_sc_hd__decap_6
XFILLER_0_31_360 VGND VGND VPWR VPWR sky130_fd_sc_hd__fill_2
XFILLER_0_31_382 VGND VGND VPWR VPWR sky130_fd_sc_hd__decap_8
XFILLER_0_101_281 VGND VGND VPWR VPWR sky130_fd_sc_hd__decap_6
XFILLER_0_92_18 VGND VGND VPWR VPWR sky130_fd_sc_hd__decap_8
XFILLER_0_92_29 VGND VGND VPWR VPWR sky130_fd_sc_hd__decap_8
XFILLER_0_58_224 VPWR VGND VPWR VGND sky130_ef_sc_hd__decap_12
XFILLER_0_58_246 VGND VGND VPWR VPWR sky130_fd_sc_hd__decap_6
XFILLER_0_73_216 VGND VGND VPWR VPWR sky130_fd_sc_hd__decap_8
XFILLER_0_39_471 VPWR VGND VPWR VGND sky130_ef_sc_hd__decap_12
XFILLER_0_41_55 VGND VGND VPWR VPWR sky130_fd_sc_hd__fill_1
X_5520_ _2531_ _2532_ _2538_ VGND VGND VPWR VPWR _2539_ sky130_fd_sc_hd__a21o_1
XFILLER_0_26_165 VGND VGND VPWR VPWR sky130_fd_sc_hd__decap_8
XFILLER_0_41_113 VPWR VGND VPWR VGND sky130_ef_sc_hd__decap_12
XFILLER_0_2_733 VGND VGND VPWR VPWR sky130_fd_sc_hd__fill_2
XFILLER_0_14_349 VGND VGND VPWR VPWR sky130_fd_sc_hd__decap_6
X_5451_ sh10\[0\] net30 sh12\[0\] VGND VGND VPWR VPWR _2471_ sky130_fd_sc_hd__o21ai_1
XFILLER_0_112_557 VGND VGND VPWR VPWR sky130_fd_sc_hd__decap_4
X_4402_ _1226_ _1229_ _1446_ VGND VGND VPWR VPWR _1448_ sky130_fd_sc_hd__a21oi_2
X_8170_ _0736_ _0737_ _0938_ VGND VGND VPWR VPWR _1016_ sky130_fd_sc_hd__a21o_1
XFILLER_0_22_360 VGND VGND VPWR VPWR sky130_fd_sc_hd__decap_4
X_5382_ _2369_ _2406_ _2396_ _2401_ VGND VGND VPWR VPWR _2407_ sky130_fd_sc_hd__o211a_2
X_4333_ _1374_ _1379_ _1375_ _1376_ VGND VGND VPWR VPWR _1380_ sky130_fd_sc_hd__o211a_1
X_7121_ _4092_ _4101_ _4102_ _4099_ _4103_ VGND VGND VPWR VPWR _4104_ sky130_fd_sc_hd__o221a_1
X_4264_ _1245_ _1299_ VGND VGND VPWR VPWR _1312_ sky130_fd_sc_hd__nand2_2
XFILLER_0_10_566 VGND VGND VPWR VPWR sky130_fd_sc_hd__decap_3
X_7052_ _4024_ _4025_ sh14\[1\] VGND VGND VPWR VPWR _4037_ sky130_fd_sc_hd__nand3b_1
X_6003_ _3008_ _3010_ _2893_ VGND VGND VPWR VPWR _3011_ sky130_fd_sc_hd__o21bai_4
XFILLER_0_5_55 VGND VGND VPWR VPWR sky130_fd_sc_hd__fill_1
X_7954_ _0787_ _0793_ _0802_ VGND VGND VPWR VPWR _0803_ sky130_fd_sc_hd__a21boi_1
XFILLER_0_89_393 VPWR VGND VPWR VGND sky130_ef_sc_hd__decap_12
XFILLER_0_89_382 VGND VGND VPWR VPWR sky130_fd_sc_hd__decap_8
XTAP_1209 VGND VPWR sky130_fd_sc_hd__tapvpwrvgnd_1
XFILLER_0_10_3 VPWR VGND VPWR VGND sky130_ef_sc_hd__decap_12
X_6905_ _3793_ _3794_ _3813_ VGND VGND VPWR VPWR _3893_ sky130_fd_sc_hd__a21boi_1
XFILLER_0_77_544 VPWR VGND VPWR VGND sky130_ef_sc_hd__decap_12
X_7885_ _0731_ _0733_ _0734_ VGND VGND VPWR VPWR _0735_ sky130_fd_sc_hd__o21bai_2
XFILLER_0_9_343 VPWR VGND VPWR VGND sky130_ef_sc_hd__decap_12
XFILLER_0_9_332 VGND VGND VPWR VPWR sky130_fd_sc_hd__decap_4
X_6836_ sh15\[1\] _3732_ VGND VGND VPWR VPWR _3825_ sky130_fd_sc_hd__nand2_1
X_6767_ _3741_ _3745_ _3724_ VGND VGND VPWR VPWR _3756_ sky130_fd_sc_hd__o21ai_1
XFILLER_0_18_622 VGND VGND VPWR VPWR sky130_fd_sc_hd__decap_8
X_8506_ clknet_leaf_25_clk _0166_ _0257_ VGND VGND VPWR VPWR final_sum\[12\] sky130_fd_sc_hd__dfrtp_1
XFILLER_0_9_387 VGND VGND VPWR VPWR sky130_fd_sc_hd__decap_4
X_5718_ _2481_ _2680_ _2730_ _2731_ _2733_ VGND VGND VPWR VPWR _2734_ sky130_fd_sc_hd__o221ai_4
XFILLER_0_17_132 VGND VGND VPWR VPWR sky130_fd_sc_hd__fill_2
X_6698_ _3675_ _3671_ _3672_ _3689_ VGND VGND VPWR VPWR _3691_ sky130_fd_sc_hd__a31o_1
XFILLER_0_17_165 VGND VGND VPWR VPWR sky130_fd_sc_hd__decap_3
XFILLER_0_45_474 VPWR VGND VPWR VGND sky130_ef_sc_hd__decap_12
X_8437_ _1231_ _1239_ _1235_ VGND VGND VPWR VPWR _1266_ sky130_fd_sc_hd__o21a_1
XFILLER_0_5_582 VGND VGND VPWR VPWR sky130_fd_sc_hd__fill_1
X_5649_ _2615_ _2641_ _2639_ VGND VGND VPWR VPWR _2666_ sky130_fd_sc_hd__o21ai_1
X_8368_ _1199_ _1200_ _1201_ VGND VGND VPWR VPWR _1202_ sky130_fd_sc_hd__and3_1
XFILLER_0_60_477 VGND VGND VPWR VPWR sky130_fd_sc_hd__decap_4
Xhold261 _1137_ VGND VGND VPWR VPWR net303 sky130_fd_sc_hd__dlygate4sd3_1
XFILLER_0_13_393 VGND VGND VPWR VPWR sky130_fd_sc_hd__fill_2
Xhold250 sh7\[2\] VGND VGND VPWR VPWR net292 sky130_fd_sc_hd__dlygate4sd3_1
X_7319_ _4139_ VGND VGND VPWR VPWR _0337_ sky130_fd_sc_hd__inv_2
Xhold294 sh4\[7\] VGND VGND VPWR VPWR net336 sky130_fd_sc_hd__dlygate4sd3_1
X_8299_ net303 _1138_ VGND VGND VPWR VPWR _0106_ sky130_fd_sc_hd__nor2_1
Xhold283 sh2\[0\] VGND VGND VPWR VPWR net325 sky130_fd_sc_hd__dlygate4sd3_1
Xhold272 sh12\[0\] VGND VGND VPWR VPWR net314 sky130_fd_sc_hd__dlygate4sd3_1
XFILLER_0_99_113 VGND VGND VPWR VPWR sky130_fd_sc_hd__decap_3
XTAP_1743 VGND VPWR sky130_fd_sc_hd__tapvpwrvgnd_1
XTAP_1721 VGND VPWR sky130_fd_sc_hd__tapvpwrvgnd_1
XTAP_1732 VGND VPWR sky130_fd_sc_hd__tapvpwrvgnd_1
XTAP_1710 VGND VPWR sky130_fd_sc_hd__tapvpwrvgnd_1
XTAP_1776 VGND VPWR sky130_fd_sc_hd__tapvpwrvgnd_1
XTAP_1765 VGND VPWR sky130_fd_sc_hd__tapvpwrvgnd_1
XTAP_1754 VGND VPWR sky130_fd_sc_hd__tapvpwrvgnd_1
XTAP_1798 VGND VPWR sky130_fd_sc_hd__tapvpwrvgnd_1
XTAP_1787 VGND VPWR sky130_fd_sc_hd__tapvpwrvgnd_1
XFILLER_0_55_249 VPWR VGND VPWR VGND sky130_ef_sc_hd__decap_12
XFILLER_0_36_441 VGND VGND VPWR VPWR sky130_fd_sc_hd__decap_6
XFILLER_0_23_113 VPWR VGND VPWR VGND sky130_ef_sc_hd__decap_12
XFILLER_0_51_422 VGND VGND VPWR VPWR sky130_fd_sc_hd__decap_4
XFILLER_0_63_293 VPWR VGND VPWR VGND sky130_ef_sc_hd__decap_12
XFILLER_0_11_69 VPWR VGND VPWR VGND sky130_ef_sc_hd__decap_12
XFILLER_0_51_466 VGND VGND VPWR VPWR sky130_fd_sc_hd__fill_1
XFILLER_0_11_319 VGND VGND VPWR VPWR sky130_fd_sc_hd__fill_1
XFILLER_0_51_499 VGND VGND VPWR VPWR sky130_fd_sc_hd__decap_4
Xinput7 x[5] VGND VGND VPWR VPWR net7 sky130_fd_sc_hd__buf_1
X_4951_ _1980_ _1983_ _1984_ VGND VGND VPWR VPWR _1985_ sky130_fd_sc_hd__a21o_2
X_4882_ _1690_ _1912_ _1916_ VGND VGND VPWR VPWR _1917_ sky130_fd_sc_hd__a21o_1
X_7670_ sum3\[11\] carry3\[10\] VGND VGND VPWR VPWR _4195_ sky130_fd_sc_hd__nor2_1
X_6621_ _3567_ _3564_ _3559_ VGND VGND VPWR VPWR _3616_ sky130_fd_sc_hd__a21boi_2
XFILLER_0_6_324 VGND VGND VPWR VPWR sky130_fd_sc_hd__fill_2
X_6552_ _3511_ _3546_ _3510_ VGND VGND VPWR VPWR _3548_ sky130_fd_sc_hd__nand3b_1
XFILLER_0_15_625 VGND VGND VPWR VPWR sky130_fd_sc_hd__fill_2
X_6483_ _3414_ _3412_ _3477_ _3480_ VGND VGND VPWR VPWR _3481_ sky130_fd_sc_hd__a2bb2o_1
XFILLER_0_15_658 VPWR VGND VPWR VGND sky130_ef_sc_hd__decap_12
X_5503_ _2519_ _2520_ _2521_ VGND VGND VPWR VPWR _2522_ sky130_fd_sc_hd__o21bai_2
X_8222_ _1062_ _1060_ _1063_ VGND VGND VPWR VPWR _1067_ sky130_fd_sc_hd__a21oi_1
X_5434_ _2437_ _2440_ _2444_ _2456_ VGND VGND VPWR VPWR _2457_ sky130_fd_sc_hd__nand4_1
XFILLER_0_42_477 VPWR VGND VPWR VGND sky130_ef_sc_hd__decap_12
XFILLER_0_112_365 VPWR VGND VPWR VGND sky130_ef_sc_hd__decap_12
X_8153_ _0748_ _0762_ _0892_ VGND VGND VPWR VPWR _0999_ sky130_fd_sc_hd__o21a_1
XFILLER_0_100_538 VGND VGND VPWR VPWR sky130_fd_sc_hd__decap_4
XFILLER_0_77_51 VGND VGND VPWR VPWR sky130_fd_sc_hd__decap_4
XFILLER_0_58_3 VGND VGND VPWR VPWR sky130_fd_sc_hd__decap_8
X_7104_ _4086_ _4084_ _4085_ VGND VGND VPWR VPWR _4088_ sky130_fd_sc_hd__and3_1
X_5365_ _2387_ _2388_ _2389_ VGND VGND VPWR VPWR _2390_ sky130_fd_sc_hd__o21ai_2
X_4316_ _1355_ _1362_ net34 VGND VGND VPWR VPWR _1363_ sky130_fd_sc_hd__o21bai_4
X_8084_ _0748_ _0762_ sh9\[3\] VGND VGND VPWR VPWR _0931_ sky130_fd_sc_hd__o21bai_1
X_5296_ _2060_ _2061_ _2038_ VGND VGND VPWR VPWR _2322_ sky130_fd_sc_hd__o21a_1
X_4247_ _1289_ _1288_ _1243_ VGND VGND VPWR VPWR _1295_ sky130_fd_sc_hd__o21ai_2
X_7035_ _4018_ _4019_ _3724_ VGND VGND VPWR VPWR _4020_ sky130_fd_sc_hd__o21bai_4
XTAP_1028 VGND VPWR sky130_fd_sc_hd__tapvpwrvgnd_1
XTAP_1017 VGND VPWR sky130_fd_sc_hd__tapvpwrvgnd_1
XTAP_1006 VGND VPWR sky130_fd_sc_hd__tapvpwrvgnd_1
X_7937_ _0785_ _0778_ _0783_ VGND VGND VPWR VPWR _0786_ sky130_fd_sc_hd__nand3b_1
XTAP_1039 VGND VPWR sky130_fd_sc_hd__tapvpwrvgnd_1
X_7868_ net251 net435 VGND VGND VPWR VPWR _0720_ sky130_fd_sc_hd__and2_1
XFILLER_0_37_205 VGND VGND VPWR VPWR sky130_fd_sc_hd__decap_6
XFILLER_0_65_547 VPWR VGND VPWR VGND sky130_ef_sc_hd__decap_12
X_6819_ _3806_ _3807_ VGND VGND VPWR VPWR _3808_ sky130_fd_sc_hd__nor2_1
XFILLER_0_37_249 VGND VGND VPWR VPWR sky130_fd_sc_hd__decap_8
X_7799_ s0\[5\] s1\[5\] net254 VGND VGND VPWR VPWR _0685_ sky130_fd_sc_hd__a21o_1
XFILLER_0_123_608 VGND VGND VPWR VPWR sky130_fd_sc_hd__fill_1
XFILLER_0_80_528 VGND VGND VPWR VPWR sky130_fd_sc_hd__decap_4
XFILLER_0_115_181 VGND VGND VPWR VPWR sky130_fd_sc_hd__decap_8
XFILLER_0_60_263 VPWR VGND VPWR VGND sky130_ef_sc_hd__decap_12
XFILLER_0_21_617 VGND VGND VPWR VPWR sky130_fd_sc_hd__fill_2
XFILLER_0_60_296 VPWR VGND VPWR VGND sky130_ef_sc_hd__decap_12
XFILLER_0_20_116 VGND VGND VPWR VPWR sky130_fd_sc_hd__decap_3
XTAP_1551 VGND VPWR sky130_fd_sc_hd__tapvpwrvgnd_1
XTAP_1540 VGND VPWR sky130_fd_sc_hd__tapvpwrvgnd_1
XFILLER_0_68_363 VGND VGND VPWR VPWR sky130_fd_sc_hd__fill_1
XFILLER_0_68_352 VGND VGND VPWR VPWR sky130_fd_sc_hd__decap_3
XFILLER_0_113_15 VPWR VGND VPWR VGND sky130_ef_sc_hd__decap_12
XTAP_1584 VGND VPWR sky130_fd_sc_hd__tapvpwrvgnd_1
XTAP_1573 VGND VPWR sky130_fd_sc_hd__tapvpwrvgnd_1
XTAP_1562 VGND VPWR sky130_fd_sc_hd__tapvpwrvgnd_1
XFILLER_0_56_558 VGND VGND VPWR VPWR sky130_fd_sc_hd__fill_1
XPHY_80 VGND VGND VPWR VPWR sky130_fd_sc_hd__decap_3
XPHY_91 VGND VGND VPWR VPWR sky130_fd_sc_hd__decap_3
XTAP_1595 VGND VPWR sky130_fd_sc_hd__tapvpwrvgnd_1
XFILLER_0_83_366 VPWR VGND VPWR VGND sky130_ef_sc_hd__decap_12
XFILLER_0_11_105 VGND VGND VPWR VPWR sky130_fd_sc_hd__decap_6
XFILLER_0_3_349 VPWR VGND VPWR VGND sky130_ef_sc_hd__decap_12
XFILLER_0_20_661 VPWR VGND VPWR VGND sky130_ef_sc_hd__decap_12
X_5150_ _2125_ _2178_ _2123_ VGND VGND VPWR VPWR _2179_ sky130_fd_sc_hd__o21ai_2
X_5081_ sh7\[2\] _2102_ VGND VGND VPWR VPWR _2110_ sky130_fd_sc_hd__nand2_4
XFILLER_0_47_54 VGND VGND VPWR VPWR sky130_fd_sc_hd__fill_2
XFILLER_0_47_98 VGND VGND VPWR VPWR sky130_fd_sc_hd__fill_1
XFILLER_0_79_617 VPWR VGND VPWR VGND sky130_ef_sc_hd__decap_12
X_8840_ clknet_leaf_1_clk net197 _0591_ VGND VGND VPWR VPWR sh11\[4\] sky130_fd_sc_hd__dfrtp_1
X_8771_ clknet_leaf_18_clk net41 _0522_ VGND VGND VPWR VPWR sh2\[7\] sky130_fd_sc_hd__dfrtp_4
X_5983_ _2988_ _2984_ _2991_ VGND VGND VPWR VPWR _2992_ sky130_fd_sc_hd__or3b_2
X_4934_ _1961_ _1962_ _1967_ VGND VGND VPWR VPWR _1968_ sky130_fd_sc_hd__o21ai_4
X_7722_ carry1\[9\] sum1\[10\] VGND VGND VPWR VPWR _0633_ sky130_fd_sc_hd__xnor2_1
XFILLER_0_47_536 VPWR VGND VPWR VGND sky130_ef_sc_hd__decap_12
X_4865_ _1896_ _1897_ _1894_ _1892_ VGND VGND VPWR VPWR _1901_ sky130_fd_sc_hd__o211ai_1
XFILLER_0_74_355 VGND VGND VPWR VPWR sky130_fd_sc_hd__fill_1
X_7653_ net374 _4181_ VGND VGND VPWR VPWR _0087_ sky130_fd_sc_hd__nand2_1
XFILLER_0_35_709 VPWR VGND VPWR VGND sky130_ef_sc_hd__decap_12
XFILLER_0_47_569 VPWR VGND VPWR VGND sky130_ef_sc_hd__decap_12
XFILLER_0_117_457 VGND VGND VPWR VPWR sky130_fd_sc_hd__decap_3
X_7584_ _4165_ VGND VGND VPWR VPWR _0576_ sky130_fd_sc_hd__inv_2
X_4796_ _1830_ _1831_ _1766_ VGND VGND VPWR VPWR _1833_ sky130_fd_sc_hd__nand3_4
X_6604_ _3594_ _3593_ VGND VGND VPWR VPWR _3599_ sky130_fd_sc_hd__nand2_1
XFILLER_0_6_121 VPWR VGND VPWR VGND sky130_ef_sc_hd__decap_12
XFILLER_0_103_92 VGND VGND VPWR VPWR sky130_fd_sc_hd__decap_6
X_6535_ _3527_ _3529_ _3531_ VGND VGND VPWR VPWR _3532_ sky130_fd_sc_hd__a21oi_1
XFILLER_0_6_165 VPWR VGND VPWR VGND sky130_ef_sc_hd__decap_12
XFILLER_0_15_422 VGND VGND VPWR VPWR sky130_fd_sc_hd__fill_1
XFILLER_0_27_293 VPWR VGND VPWR VGND sky130_ef_sc_hd__decap_12
X_6466_ _3457_ _3458_ _3459_ _3463_ VGND VGND VPWR VPWR _3464_ sky130_fd_sc_hd__o22ai_2
X_8205_ _0969_ _1035_ _1030_ VGND VGND VPWR VPWR _1050_ sky130_fd_sc_hd__a21boi_2
XFILLER_0_42_296 VPWR VGND VPWR VGND sky130_ef_sc_hd__decap_12
XFILLER_0_113_685 VPWR VGND VPWR VGND sky130_ef_sc_hd__decap_12
X_6397_ _3330_ _3332_ _3341_ _3347_ VGND VGND VPWR VPWR _3396_ sky130_fd_sc_hd__o211ai_2
XFILLER_0_11_661 VGND VGND VPWR VPWR sky130_fd_sc_hd__decap_8
X_5417_ _2397_ _2398_ _2386_ _2390_ VGND VGND VPWR VPWR _2441_ sky130_fd_sc_hd__o211ai_2
XFILLER_0_112_195 VGND VGND VPWR VPWR sky130_fd_sc_hd__fill_1
X_5348_ _2372_ VGND VGND VPWR VPWR _2373_ sky130_fd_sc_hd__buf_2
X_8136_ _0901_ _0891_ _0974_ VGND VGND VPWR VPWR _0983_ sky130_fd_sc_hd__o21ai_1
X_8067_ _0911_ _0912_ _0914_ VGND VGND VPWR VPWR _0915_ sky130_fd_sc_hd__a21oi_2
X_7018_ _3931_ _3932_ VGND VGND VPWR VPWR _4004_ sky130_fd_sc_hd__and2_1
X_5279_ _2301_ _2305_ VGND VGND VPWR VPWR _2306_ sky130_fd_sc_hd__nor2_1
XFILLER_0_97_414 VGND VGND VPWR VPWR sky130_fd_sc_hd__decap_4
XFILLER_0_78_661 VPWR VGND VPWR VGND sky130_ef_sc_hd__decap_12
XFILLER_0_123_405 VPWR VGND VPWR VGND sky130_ef_sc_hd__decap_12
XFILLER_0_18_293 VPWR VGND VPWR VGND sky130_ef_sc_hd__decap_12
XFILLER_0_33_230 VGND VGND VPWR VPWR sky130_fd_sc_hd__decap_8
XFILLER_0_123_449 VPWR VGND VPWR VGND sky130_ef_sc_hd__decap_12
XFILLER_0_61_561 VGND VGND VPWR VPWR sky130_fd_sc_hd__decap_4
XFILLER_0_21_447 VGND VGND VPWR VPWR sky130_fd_sc_hd__fill_1
XFILLER_0_33_274 VGND VGND VPWR VPWR sky130_fd_sc_hd__decap_6
XFILLER_0_33_285 VGND VGND VPWR VPWR sky130_fd_sc_hd__fill_1
XFILLER_0_104_685 VPWR VGND VPWR VGND sky130_ef_sc_hd__decap_12
XTAP_609 VGND VPWR sky130_fd_sc_hd__tapvpwrvgnd_1
XFILLER_0_108_15 VPWR VGND VPWR VGND sky130_ef_sc_hd__decap_12
XFILLER_0_17_35 VGND VGND VPWR VPWR sky130_fd_sc_hd__fill_2
XFILLER_0_68_171 VGND VGND VPWR VPWR sky130_fd_sc_hd__fill_2
XTAP_1392 VGND VPWR sky130_fd_sc_hd__tapvpwrvgnd_1
XTAP_1370 VGND VPWR sky130_fd_sc_hd__tapvpwrvgnd_1
XTAP_1381 VGND VPWR sky130_fd_sc_hd__tapvpwrvgnd_1
XFILLER_0_17_709 VPWR VGND VPWR VGND sky130_ef_sc_hd__decap_12
X_4650_ _1683_ _1687_ _1636_ VGND VGND VPWR VPWR _1688_ sky130_fd_sc_hd__o21ai_1
XFILLER_0_84_697 VGND VGND VPWR VPWR sky130_fd_sc_hd__decap_3
XFILLER_0_116_3 VPWR VGND VPWR VGND sky130_ef_sc_hd__decap_12
XFILLER_0_114_416 VGND VGND VPWR VPWR sky130_fd_sc_hd__decap_4
X_4581_ _1602_ _1601_ _1599_ VGND VGND VPWR VPWR _1623_ sky130_fd_sc_hd__a21boi_2
X_6320_ _3313_ _3312_ VGND VGND VPWR VPWR _3320_ sky130_fd_sc_hd__nand2_1
XFILLER_0_3_113 VPWR VGND VPWR VGND sky130_ef_sc_hd__decap_12
XFILLER_0_40_701 VPWR VGND VPWR VGND sky130_ef_sc_hd__decap_12
XFILLER_0_4_669 VPWR VGND VPWR VGND sky130_ef_sc_hd__decap_12
X_6251_ _3250_ VGND VGND VPWR VPWR _3255_ sky130_fd_sc_hd__inv_2
X_6182_ _3120_ _3185_ _3187_ VGND VGND VPWR VPWR _3188_ sky130_fd_sc_hd__o21ai_2
X_5202_ _2226_ _2227_ _2200_ VGND VGND VPWR VPWR _2230_ sky130_fd_sc_hd__o21bai_2
X_5133_ _2161_ _2043_ VGND VGND VPWR VPWR _2162_ sky130_fd_sc_hd__nor2_2
XFILLER_0_74_41 VPWR VGND VPWR VGND sky130_ef_sc_hd__decap_12
X_5064_ _2089_ _2092_ _2086_ VGND VGND VPWR VPWR _2093_ sky130_fd_sc_hd__nand3_1
XFILLER_0_74_85 VPWR VGND VPWR VGND sky130_ef_sc_hd__decap_12
XFILLER_0_79_447 VGND VGND VPWR VPWR sky130_fd_sc_hd__fill_1
XFILLER_0_79_436 VGND VGND VPWR VPWR sky130_fd_sc_hd__fill_1
X_8823_ clknet_leaf_4_clk net218 _0574_ VGND VGND VPWR VPWR sh9\[3\] sky130_fd_sc_hd__dfrtp_4
X_8754_ clknet_leaf_7_clk net8 _0505_ VGND VGND VPWR VPWR sh0\[6\] sky130_fd_sc_hd__dfrtp_4
X_5966_ _2906_ net28 VGND VGND VPWR VPWR _2975_ sky130_fd_sc_hd__nor2_2
XFILLER_0_118_733 VGND VGND VPWR VPWR sky130_fd_sc_hd__fill_2
X_5897_ sh11\[6\] VGND VGND VPWR VPWR _2906_ sky130_fd_sc_hd__clkbuf_4
X_4917_ _1948_ _1949_ _1951_ VGND VGND VPWR VPWR _1952_ sky130_fd_sc_hd__a21oi_1
XFILLER_0_74_141 VGND VGND VPWR VPWR sky130_fd_sc_hd__decap_4
XFILLER_0_59_193 VGND VGND VPWR VPWR sky130_fd_sc_hd__fill_1
X_7705_ carry1\[10\] net261 _4216_ VGND VGND VPWR VPWR _0011_ sky130_fd_sc_hd__o21a_1
X_8685_ clknet_leaf_49_clk _0150_ _0436_ VGND VGND VPWR VPWR bit_sum1\[6\] sky130_fd_sc_hd__dfrtp_1
X_4848_ _1847_ _1844_ _1883_ _1839_ VGND VGND VPWR VPWR _1884_ sky130_fd_sc_hd__nand4_1
X_7636_ _4122_ VGND VGND VPWR VPWR _0624_ sky130_fd_sc_hd__inv_2
XFILLER_0_62_325 VGND VGND VPWR VPWR sky130_fd_sc_hd__decap_3
XFILLER_0_62_303 VGND VGND VPWR VPWR sky130_fd_sc_hd__decap_4
XFILLER_0_35_517 VGND VGND VPWR VPWR sky130_fd_sc_hd__decap_4
XFILLER_0_117_254 VGND VGND VPWR VPWR sky130_fd_sc_hd__fill_1
XFILLER_0_7_485 VGND VGND VPWR VPWR sky130_fd_sc_hd__fill_1
XFILLER_0_7_452 VGND VGND VPWR VPWR sky130_fd_sc_hd__fill_2
XFILLER_0_117_287 VGND VGND VPWR VPWR sky130_fd_sc_hd__decap_8
X_4779_ _1810_ _1814_ VGND VGND VPWR VPWR _1816_ sky130_fd_sc_hd__nand2_1
X_7567_ _4164_ VGND VGND VPWR VPWR _0560_ sky130_fd_sc_hd__inv_2
XFILLER_0_43_561 VGND VGND VPWR VPWR sky130_fd_sc_hd__decap_3
XFILLER_0_43_572 VGND VGND VPWR VPWR sky130_fd_sc_hd__fill_1
X_7498_ _4147_ VGND VGND VPWR VPWR _4157_ sky130_fd_sc_hd__clkbuf_16
X_6518_ _3503_ _3505_ _3514_ VGND VGND VPWR VPWR _3515_ sky130_fd_sc_hd__o21ai_1
XFILLER_0_15_274 VGND VGND VPWR VPWR sky130_fd_sc_hd__decap_6
X_6449_ _3444_ _3445_ _3446_ _3389_ VGND VGND VPWR VPWR _3447_ sky130_fd_sc_hd__o31ai_2
X_8119_ _0946_ _0950_ _0964_ _0965_ VGND VGND VPWR VPWR _0966_ sky130_fd_sc_hd__o2bb2ai_2
XFILLER_0_98_701 VPWR VGND VPWR VGND sky130_ef_sc_hd__decap_12
XFILLER_0_53_314 VPWR VGND VPWR VGND sky130_ef_sc_hd__decap_12
XFILLER_0_26_528 VGND VGND VPWR VPWR sky130_fd_sc_hd__decap_4
XFILLER_0_80_133 VGND VGND VPWR VPWR sky130_fd_sc_hd__decap_6
XFILLER_0_108_287 VGND VGND VPWR VPWR sky130_fd_sc_hd__decap_4
XFILLER_0_22_701 VPWR VGND VPWR VGND sky130_ef_sc_hd__decap_12
XFILLER_0_110_27 VGND VGND VPWR VPWR sky130_fd_sc_hd__fill_1
XFILLER_0_1_617 VPWR VGND VPWR VGND sky130_ef_sc_hd__decap_12
XFILLER_0_123_279 VGND VGND VPWR VPWR sky130_fd_sc_hd__fill_1
XTAP_406 VGND VPWR sky130_fd_sc_hd__tapvpwrvgnd_1
XTAP_428 VGND VPWR sky130_fd_sc_hd__tapvpwrvgnd_1
XTAP_417 VGND VPWR sky130_fd_sc_hd__tapvpwrvgnd_1
XTAP_439 VGND VPWR sky130_fd_sc_hd__tapvpwrvgnd_1
XFILLER_0_119_69 VPWR VGND VPWR VGND sky130_ef_sc_hd__decap_12
XFILLER_0_69_491 VGND VGND VPWR VPWR sky130_fd_sc_hd__fill_1
X_5820_ _2829_ _2832_ _2833_ VGND VGND VPWR VPWR _2834_ sky130_fd_sc_hd__nand3b_2
XFILLER_0_84_450 VGND VGND VPWR VPWR sky130_fd_sc_hd__decap_6
XFILLER_0_56_141 VGND VGND VPWR VPWR sky130_fd_sc_hd__decap_3
X_5751_ _2761_ _2765_ _2766_ VGND VGND VPWR VPWR _2767_ sky130_fd_sc_hd__nand3_2
X_4702_ _1739_ _1692_ _1689_ VGND VGND VPWR VPWR _1740_ sky130_fd_sc_hd__nand3_1
XFILLER_0_72_612 VPWR VGND VPWR VGND sky130_ef_sc_hd__decap_12
XFILLER_0_60_43 VPWR VGND VPWR VGND sky130_ef_sc_hd__decap_12
X_8470_ clknet_leaf_36_clk net100 _0221_ VGND VGND VPWR VPWR s0\[2\] sky130_fd_sc_hd__dfrtp_1
XFILLER_0_72_645 VGND VGND VPWR VPWR sky130_fd_sc_hd__fill_1
X_5682_ _2673_ _2669_ _2671_ VGND VGND VPWR VPWR _2699_ sky130_fd_sc_hd__and3_1
X_7421_ _4147_ VGND VGND VPWR VPWR _4150_ sky130_fd_sc_hd__buf_4
XFILLER_0_44_325 VGND VGND VPWR VPWR sky130_fd_sc_hd__fill_1
X_4633_ _1669_ _1670_ _1659_ _1661_ VGND VGND VPWR VPWR _1672_ sky130_fd_sc_hd__o211ai_2
X_4564_ _1603_ _1604_ VGND VGND VPWR VPWR _1607_ sky130_fd_sc_hd__nand2_1
XFILLER_0_102_408 VPWR VGND VPWR VGND sky130_ef_sc_hd__decap_12
X_7352_ _4142_ VGND VGND VPWR VPWR _0367_ sky130_fd_sc_hd__inv_2
X_6303_ _3299_ _3301_ _3302_ VGND VGND VPWR VPWR _3303_ sky130_fd_sc_hd__o21ba_1
X_7283_ _4135_ VGND VGND VPWR VPWR _0305_ sky130_fd_sc_hd__inv_2
XFILLER_0_12_233 VGND VGND VPWR VPWR sky130_fd_sc_hd__fill_2
XFILLER_0_8_77 VGND VGND VPWR VPWR sky130_fd_sc_hd__decap_6
XFILLER_0_4_477 VGND VGND VPWR VPWR sky130_fd_sc_hd__fill_1
XFILLER_0_40_531 VGND VGND VPWR VPWR sky130_fd_sc_hd__fill_1
XFILLER_0_40_564 VGND VGND VPWR VPWR sky130_fd_sc_hd__decap_4
X_6234_ _3236_ _3186_ VGND VGND VPWR VPWR _3239_ sky130_fd_sc_hd__nand2_1
X_4495_ _1417_ _1482_ _1538_ VGND VGND VPWR VPWR _1539_ sky130_fd_sc_hd__o21ai_2
XFILLER_0_12_266 VGND VGND VPWR VPWR sky130_fd_sc_hd__fill_1
X_6165_ _3157_ _3158_ _3162_ VGND VGND VPWR VPWR _3171_ sky130_fd_sc_hd__a21o_1
XFILLER_0_85_51 VGND VGND VPWR VPWR sky130_fd_sc_hd__decap_4
XTAP_962 VGND VPWR sky130_fd_sc_hd__tapvpwrvgnd_1
XTAP_940 VGND VPWR sky130_fd_sc_hd__tapvpwrvgnd_1
XTAP_951 VGND VPWR sky130_fd_sc_hd__tapvpwrvgnd_1
XFILLER_0_40_3 VPWR VGND VPWR VGND sky130_ef_sc_hd__decap_12
X_6096_ _3037_ _3032_ VGND VGND VPWR VPWR _3103_ sky130_fd_sc_hd__and2_1
XTAP_995 VGND VPWR sky130_fd_sc_hd__tapvpwrvgnd_1
XTAP_984 VGND VPWR sky130_fd_sc_hd__tapvpwrvgnd_1
XTAP_973 VGND VPWR sky130_fd_sc_hd__tapvpwrvgnd_1
X_5116_ _2140_ _2143_ _2144_ VGND VGND VPWR VPWR _2145_ sky130_fd_sc_hd__nand3_4
X_5047_ _2059_ _2065_ _2076_ VGND VGND VPWR VPWR _2077_ sky130_fd_sc_hd__a21o_1
XFILLER_0_67_417 VGND VGND VPWR VPWR sky130_fd_sc_hd__decap_8
XFILLER_0_79_299 VGND VGND VPWR VPWR sky130_fd_sc_hd__fill_1
X_6998_ _3979_ _3971_ _3976_ VGND VGND VPWR VPWR _3984_ sky130_fd_sc_hd__nand3b_1
X_8806_ clknet_leaf_63_clk net396 _0557_ VGND VGND VPWR VPWR sh7\[2\] sky130_fd_sc_hd__dfrtp_4
X_5949_ _2894_ sh7\[6\] VGND VGND VPWR VPWR _2958_ sky130_fd_sc_hd__and2_2
X_8737_ clknet_leaf_16_clk _0143_ _0488_ VGND VGND VPWR VPWR bit_sum6\[8\] sky130_fd_sc_hd__dfrtp_1
XFILLER_0_47_141 VPWR VGND VPWR VGND sky130_ef_sc_hd__decap_12
XFILLER_0_106_725 VGND VGND VPWR VPWR sky130_fd_sc_hd__decap_4
X_8668_ clknet_leaf_23_clk net80 _0419_ VGND VGND VPWR VPWR s7\[15\] sky130_fd_sc_hd__dfrtp_1
X_7619_ _4168_ VGND VGND VPWR VPWR _0608_ sky130_fd_sc_hd__inv_2
XFILLER_0_105_235 VGND VGND VPWR VPWR sky130_fd_sc_hd__decap_6
XFILLER_0_90_464 VPWR VGND VPWR VGND sky130_ef_sc_hd__decap_12
XFILLER_0_7_293 VGND VGND VPWR VPWR sky130_fd_sc_hd__decap_8
X_8599_ clknet_leaf_54_clk net62 _0350_ VGND VGND VPWR VPWR sum1\[11\] sky130_fd_sc_hd__dfrtp_1
XFILLER_0_105_279 VGND VGND VPWR VPWR sky130_fd_sc_hd__fill_1
XFILLER_0_31_586 VPWR VGND VPWR VGND sky130_ef_sc_hd__decap_12
XFILLER_0_98_597 VPWR VGND VPWR VGND sky130_ef_sc_hd__decap_12
XFILLER_0_85_225 VGND VGND VPWR VPWR sky130_fd_sc_hd__decap_4
XFILLER_0_85_214 VGND VGND VPWR VPWR sky130_fd_sc_hd__decap_8
XFILLER_0_85_247 VPWR VGND VPWR VGND sky130_ef_sc_hd__decap_12
XFILLER_0_66_461 VGND VGND VPWR VPWR sky130_fd_sc_hd__fill_1
XFILLER_0_66_450 VGND VGND VPWR VPWR sky130_fd_sc_hd__fill_1
XFILLER_0_54_601 VGND VGND VPWR VPWR sky130_fd_sc_hd__decap_4
XFILLER_0_39_697 VPWR VGND VPWR VGND sky130_ef_sc_hd__decap_12
XFILLER_0_121_15 VPWR VGND VPWR VGND sky130_ef_sc_hd__decap_12
XFILLER_0_109_552 VGND VGND VPWR VPWR sky130_fd_sc_hd__decap_8
XFILLER_0_54_645 VGND VGND VPWR VPWR sky130_fd_sc_hd__fill_1
XFILLER_0_109_585 VPWR VGND VPWR VGND sky130_ef_sc_hd__decap_12
XFILLER_0_41_306 VGND VGND VPWR VPWR sky130_fd_sc_hd__fill_1
XFILLER_0_22_520 VPWR VGND VPWR VGND sky130_ef_sc_hd__decap_12
XFILLER_0_30_68 VGND VGND VPWR VPWR sky130_fd_sc_hd__fill_1
XFILLER_0_1_425 VPWR VGND VPWR VGND sky130_ef_sc_hd__decap_12
X_4280_ _1246_ _1247_ _1245_ VGND VGND VPWR VPWR _1328_ sky130_fd_sc_hd__o21a_1
XFILLER_0_22_597 VPWR VGND VPWR VGND sky130_ef_sc_hd__decap_12
XFILLER_0_39_55 VGND VGND VPWR VPWR sky130_fd_sc_hd__fill_1
XFILLER_0_39_88 VGND VGND VPWR VPWR sky130_fd_sc_hd__decap_3
XTAP_258 VGND VPWR sky130_fd_sc_hd__tapvpwrvgnd_1
XTAP_269 VGND VPWR sky130_fd_sc_hd__tapvpwrvgnd_1
X_7970_ _0737_ _0723_ _0746_ VGND VGND VPWR VPWR _0819_ sky130_fd_sc_hd__o21a_1
X_6921_ _3905_ _3906_ _3907_ VGND VGND VPWR VPWR _3908_ sky130_fd_sc_hd__a21oi_1
X_6852_ _3717_ _3703_ _3710_ VGND VGND VPWR VPWR _3840_ sky130_fd_sc_hd__o21a_1
XFILLER_0_71_53 VGND VGND VPWR VPWR sky130_fd_sc_hd__decap_3
Xfanout29 sh12\[1\] VGND VGND VPWR VPWR net29 sky130_fd_sc_hd__buf_2
X_5803_ _2722_ _2767_ VGND VGND VPWR VPWR _2818_ sky130_fd_sc_hd__nand2_1
XFILLER_0_119_349 VPWR VGND VPWR VGND sky130_ef_sc_hd__decap_12
X_8522_ clknet_leaf_28_clk _0092_ _0273_ VGND VGND VPWR VPWR sum5\[12\] sky130_fd_sc_hd__dfrtp_1
XFILLER_0_57_472 VGND VGND VPWR VPWR sky130_fd_sc_hd__decap_6
X_6783_ _3712_ _3704_ VGND VGND VPWR VPWR _3772_ sky130_fd_sc_hd__nor2_1
XFILLER_0_17_347 VGND VGND VPWR VPWR sky130_fd_sc_hd__decap_4
X_5734_ _2533_ _2524_ _2748_ VGND VGND VPWR VPWR _2750_ sky130_fd_sc_hd__and3_1
XFILLER_0_72_442 VGND VGND VPWR VPWR sky130_fd_sc_hd__decap_3
X_8453_ clknet_leaf_30_clk net288 _0204_ VGND VGND VPWR VPWR carry3\[8\] sky130_fd_sc_hd__dfrtp_1
X_5665_ _2478_ _2481_ _2473_ VGND VGND VPWR VPWR _2682_ sky130_fd_sc_hd__o21bai_2
X_4616_ _1648_ _1649_ _1654_ VGND VGND VPWR VPWR _1655_ sky130_fd_sc_hd__and3_1
XFILLER_0_103_717 VGND VGND VPWR VPWR sky130_fd_sc_hd__fill_2
X_7404_ _4148_ VGND VGND VPWR VPWR _0413_ sky130_fd_sc_hd__inv_2
XFILLER_0_88_3 VPWR VGND VPWR VGND sky130_ef_sc_hd__decap_12
X_8384_ _1215_ _1216_ VGND VGND VPWR VPWR _0168_ sky130_fd_sc_hd__nor2_1
Xhold410 s6\[11\] VGND VGND VPWR VPWR net452 sky130_fd_sc_hd__dlygate4sd3_1
XFILLER_0_4_285 VGND VGND VPWR VPWR sky130_fd_sc_hd__fill_1
X_5596_ _2548_ _2469_ _2610_ _2613_ VGND VGND VPWR VPWR _2614_ sky130_fd_sc_hd__o22ai_4
X_7335_ _4141_ VGND VGND VPWR VPWR _0351_ sky130_fd_sc_hd__inv_2
XFILLER_0_102_238 VGND VGND VPWR VPWR sky130_fd_sc_hd__fill_1
X_4547_ _1533_ _1537_ _1589_ _1539_ VGND VGND VPWR VPWR _1591_ sky130_fd_sc_hd__o211ai_2
X_4478_ _1510_ _1501_ _1513_ _1512_ VGND VGND VPWR VPWR _1523_ sky130_fd_sc_hd__o211a_1
XFILLER_0_96_50 VGND VGND VPWR VPWR sky130_fd_sc_hd__decap_8
X_7266_ _4134_ VGND VGND VPWR VPWR _0289_ sky130_fd_sc_hd__inv_2
XFILLER_0_13_597 VPWR VGND VPWR VGND sky130_ef_sc_hd__decap_12
XFILLER_0_40_383 VGND VGND VPWR VPWR sky130_fd_sc_hd__fill_1
X_6217_ _3172_ _3162_ _3155_ VGND VGND VPWR VPWR _3222_ sky130_fd_sc_hd__o21ai_2
XFILLER_0_110_293 VPWR VGND VPWR VGND sky130_ef_sc_hd__decap_12
XFILLER_0_96_83 VGND VGND VPWR VPWR sky130_fd_sc_hd__fill_1
X_7197_ _4127_ VGND VGND VPWR VPWR _0227_ sky130_fd_sc_hd__inv_2
X_6148_ _3092_ _3149_ _3153_ VGND VGND VPWR VPWR _3154_ sky130_fd_sc_hd__o21ai_1
XTAP_770 VGND VPWR sky130_fd_sc_hd__tapvpwrvgnd_1
XTAP_781 VGND VPWR sky130_fd_sc_hd__tapvpwrvgnd_1
XTAP_792 VGND VPWR sky130_fd_sc_hd__tapvpwrvgnd_1
X_6079_ _2893_ _2922_ _3033_ VGND VGND VPWR VPWR _3086_ sky130_fd_sc_hd__o21bai_1
XFILLER_0_95_534 VPWR VGND VPWR VGND sky130_ef_sc_hd__decap_12
XFILLER_0_67_225 VGND VGND VPWR VPWR sky130_fd_sc_hd__decap_6
XFILLER_0_83_729 VGND VGND VPWR VPWR sky130_fd_sc_hd__decap_6
XFILLER_0_82_206 VGND VGND VPWR VPWR sky130_fd_sc_hd__decap_8
XFILLER_0_55_409 VGND VGND VPWR VPWR sky130_fd_sc_hd__fill_1
XFILLER_0_82_239 VPWR VGND VPWR VGND sky130_ef_sc_hd__decap_12
XFILLER_0_36_645 VPWR VGND VPWR VGND sky130_ef_sc_hd__decap_12
XFILLER_0_63_442 VGND VGND VPWR VPWR sky130_fd_sc_hd__decap_3
XFILLER_0_51_615 VGND VGND VPWR VPWR sky130_fd_sc_hd__fill_1
XFILLER_0_90_261 VGND VGND VPWR VPWR sky130_fd_sc_hd__fill_2
XFILLER_0_35_166 VGND VGND VPWR VPWR sky130_fd_sc_hd__fill_2
XFILLER_0_35_177 VGND VGND VPWR VPWR sky130_fd_sc_hd__decap_8
XFILLER_0_121_503 VGND VGND VPWR VPWR sky130_fd_sc_hd__fill_1
XFILLER_0_106_599 VGND VGND VPWR VPWR sky130_fd_sc_hd__decap_6
XFILLER_0_106_577 VGND VGND VPWR VPWR sky130_fd_sc_hd__decap_8
XFILLER_0_116_15 VPWR VGND VPWR VGND sky130_ef_sc_hd__decap_12
XFILLER_0_98_372 VPWR VGND VPWR VGND sky130_ef_sc_hd__decap_12
XFILLER_0_59_726 VGND VGND VPWR VPWR sky130_fd_sc_hd__fill_2
XFILLER_0_25_57 VGND VGND VPWR VPWR sky130_fd_sc_hd__fill_2
XFILLER_0_73_239 VPWR VGND VPWR VGND sky130_ef_sc_hd__decap_12
XFILLER_0_39_483 VPWR VGND VPWR VGND sky130_ef_sc_hd__decap_12
XFILLER_0_54_464 VPWR VGND VPWR VGND sky130_ef_sc_hd__decap_12
XFILLER_0_26_133 VGND VGND VPWR VPWR sky130_fd_sc_hd__decap_6
XFILLER_0_109_393 VGND VGND VPWR VPWR sky130_fd_sc_hd__decap_4
X_5450_ _2467_ _2468_ _2469_ VGND VGND VPWR VPWR _2470_ sky130_fd_sc_hd__o21ai_4
XFILLER_0_112_525 VGND VGND VPWR VPWR sky130_fd_sc_hd__decap_6
X_4401_ _1225_ _1228_ _1446_ _1226_ VGND VGND VPWR VPWR _1447_ sky130_fd_sc_hd__o211a_1
XFILLER_0_2_701 VPWR VGND VPWR VGND sky130_ef_sc_hd__decap_12
XFILLER_0_41_125 VGND VGND VPWR VPWR sky130_fd_sc_hd__decap_6
X_5381_ _2342_ _2346_ VGND VGND VPWR VPWR _2406_ sky130_fd_sc_hd__and2_1
XFILLER_0_41_169 VPWR VGND VPWR VGND sky130_ef_sc_hd__decap_12
X_4332_ _1368_ _1378_ VGND VGND VPWR VPWR _1379_ sky130_fd_sc_hd__nand2_1
X_7120_ _4060_ _4059_ _4087_ _4088_ VGND VGND VPWR VPWR _4103_ sky130_fd_sc_hd__a211o_1
X_4263_ _1307_ _1309_ _1310_ VGND VGND VPWR VPWR _1311_ sky130_fd_sc_hd__nand3_4
X_7051_ _3979_ _3976_ _3971_ VGND VGND VPWR VPWR _4036_ sky130_fd_sc_hd__a21bo_1
X_6002_ net39 _2894_ VGND VGND VPWR VPWR _3010_ sky130_fd_sc_hd__nor2_1
XFILLER_0_10_589 VPWR VGND VPWR VGND sky130_ef_sc_hd__decap_12
XFILLER_0_66_64 VPWR VGND VPWR VGND sky130_ef_sc_hd__decap_12
XFILLER_0_82_41 VPWR VGND VPWR VGND sky130_ef_sc_hd__decap_12
X_7953_ _0800_ _0801_ VGND VGND VPWR VPWR _0802_ sky130_fd_sc_hd__nor2_1
X_6904_ _3891_ _3880_ VGND VGND VPWR VPWR _3892_ sky130_fd_sc_hd__nand2_1
XFILLER_0_49_214 VGND VGND VPWR VPWR sky130_fd_sc_hd__fill_1
XFILLER_0_82_85 VPWR VGND VPWR VGND sky130_ef_sc_hd__decap_12
XFILLER_0_77_556 VGND VGND VPWR VPWR sky130_fd_sc_hd__fill_1
X_7884_ sh3\[3\] VGND VGND VPWR VPWR _0734_ sky130_fd_sc_hd__clkbuf_4
XFILLER_0_49_225 VPWR VGND VPWR VGND sky130_ef_sc_hd__decap_12
XFILLER_0_119_135 VGND VGND VPWR VPWR sky130_fd_sc_hd__decap_4
XFILLER_0_119_113 VGND VGND VPWR VPWR sky130_fd_sc_hd__decap_6
XFILLER_0_65_729 VGND VGND VPWR VPWR sky130_fd_sc_hd__decap_6
XFILLER_0_18_601 VPWR VGND VPWR VGND sky130_ef_sc_hd__decap_12
X_6835_ _3800_ _3812_ _3808_ VGND VGND VPWR VPWR _3824_ sky130_fd_sc_hd__a21bo_1
XFILLER_0_9_377 VGND VGND VPWR VPWR sky130_fd_sc_hd__fill_1
XFILLER_0_9_355 VGND VGND VPWR VPWR sky130_fd_sc_hd__decap_8
XFILLER_0_17_111 VGND VGND VPWR VPWR sky130_fd_sc_hd__fill_1
XFILLER_0_17_122 VGND VGND VPWR VPWR sky130_fd_sc_hd__fill_2
XFILLER_0_18_645 VGND VGND VPWR VPWR sky130_fd_sc_hd__decap_3
X_6766_ _3743_ _3749_ _3754_ VGND VGND VPWR VPWR _3755_ sky130_fd_sc_hd__a21o_1
X_8505_ clknet_leaf_25_clk _0165_ _0256_ VGND VGND VPWR VPWR final_sum\[11\] sky130_fd_sc_hd__dfrtp_1
X_5717_ _2730_ _2732_ _2489_ VGND VGND VPWR VPWR _2733_ sky130_fd_sc_hd__o21bai_2
XFILLER_0_17_144 VGND VGND VPWR VPWR sky130_fd_sc_hd__fill_1
X_6697_ _3688_ _3689_ VGND VGND VPWR VPWR _3690_ sky130_fd_sc_hd__nor2_1
XFILLER_0_33_615 VGND VGND VPWR VPWR sky130_fd_sc_hd__fill_1
XFILLER_0_45_486 VPWR VGND VPWR VGND sky130_ef_sc_hd__decap_12
X_8436_ _1259_ _1263_ _1265_ VGND VGND VPWR VPWR _0102_ sky130_fd_sc_hd__a21oi_1
XFILLER_0_5_561 VGND VGND VPWR VPWR sky130_fd_sc_hd__decap_4
XFILLER_0_32_125 VPWR VGND VPWR VGND sky130_ef_sc_hd__decap_12
X_5648_ _2665_ VGND VGND VPWR VPWR _0174_ sky130_fd_sc_hd__clkbuf_1
XFILLER_0_103_558 VGND VGND VPWR VPWR sky130_fd_sc_hd__fill_2
X_8367_ sum5\[12\] s7\[12\] _1190_ VGND VGND VPWR VPWR _1201_ sky130_fd_sc_hd__a21bo_1
XFILLER_0_13_361 VPWR VGND VPWR VGND sky130_ef_sc_hd__decap_12
XFILLER_0_20_309 VGND VGND VPWR VPWR sky130_fd_sc_hd__fill_1
X_5579_ _2595_ _2596_ _2597_ VGND VGND VPWR VPWR _2598_ sky130_fd_sc_hd__a21o_1
Xhold240 sh13\[3\] VGND VGND VPWR VPWR net282 sky130_fd_sc_hd__dlygate4sd3_1
Xhold262 _0106_ VGND VGND VPWR VPWR net304 sky130_fd_sc_hd__dlygate4sd3_1
X_8298_ carry5\[5\] net302 VGND VGND VPWR VPWR _1138_ sky130_fd_sc_hd__and2_1
Xhold251 s2\[9\] VGND VGND VPWR VPWR net293 sky130_fd_sc_hd__dlygate4sd3_1
X_7318_ _4139_ VGND VGND VPWR VPWR _0336_ sky130_fd_sc_hd__inv_2
Xhold284 carry4\[13\] VGND VGND VPWR VPWR net326 sky130_fd_sc_hd__dlygate4sd3_1
X_7249_ _4132_ VGND VGND VPWR VPWR _0274_ sky130_fd_sc_hd__inv_2
Xhold273 sum4\[5\] VGND VGND VPWR VPWR net315 sky130_fd_sc_hd__dlygate4sd3_1
Xhold295 sh1\[1\] VGND VGND VPWR VPWR net337 sky130_fd_sc_hd__dlygate4sd3_1
XTAP_1700 VGND VPWR sky130_fd_sc_hd__tapvpwrvgnd_1
XTAP_1722 VGND VPWR sky130_fd_sc_hd__tapvpwrvgnd_1
XTAP_1733 VGND VPWR sky130_fd_sc_hd__tapvpwrvgnd_1
XTAP_1711 VGND VPWR sky130_fd_sc_hd__tapvpwrvgnd_1
XTAP_1766 VGND VPWR sky130_fd_sc_hd__tapvpwrvgnd_1
XTAP_1755 VGND VPWR sky130_fd_sc_hd__tapvpwrvgnd_1
XTAP_1744 VGND VPWR sky130_fd_sc_hd__tapvpwrvgnd_1
XTAP_1799 VGND VPWR sky130_fd_sc_hd__tapvpwrvgnd_1
XTAP_1788 VGND VPWR sky130_fd_sc_hd__tapvpwrvgnd_1
XTAP_1777 VGND VPWR sky130_fd_sc_hd__tapvpwrvgnd_1
XFILLER_0_95_386 VGND VGND VPWR VPWR sky130_fd_sc_hd__fill_2
XFILLER_0_83_537 VGND VGND VPWR VPWR sky130_fd_sc_hd__fill_1
XFILLER_0_11_15 VPWR VGND VPWR VGND sky130_ef_sc_hd__decap_12
XFILLER_0_23_125 VGND VGND VPWR VPWR sky130_fd_sc_hd__decap_3
XFILLER_0_23_169 VPWR VGND VPWR VGND sky130_ef_sc_hd__decap_12
Xinput8 x[6] VGND VGND VPWR VPWR net8 sky130_fd_sc_hd__clkbuf_1
X_4950_ _1910_ _1923_ _1926_ _1934_ _1930_ VGND VGND VPWR VPWR _1984_ sky130_fd_sc_hd__a32o_2
XFILLER_0_98_180 VGND VGND VPWR VPWR sky130_fd_sc_hd__decap_8
X_4881_ _1913_ _1835_ _1914_ _1915_ VGND VGND VPWR VPWR _1916_ sky130_fd_sc_hd__o2bb2ai_1
XFILLER_0_19_409 VGND VGND VPWR VPWR sky130_fd_sc_hd__fill_1
XFILLER_0_47_729 VGND VGND VPWR VPWR sky130_fd_sc_hd__decap_6
XFILLER_0_117_606 VGND VGND VPWR VPWR sky130_fd_sc_hd__decap_4
X_6620_ _3606_ _3608_ _3614_ VGND VGND VPWR VPWR _3615_ sky130_fd_sc_hd__o21ai_1
XFILLER_0_46_239 VPWR VGND VPWR VGND sky130_ef_sc_hd__decap_12
X_6551_ _3445_ _3509_ _3546_ VGND VGND VPWR VPWR _3547_ sky130_fd_sc_hd__o21a_1
XFILLER_0_27_431 VGND VGND VPWR VPWR sky130_fd_sc_hd__fill_1
XFILLER_0_15_615 VGND VGND VPWR VPWR sky130_fd_sc_hd__fill_1
X_5502_ sh13\[0\] VGND VGND VPWR VPWR _2521_ sky130_fd_sc_hd__clkbuf_4
X_6482_ _3478_ _3479_ sh13\[4\] _3475_ VGND VGND VPWR VPWR _3480_ sky130_fd_sc_hd__o211ai_2
XFILLER_0_54_294 VGND VGND VPWR VPWR sky130_fd_sc_hd__decap_4
XFILLER_0_14_125 VGND VGND VPWR VPWR sky130_fd_sc_hd__fill_1
XFILLER_0_14_114 VGND VGND VPWR VPWR sky130_fd_sc_hd__fill_2
XFILLER_0_42_434 VPWR VGND VPWR VGND sky130_ef_sc_hd__decap_12
X_8221_ _1004_ _1056_ _1057_ _1058_ _1060_ VGND VGND VPWR VPWR _1066_ sky130_fd_sc_hd__o221a_1
XFILLER_0_2_531 VGND VGND VPWR VPWR sky130_fd_sc_hd__fill_1
XFILLER_0_30_607 VGND VGND VPWR VPWR sky130_fd_sc_hd__decap_6
X_5433_ _2373_ _2427_ _2436_ VGND VGND VPWR VPWR _2456_ sky130_fd_sc_hd__o21ai_1
XFILLER_0_42_467 VGND VGND VPWR VPWR sky130_fd_sc_hd__decap_8
XFILLER_0_42_489 VPWR VGND VPWR VGND sky130_ef_sc_hd__decap_12
XFILLER_0_100_517 VGND VGND VPWR VPWR sky130_fd_sc_hd__decap_4
X_8152_ _0957_ _0961_ _0997_ _0949_ VGND VGND VPWR VPWR _0998_ sky130_fd_sc_hd__a22oi_2
X_5364_ _2373_ _2374_ _2376_ VGND VGND VPWR VPWR _2389_ sky130_fd_sc_hd__o21ai_2
XFILLER_0_112_399 VGND VGND VPWR VPWR sky130_fd_sc_hd__fill_2
XFILLER_0_112_377 VPWR VGND VPWR VGND sky130_ef_sc_hd__decap_12
X_4315_ _1242_ _1247_ VGND VGND VPWR VPWR _1362_ sky130_fd_sc_hd__nor2_1
X_7103_ _4084_ _4085_ _4086_ VGND VGND VPWR VPWR _4087_ sky130_fd_sc_hd__a21oi_2
XFILLER_0_22_191 VGND VGND VPWR VPWR sky130_fd_sc_hd__decap_4
X_8083_ _0763_ _0765_ _0892_ VGND VGND VPWR VPWR _0930_ sky130_fd_sc_hd__o21a_1
X_5295_ _2320_ VGND VGND VPWR VPWR _2321_ sky130_fd_sc_hd__clkbuf_4
X_4246_ _1238_ _1268_ _1287_ VGND VGND VPWR VPWR _1294_ sky130_fd_sc_hd__a21oi_1
X_7034_ _3715_ _3704_ VGND VGND VPWR VPWR _4019_ sky130_fd_sc_hd__nor2_1
XFILLER_0_93_51 VGND VGND VPWR VPWR sky130_fd_sc_hd__decap_4
XFILLER_0_93_73 VGND VGND VPWR VPWR sky130_fd_sc_hd__decap_4
XFILLER_0_97_629 VGND VGND VPWR VPWR sky130_fd_sc_hd__fill_1
XFILLER_0_96_106 VGND VGND VPWR VPWR sky130_fd_sc_hd__decap_8
XFILLER_0_77_331 VGND VGND VPWR VPWR sky130_fd_sc_hd__decap_4
XTAP_1029 VGND VPWR sky130_fd_sc_hd__tapvpwrvgnd_1
XTAP_1018 VGND VPWR sky130_fd_sc_hd__tapvpwrvgnd_1
XTAP_1007 VGND VPWR sky130_fd_sc_hd__tapvpwrvgnd_1
X_7936_ _0766_ _0770_ VGND VGND VPWR VPWR _0785_ sky130_fd_sc_hd__nand2_2
X_7867_ net251 sum2\[3\] VGND VGND VPWR VPWR _0719_ sky130_fd_sc_hd__nor2_1
XFILLER_0_65_526 VGND VGND VPWR VPWR sky130_fd_sc_hd__fill_1
X_6818_ _3802_ _3805_ _3804_ VGND VGND VPWR VPWR _3807_ sky130_fd_sc_hd__and3_1
XFILLER_0_107_105 VGND VGND VPWR VPWR sky130_fd_sc_hd__fill_1
XFILLER_0_65_559 VGND VGND VPWR VPWR sky130_fd_sc_hd__fill_1
XFILLER_0_18_431 VGND VGND VPWR VPWR sky130_fd_sc_hd__decap_8
X_7798_ net397 s1\[4\] _0684_ VGND VGND VPWR VPWR _0004_ sky130_fd_sc_hd__o21a_1
X_6749_ _3736_ _3737_ _3733_ VGND VGND VPWR VPWR _3738_ sky130_fd_sc_hd__nand3_2
XFILLER_0_18_475 VGND VGND VPWR VPWR sky130_fd_sc_hd__fill_1
XFILLER_0_45_261 VGND VGND VPWR VPWR sky130_fd_sc_hd__decap_4
X_8419_ sh6\[5\] sh5\[5\] VGND VGND VPWR VPWR _1249_ sky130_fd_sc_hd__and2_1
XFILLER_0_115_160 VGND VGND VPWR VPWR sky130_fd_sc_hd__decap_8
XFILLER_0_60_253 VGND VGND VPWR VPWR sky130_fd_sc_hd__decap_3
XFILLER_0_60_275 VGND VGND VPWR VPWR sky130_fd_sc_hd__decap_6
XFILLER_0_14_681 VPWR VGND VPWR VGND sky130_ef_sc_hd__decap_12
XTAP_1541 VGND VPWR sky130_fd_sc_hd__tapvpwrvgnd_1
XTAP_1530 VGND VPWR sky130_fd_sc_hd__tapvpwrvgnd_1
XFILLER_0_56_504 VPWR VGND VPWR VGND sky130_ef_sc_hd__decap_12
XFILLER_0_29_729 VGND VGND VPWR VPWR sky130_fd_sc_hd__decap_6
XFILLER_0_113_27 VPWR VGND VPWR VGND sky130_ef_sc_hd__decap_12
XTAP_1585 VGND VPWR sky130_fd_sc_hd__tapvpwrvgnd_1
XTAP_1574 VGND VPWR sky130_fd_sc_hd__tapvpwrvgnd_1
XTAP_1552 VGND VPWR sky130_fd_sc_hd__tapvpwrvgnd_1
XTAP_1563 VGND VPWR sky130_fd_sc_hd__tapvpwrvgnd_1
XPHY_70 VGND VGND VPWR VPWR sky130_fd_sc_hd__decap_3
XPHY_81 VGND VGND VPWR VPWR sky130_fd_sc_hd__decap_3
XPHY_92 VGND VGND VPWR VPWR sky130_fd_sc_hd__decap_3
XTAP_1596 VGND VPWR sky130_fd_sc_hd__tapvpwrvgnd_1
XFILLER_0_22_58 VGND VGND VPWR VPWR sky130_fd_sc_hd__decap_6
XFILLER_0_83_378 VPWR VGND VPWR VGND sky130_ef_sc_hd__decap_12
XFILLER_0_64_581 VGND VGND VPWR VPWR sky130_fd_sc_hd__fill_1
XFILLER_0_113_108 VGND VGND VPWR VPWR sky130_fd_sc_hd__decap_4
XFILLER_0_107_694 VPWR VGND VPWR VGND sky130_ef_sc_hd__decap_12
XFILLER_0_106_171 VGND VGND VPWR VPWR sky130_fd_sc_hd__fill_2
XFILLER_0_20_673 VPWR VGND VPWR VGND sky130_ef_sc_hd__decap_12
X_5080_ sh7\[2\] _2102_ VGND VGND VPWR VPWR _2109_ sky130_fd_sc_hd__or2_1
XFILLER_0_79_629 VGND VGND VPWR VPWR sky130_fd_sc_hd__decap_8
XFILLER_0_78_117 VPWR VGND VPWR VGND sky130_ef_sc_hd__decap_12
X_8770_ clknet_leaf_7_clk net189 _0521_ VGND VGND VPWR VPWR sh2\[6\] sky130_fd_sc_hd__dfrtp_1
X_5982_ _2981_ _2982_ _2983_ VGND VGND VPWR VPWR _2991_ sky130_fd_sc_hd__nand3_1
XFILLER_0_63_54 VGND VGND VPWR VPWR sky130_fd_sc_hd__fill_2
X_4933_ _1965_ _1966_ VGND VGND VPWR VPWR _1967_ sky130_fd_sc_hd__nor2_1
XFILLER_0_87_673 VPWR VGND VPWR VGND sky130_ef_sc_hd__decap_12
X_7721_ net268 _0632_ VGND VGND VPWR VPWR _0069_ sky130_fd_sc_hd__xnor2_1
XFILLER_0_86_172 VPWR VGND VPWR VGND sky130_ef_sc_hd__decap_12
XFILLER_0_74_301 VGND VGND VPWR VPWR sky130_fd_sc_hd__fill_1
XFILLER_0_47_548 VPWR VGND VPWR VGND sky130_ef_sc_hd__decap_12
X_4864_ _1892_ _1893_ _1894_ VGND VGND VPWR VPWR _1900_ sky130_fd_sc_hd__a21o_1
X_7652_ net373 _4178_ _4179_ VGND VGND VPWR VPWR _4181_ sky130_fd_sc_hd__or3_1
X_4795_ _1764_ _1754_ _1757_ _1830_ _1831_ VGND VGND VPWR VPWR _1832_ sky130_fd_sc_hd__a32o_1
X_7583_ _4165_ VGND VGND VPWR VPWR _0575_ sky130_fd_sc_hd__inv_2
X_6603_ _3596_ _3598_ VGND VGND VPWR VPWR _0122_ sky130_fd_sc_hd__xnor2_1
XFILLER_0_6_133 VGND VGND VPWR VPWR sky130_fd_sc_hd__decap_6
XFILLER_0_15_401 VGND VGND VPWR VPWR sky130_fd_sc_hd__decap_3
XFILLER_0_43_721 VGND VGND VPWR VPWR sky130_fd_sc_hd__decap_6
XFILLER_0_104_108 VGND VGND VPWR VPWR sky130_fd_sc_hd__fill_2
X_6534_ net27 _3469_ _3530_ VGND VGND VPWR VPWR _3531_ sky130_fd_sc_hd__a21o_1
XFILLER_0_6_177 VPWR VGND VPWR VGND sky130_ef_sc_hd__decap_12
XFILLER_0_70_573 VPWR VGND VPWR VGND sky130_ef_sc_hd__decap_12
X_6465_ _3442_ _3462_ _3434_ _3439_ VGND VGND VPWR VPWR _3463_ sky130_fd_sc_hd__o211a_1
XFILLER_0_42_253 VGND VGND VPWR VPWR sky130_fd_sc_hd__decap_4
XFILLER_0_112_141 VGND VGND VPWR VPWR sky130_fd_sc_hd__decap_4
XFILLER_0_70_3 VPWR VGND VPWR VGND sky130_ef_sc_hd__decap_12
X_5416_ _2399_ _2395_ _2439_ VGND VGND VPWR VPWR _2440_ sky130_fd_sc_hd__o21ai_2
X_8204_ _0925_ _0993_ _0994_ _1043_ VGND VGND VPWR VPWR _1049_ sky130_fd_sc_hd__o211a_1
XFILLER_0_113_697 VPWR VGND VPWR VGND sky130_ef_sc_hd__decap_12
X_6396_ _3382_ _3387_ _3394_ VGND VGND VPWR VPWR _3395_ sky130_fd_sc_hd__nand3_1
XFILLER_0_11_673 VPWR VGND VPWR VGND sky130_ef_sc_hd__decap_12
XFILLER_0_2_394 VGND VGND VPWR VPWR sky130_fd_sc_hd__decap_8
X_5347_ sh13\[2\] sh9\[2\] VGND VGND VPWR VPWR _2372_ sky130_fd_sc_hd__and2_1
X_8135_ _0927_ _0963_ _0966_ VGND VGND VPWR VPWR _0982_ sky130_fd_sc_hd__and3_1
XFILLER_0_10_194 VGND VGND VPWR VPWR sky130_fd_sc_hd__fill_2
X_5278_ _2302_ _2304_ _2296_ VGND VGND VPWR VPWR _2305_ sky130_fd_sc_hd__o21ai_4
X_8066_ _0855_ _0913_ _0853_ VGND VGND VPWR VPWR _0914_ sky130_fd_sc_hd__o21ai_1
X_4229_ _1276_ VGND VGND VPWR VPWR _1277_ sky130_fd_sc_hd__clkbuf_4
X_7017_ _3994_ _3999_ _4000_ VGND VGND VPWR VPWR _4003_ sky130_fd_sc_hd__and3_1
XFILLER_0_84_109 VPWR VGND VPWR VGND sky130_ef_sc_hd__decap_12
XFILLER_0_78_673 VGND VGND VPWR VPWR sky130_fd_sc_hd__decap_8
XFILLER_0_78_651 VGND VGND VPWR VPWR sky130_fd_sc_hd__decap_6
X_7919_ net35 _0762_ VGND VGND VPWR VPWR _0768_ sky130_fd_sc_hd__or2_1
XFILLER_0_108_425 VGND VGND VPWR VPWR sky130_fd_sc_hd__fill_1
XFILLER_0_93_676 VGND VGND VPWR VPWR sky130_fd_sc_hd__decap_8
XFILLER_0_53_518 VGND VGND VPWR VPWR sky130_fd_sc_hd__fill_1
XFILLER_0_123_417 VGND VGND VPWR VPWR sky130_fd_sc_hd__decap_3
XFILLER_0_92_197 VPWR VGND VPWR VGND sky130_ef_sc_hd__decap_12
XFILLER_0_61_573 VGND VGND VPWR VPWR sky130_fd_sc_hd__decap_3
XFILLER_0_0_309 VPWR VGND VPWR VGND sky130_ef_sc_hd__decap_12
XFILLER_0_104_697 VGND VGND VPWR VPWR sky130_fd_sc_hd__decap_3
XFILLER_0_108_27 VGND VGND VPWR VPWR sky130_fd_sc_hd__fill_1
XFILLER_0_69_673 VGND VGND VPWR VPWR sky130_fd_sc_hd__decap_8
XTAP_1393 VGND VPWR sky130_fd_sc_hd__tapvpwrvgnd_1
XTAP_1371 VGND VPWR sky130_fd_sc_hd__tapvpwrvgnd_1
XTAP_1382 VGND VPWR sky130_fd_sc_hd__tapvpwrvgnd_1
XTAP_1360 VGND VPWR sky130_fd_sc_hd__tapvpwrvgnd_1
X_4580_ _1621_ _1539_ VGND VGND VPWR VPWR _1622_ sky130_fd_sc_hd__nand2_1
XFILLER_0_83_197 VGND VGND VPWR VPWR sky130_fd_sc_hd__decap_8
XFILLER_0_37_581 VPWR VGND VPWR VGND sky130_ef_sc_hd__decap_12
XFILLER_0_3_125 VPWR VGND VPWR VGND sky130_ef_sc_hd__decap_12
XFILLER_0_40_713 VPWR VGND VPWR VGND sky130_ef_sc_hd__decap_12
XFILLER_0_3_169 VPWR VGND VPWR VGND sky130_ef_sc_hd__decap_12
X_6250_ _3193_ _3245_ _3248_ _3250_ VGND VGND VPWR VPWR _3254_ sky130_fd_sc_hd__o22ai_1
XFILLER_0_110_645 VGND VGND VPWR VPWR sky130_fd_sc_hd__decap_4
X_6181_ _3125_ _3131_ _3186_ VGND VGND VPWR VPWR _3187_ sky130_fd_sc_hd__a21o_1
X_5201_ _2154_ _2188_ _2225_ _2228_ VGND VGND VPWR VPWR _2229_ sky130_fd_sc_hd__o211ai_4
X_5132_ sh11\[2\] VGND VGND VPWR VPWR _2161_ sky130_fd_sc_hd__inv_2
X_5063_ _2090_ _2091_ VGND VGND VPWR VPWR _2092_ sky130_fd_sc_hd__nand2_1
XFILLER_0_74_53 VPWR VGND VPWR VGND sky130_ef_sc_hd__decap_12
XFILLER_0_74_97 VPWR VGND VPWR VGND sky130_ef_sc_hd__decap_12
X_8822_ clknet_leaf_62_clk net161 _0573_ VGND VGND VPWR VPWR sh9\[2\] sky130_fd_sc_hd__dfrtp_4
X_5965_ sh7\[6\] sh8\[6\] VGND VGND VPWR VPWR _2974_ sky130_fd_sc_hd__nand2_2
X_8753_ clknet_leaf_11_clk net7 _0504_ VGND VGND VPWR VPWR sh0\[5\] sky130_fd_sc_hd__dfrtp_4
XFILLER_0_90_41 VPWR VGND VPWR VGND sky130_ef_sc_hd__decap_12
XFILLER_0_59_161 VGND VGND VPWR VPWR sky130_fd_sc_hd__decap_6
XFILLER_0_118_701 VPWR VGND VPWR VGND sky130_ef_sc_hd__decap_12
X_4916_ _1833_ _1905_ _1906_ VGND VGND VPWR VPWR _1951_ sky130_fd_sc_hd__o21a_1
X_5896_ _2868_ _2905_ VGND VGND VPWR VPWR _0103_ sky130_fd_sc_hd__xor2_2
X_7704_ carry1\[10\] net261 net250 VGND VGND VPWR VPWR _4216_ sky130_fd_sc_hd__a21o_1
X_8684_ clknet_leaf_49_clk _0149_ _0435_ VGND VGND VPWR VPWR bit_sum1\[5\] sky130_fd_sc_hd__dfrtp_1
XFILLER_0_117_211 VGND VGND VPWR VPWR sky130_fd_sc_hd__decap_8
XFILLER_0_114_81 VGND VGND VPWR VPWR sky130_fd_sc_hd__decap_3
X_4847_ _1639_ _1722_ _1838_ VGND VGND VPWR VPWR _1883_ sky130_fd_sc_hd__a21o_1
XFILLER_0_90_624 VPWR VGND VPWR VGND sky130_ef_sc_hd__decap_12
X_7635_ _4122_ VGND VGND VPWR VPWR _0623_ sky130_fd_sc_hd__inv_2
XFILLER_0_28_570 VPWR VGND VPWR VGND sky130_ef_sc_hd__decap_12
X_4778_ _1805_ _1806_ _1810_ _1814_ VGND VGND VPWR VPWR _1815_ sky130_fd_sc_hd__nand4_1
X_7566_ _4164_ VGND VGND VPWR VPWR _0559_ sky130_fd_sc_hd__inv_2
XFILLER_0_120_409 VGND VGND VPWR VPWR sky130_fd_sc_hd__decap_4
X_7497_ _4156_ VGND VGND VPWR VPWR _0498_ sky130_fd_sc_hd__inv_2
X_6517_ _3508_ _3512_ _3513_ VGND VGND VPWR VPWR _3514_ sky130_fd_sc_hd__o21ai_2
X_6448_ _3357_ _3376_ VGND VGND VPWR VPWR _3446_ sky130_fd_sc_hd__nand2_1
X_6379_ _3376_ _3309_ _3377_ _3310_ VGND VGND VPWR VPWR _3378_ sky130_fd_sc_hd__o22ai_4
XFILLER_0_101_667 VGND VGND VPWR VPWR sky130_fd_sc_hd__decap_4
X_8118_ _0952_ _0954_ _0959_ VGND VGND VPWR VPWR _0965_ sky130_fd_sc_hd__o21a_1
X_8049_ _0890_ _0891_ _0895_ _0896_ VGND VGND VPWR VPWR _0897_ sky130_fd_sc_hd__a22oi_4
XFILLER_0_98_713 VPWR VGND VPWR VGND sky130_ef_sc_hd__decap_12
XFILLER_0_97_289 VGND VGND VPWR VPWR sky130_fd_sc_hd__decap_8
XFILLER_0_26_507 VGND VGND VPWR VPWR sky130_fd_sc_hd__decap_4
XFILLER_0_38_378 VGND VGND VPWR VPWR sky130_fd_sc_hd__fill_1
XFILLER_0_53_337 VGND VGND VPWR VPWR sky130_fd_sc_hd__decap_4
XFILLER_0_53_326 VGND VGND VPWR VPWR sky130_fd_sc_hd__fill_2
XFILLER_0_123_225 VPWR VGND VPWR VGND sky130_ef_sc_hd__decap_12
XFILLER_0_108_277 VGND VGND VPWR VPWR sky130_fd_sc_hd__fill_2
XFILLER_0_22_713 VPWR VGND VPWR VGND sky130_ef_sc_hd__decap_12
XFILLER_0_34_595 VGND VGND VPWR VPWR sky130_fd_sc_hd__fill_1
XFILLER_0_104_450 VGND VGND VPWR VPWR sky130_fd_sc_hd__decap_3
XFILLER_0_1_629 VPWR VGND VPWR VGND sky130_ef_sc_hd__decap_12
XFILLER_0_119_15 VPWR VGND VPWR VGND sky130_ef_sc_hd__decap_12
XTAP_429 VGND VPWR sky130_fd_sc_hd__tapvpwrvgnd_1
XTAP_418 VGND VPWR sky130_fd_sc_hd__tapvpwrvgnd_1
XTAP_407 VGND VPWR sky130_fd_sc_hd__tapvpwrvgnd_1
XFILLER_0_88_223 VGND VGND VPWR VPWR sky130_fd_sc_hd__decap_8
XFILLER_0_76_429 VGND VGND VPWR VPWR sky130_fd_sc_hd__decap_3
XFILLER_0_57_643 VGND VGND VPWR VPWR sky130_fd_sc_hd__decap_8
XFILLER_0_9_729 VGND VGND VPWR VPWR sky130_fd_sc_hd__decap_6
XFILLER_0_29_334 VGND VGND VPWR VPWR sky130_fd_sc_hd__fill_2
XFILLER_0_29_345 VGND VGND VPWR VPWR sky130_fd_sc_hd__decap_3
X_5750_ _2466_ _2712_ _2718_ VGND VGND VPWR VPWR _2766_ sky130_fd_sc_hd__o21ai_2
X_4701_ _1675_ _1677_ _1674_ _1679_ VGND VGND VPWR VPWR _1739_ sky130_fd_sc_hd__o22ai_1
XFILLER_0_72_624 VPWR VGND VPWR VGND sky130_ef_sc_hd__decap_12
XTAP_1190 VGND VPWR sky130_fd_sc_hd__tapvpwrvgnd_1
XFILLER_0_57_676 VPWR VGND VPWR VGND sky130_ef_sc_hd__decap_12
X_5681_ _2674_ _2675_ _2694_ _2697_ VGND VGND VPWR VPWR _2698_ sky130_fd_sc_hd__o211ai_2
X_4632_ _1659_ _1661_ _1669_ _1670_ VGND VGND VPWR VPWR _1671_ sky130_fd_sc_hd__a211oi_2
XFILLER_0_71_134 VGND VGND VPWR VPWR sky130_fd_sc_hd__decap_3
X_7420_ _4149_ VGND VGND VPWR VPWR _0428_ sky130_fd_sc_hd__inv_2
X_4563_ _1543_ _1568_ _1566_ VGND VGND VPWR VPWR _1606_ sky130_fd_sc_hd__o21a_1
X_7351_ _4142_ VGND VGND VPWR VPWR _0366_ sky130_fd_sc_hd__inv_2
X_4494_ _1537_ _1533_ _1480_ _1475_ VGND VGND VPWR VPWR _1538_ sky130_fd_sc_hd__a22oi_1
X_6302_ sh4\[4\] VGND VGND VPWR VPWR _3302_ sky130_fd_sc_hd__clkbuf_4
X_7282_ _4135_ VGND VGND VPWR VPWR _0304_ sky130_fd_sc_hd__inv_2
X_6233_ _3069_ _3133_ _3237_ VGND VGND VPWR VPWR _3238_ sky130_fd_sc_hd__o21ai_2
XFILLER_0_100_83 VGND VGND VPWR VPWR sky130_fd_sc_hd__fill_1
XFILLER_0_110_475 VGND VGND VPWR VPWR sky130_fd_sc_hd__fill_1
XFILLER_0_0_673 VPWR VGND VPWR VGND sky130_ef_sc_hd__decap_12
X_6164_ _3092_ _3149_ _3156_ _3153_ VGND VGND VPWR VPWR _3170_ sky130_fd_sc_hd__o211a_2
XTAP_941 VGND VPWR sky130_fd_sc_hd__tapvpwrvgnd_1
XTAP_952 VGND VPWR sky130_fd_sc_hd__tapvpwrvgnd_1
XTAP_930 VGND VPWR sky130_fd_sc_hd__tapvpwrvgnd_1
X_6095_ _3097_ _3101_ VGND VGND VPWR VPWR _3102_ sky130_fd_sc_hd__nand2_1
XTAP_996 VGND VPWR sky130_fd_sc_hd__tapvpwrvgnd_1
XTAP_985 VGND VPWR sky130_fd_sc_hd__tapvpwrvgnd_1
XTAP_974 VGND VPWR sky130_fd_sc_hd__tapvpwrvgnd_1
XTAP_963 VGND VPWR sky130_fd_sc_hd__tapvpwrvgnd_1
X_5115_ _2090_ _2091_ _2086_ VGND VGND VPWR VPWR _2144_ sky130_fd_sc_hd__o21a_1
X_5046_ _2070_ _2075_ VGND VGND VPWR VPWR _2076_ sky130_fd_sc_hd__nand2_1
XFILLER_0_33_3 VPWR VGND VPWR VGND sky130_ef_sc_hd__decap_12
X_6997_ _3980_ _3979_ VGND VGND VPWR VPWR _3983_ sky130_fd_sc_hd__nand2_1
X_8805_ clknet_leaf_61_clk net411 _0556_ VGND VGND VPWR VPWR sh7\[1\] sky130_fd_sc_hd__dfrtp_4
XFILLER_0_39_109 VGND VGND VPWR VPWR sky130_fd_sc_hd__decap_3
X_5948_ _2951_ _2954_ _2955_ _2956_ VGND VGND VPWR VPWR _2957_ sky130_fd_sc_hd__o211ai_4
X_8736_ clknet_leaf_16_clk _0142_ _0487_ VGND VGND VPWR VPWR bit_sum6\[7\] sky130_fd_sc_hd__dfrtp_1
XFILLER_0_48_643 VGND VGND VPWR VPWR sky130_fd_sc_hd__fill_1
XFILLER_0_118_531 VGND VGND VPWR VPWR sky130_fd_sc_hd__fill_1
XFILLER_0_75_473 VGND VGND VPWR VPWR sky130_fd_sc_hd__decap_4
XFILLER_0_63_602 VGND VGND VPWR VPWR sky130_fd_sc_hd__decap_8
XFILLER_0_47_153 VGND VGND VPWR VPWR sky130_fd_sc_hd__decap_4
XFILLER_0_48_665 VGND VGND VPWR VPWR sky130_fd_sc_hd__fill_2
XFILLER_0_48_687 VGND VGND VPWR VPWR sky130_fd_sc_hd__decap_4
X_5879_ sh1\[6\] VGND VGND VPWR VPWR _2889_ sky130_fd_sc_hd__clkbuf_4
X_8667_ clknet_leaf_24_clk net145 _0418_ VGND VGND VPWR VPWR s7\[14\] sky130_fd_sc_hd__dfrtp_1
XFILLER_0_47_186 VGND VGND VPWR VPWR sky130_fd_sc_hd__decap_3
XFILLER_0_118_597 VGND VGND VPWR VPWR sky130_fd_sc_hd__decap_3
XFILLER_0_63_679 VGND VGND VPWR VPWR sky130_fd_sc_hd__decap_3
X_7618_ _4168_ VGND VGND VPWR VPWR _0607_ sky130_fd_sc_hd__inv_2
X_8598_ clknet_leaf_54_clk _0050_ _0349_ VGND VGND VPWR VPWR sum1\[10\] sky130_fd_sc_hd__dfrtp_1
XFILLER_0_50_307 VGND VGND VPWR VPWR sky130_fd_sc_hd__fill_1
X_7549_ _4162_ VGND VGND VPWR VPWR _0544_ sky130_fd_sc_hd__inv_2
XFILLER_0_50_329 VGND VGND VPWR VPWR sky130_fd_sc_hd__fill_1
XFILLER_0_121_729 VGND VGND VPWR VPWR sky130_fd_sc_hd__decap_6
XFILLER_0_31_598 VPWR VGND VPWR VGND sky130_ef_sc_hd__decap_12
XFILLER_0_105_39 VGND VGND VPWR VPWR sky130_fd_sc_hd__decap_8
XFILLER_0_14_15 VPWR VGND VPWR VGND sky130_ef_sc_hd__decap_12
XFILLER_0_85_259 VGND VGND VPWR VPWR sky130_fd_sc_hd__decap_6
XFILLER_0_66_440 VGND VGND VPWR VPWR sky130_fd_sc_hd__fill_1
XPHY_240 VGND VGND VPWR VPWR sky130_fd_sc_hd__decap_3
XFILLER_0_39_665 VGND VGND VPWR VPWR sky130_fd_sc_hd__decap_6
XFILLER_0_121_27 VPWR VGND VPWR VGND sky130_ef_sc_hd__decap_12
XFILLER_0_93_281 VPWR VGND VPWR VGND sky130_ef_sc_hd__decap_12
XFILLER_0_38_197 VPWR VGND VPWR VGND sky130_ef_sc_hd__decap_12
XFILLER_0_81_443 VGND VGND VPWR VPWR sky130_fd_sc_hd__fill_2
XFILLER_0_54_668 VGND VGND VPWR VPWR sky130_fd_sc_hd__fill_2
XFILLER_0_34_370 VGND VGND VPWR VPWR sky130_fd_sc_hd__decap_4
XFILLER_0_1_437 VGND VGND VPWR VPWR sky130_fd_sc_hd__decap_8
XTAP_248 VGND VPWR sky130_fd_sc_hd__tapvpwrvgnd_1
XTAP_259 VGND VPWR sky130_fd_sc_hd__tapvpwrvgnd_1
XFILLER_0_55_44 VPWR VGND VPWR VGND sky130_ef_sc_hd__decap_12
XFILLER_0_55_33 VGND VGND VPWR VPWR sky130_fd_sc_hd__decap_3
XFILLER_0_55_88 VGND VGND VPWR VPWR sky130_fd_sc_hd__fill_2
X_6920_ _3832_ _3835_ _3850_ VGND VGND VPWR VPWR _3907_ sky130_fd_sc_hd__o21ai_1
XFILLER_0_77_727 VGND VGND VPWR VPWR sky130_fd_sc_hd__fill_1
X_6851_ _3837_ _3838_ _3710_ VGND VGND VPWR VPWR _3839_ sky130_fd_sc_hd__o21bai_4
XFILLER_0_29_120 VGND VGND VPWR VPWR sky130_fd_sc_hd__decap_3
X_5802_ _2768_ _2771_ _2816_ VGND VGND VPWR VPWR _2817_ sky130_fd_sc_hd__a21o_1
X_8521_ clknet_leaf_27_clk _0091_ _0272_ VGND VGND VPWR VPWR sum5\[11\] sky130_fd_sc_hd__dfrtp_1
X_6782_ _3765_ _3770_ VGND VGND VPWR VPWR _3771_ sky130_fd_sc_hd__nand2_2
XFILLER_0_84_292 VGND VGND VPWR VPWR sky130_fd_sc_hd__fill_1
XFILLER_0_17_337 VGND VGND VPWR VPWR sky130_fd_sc_hd__decap_6
X_5733_ _2524_ _2748_ _2533_ VGND VGND VPWR VPWR _2749_ sky130_fd_sc_hd__a21oi_4
X_8452_ clknet_leaf_33_clk net403 _0203_ VGND VGND VPWR VPWR carry3\[7\] sky130_fd_sc_hd__dfrtp_1
XFILLER_0_60_605 VPWR VGND VPWR VGND sky130_ef_sc_hd__decap_12
X_5664_ _2680_ _2485_ VGND VGND VPWR VPWR _2681_ sky130_fd_sc_hd__nand2_1
XFILLER_0_17_359 VPWR VGND VPWR VGND sky130_ef_sc_hd__decap_12
X_4615_ _1650_ _1651_ _1653_ VGND VGND VPWR VPWR _1654_ sky130_fd_sc_hd__o21ai_1
X_7403_ _4148_ VGND VGND VPWR VPWR _0412_ sky130_fd_sc_hd__inv_2
X_8383_ _1199_ _1200_ _1201_ _1206_ _1214_ VGND VGND VPWR VPWR _1216_ sky130_fd_sc_hd__a311oi_1
XFILLER_0_25_370 VGND VGND VPWR VPWR sky130_fd_sc_hd__fill_1
X_5595_ _2612_ _2609_ _2607_ VGND VGND VPWR VPWR _2613_ sky130_fd_sc_hd__a21oi_2
XFILLER_0_32_307 VGND VGND VPWR VPWR sky130_fd_sc_hd__fill_1
XFILLER_0_103_729 VGND VGND VPWR VPWR sky130_fd_sc_hd__decap_6
X_4546_ _1534_ _1539_ _1589_ VGND VGND VPWR VPWR _1590_ sky130_fd_sc_hd__a21o_1
XFILLER_0_4_253 VGND VGND VPWR VPWR sky130_fd_sc_hd__decap_6
X_7334_ _4141_ VGND VGND VPWR VPWR _0350_ sky130_fd_sc_hd__inv_2
Xhold400 carry1\[1\] VGND VGND VPWR VPWR net442 sky130_fd_sc_hd__dlygate4sd3_1
XFILLER_0_13_565 VGND VGND VPWR VPWR sky130_fd_sc_hd__fill_1
X_4477_ _1444_ _1448_ _1514_ _1518_ _1442_ VGND VGND VPWR VPWR _1522_ sky130_fd_sc_hd__o2111ai_4
X_7265_ _4125_ VGND VGND VPWR VPWR _4134_ sky130_fd_sc_hd__clkbuf_8
X_6216_ _3170_ _3163_ _3216_ _3220_ VGND VGND VPWR VPWR _3221_ sky130_fd_sc_hd__o211ai_4
X_7196_ _4127_ VGND VGND VPWR VPWR _0226_ sky130_fd_sc_hd__inv_2
X_6147_ _3151_ _3152_ _3148_ VGND VGND VPWR VPWR _3153_ sky130_fd_sc_hd__o21bai_4
XTAP_760 VGND VPWR sky130_fd_sc_hd__tapvpwrvgnd_1
XTAP_782 VGND VPWR sky130_fd_sc_hd__tapvpwrvgnd_1
XTAP_771 VGND VPWR sky130_fd_sc_hd__tapvpwrvgnd_1
XTAP_793 VGND VPWR sky130_fd_sc_hd__tapvpwrvgnd_1
X_6078_ _3079_ _3082_ _3083_ _3084_ VGND VGND VPWR VPWR _3085_ sky130_fd_sc_hd__o2bb2ai_2
X_5029_ _2056_ _2057_ _2058_ VGND VGND VPWR VPWR _2059_ sky130_fd_sc_hd__nand3_1
XFILLER_0_95_546 VGND VGND VPWR VPWR sky130_fd_sc_hd__decap_3
XFILLER_0_67_248 VGND VGND VPWR VPWR sky130_fd_sc_hd__decap_6
XFILLER_0_36_602 VPWR VGND VPWR VGND sky130_ef_sc_hd__decap_12
X_8719_ clknet_leaf_14_clk _0102_ _0470_ VGND VGND VPWR VPWR bit_sum5\[0\] sky130_fd_sc_hd__dfrtp_1
XFILLER_0_63_432 VGND VGND VPWR VPWR sky130_fd_sc_hd__decap_6
XFILLER_0_90_251 VGND VGND VPWR VPWR sky130_fd_sc_hd__fill_1
XFILLER_0_63_465 VGND VGND VPWR VPWR sky130_fd_sc_hd__fill_1
XFILLER_0_8_581 VGND VGND VPWR VPWR sky130_fd_sc_hd__fill_1
XFILLER_0_36_657 VPWR VGND VPWR VGND sky130_ef_sc_hd__decap_12
XFILLER_0_31_340 VGND VGND VPWR VPWR sky130_fd_sc_hd__decap_8
XFILLER_0_116_27 VGND VGND VPWR VPWR sky130_fd_sc_hd__fill_1
XFILLER_0_98_351 VPWR VGND VPWR VGND sky130_ef_sc_hd__decap_12
XFILLER_0_98_384 VPWR VGND VPWR VGND sky130_ef_sc_hd__decap_12
XFILLER_0_58_215 VGND VGND VPWR VPWR sky130_fd_sc_hd__fill_1
XFILLER_0_86_579 VGND VGND VPWR VPWR sky130_fd_sc_hd__decap_8
XFILLER_0_54_421 VGND VGND VPWR VPWR sky130_fd_sc_hd__fill_1
XFILLER_0_27_624 VGND VGND VPWR VPWR sky130_fd_sc_hd__decap_6
XFILLER_0_39_495 VGND VGND VPWR VPWR sky130_fd_sc_hd__decap_8
XFILLER_0_41_57 VPWR VGND VPWR VGND sky130_ef_sc_hd__decap_12
X_4400_ _1440_ _1354_ VGND VGND VPWR VPWR _1446_ sky130_fd_sc_hd__nand2_1
XFILLER_0_2_713 VPWR VGND VPWR VGND sky130_ef_sc_hd__decap_12
XFILLER_0_1_223 VGND VGND VPWR VPWR sky130_fd_sc_hd__fill_1
X_5380_ _2370_ _2402_ _2404_ VGND VGND VPWR VPWR _2405_ sky130_fd_sc_hd__o21ai_1
X_4331_ _1355_ _1354_ _1363_ VGND VGND VPWR VPWR _1378_ sky130_fd_sc_hd__o21a_1
X_4262_ _1302_ _1292_ _1296_ VGND VGND VPWR VPWR _1310_ sky130_fd_sc_hd__nand3b_4
XFILLER_0_1_289 VGND VGND VPWR VPWR sky130_fd_sc_hd__decap_4
X_7050_ _4030_ _4031_ _4034_ VGND VGND VPWR VPWR _4035_ sky130_fd_sc_hd__nand3_2
X_6001_ net39 _2894_ sh7\[6\] VGND VGND VPWR VPWR _3009_ sky130_fd_sc_hd__o21ai_2
XFILLER_0_5_57 VPWR VGND VPWR VGND sky130_ef_sc_hd__decap_12
XFILLER_0_66_76 VGND VGND VPWR VPWR sky130_fd_sc_hd__decap_3
X_7952_ _0799_ _0795_ _0796_ VGND VGND VPWR VPWR _0801_ sky130_fd_sc_hd__and3_1
XFILLER_0_82_53 VPWR VGND VPWR VGND sky130_ef_sc_hd__decap_12
X_6903_ _3884_ _3885_ _3887_ _3890_ VGND VGND VPWR VPWR _3891_ sky130_fd_sc_hd__a31oi_4
XFILLER_0_82_97 VPWR VGND VPWR VGND sky130_ef_sc_hd__decap_12
X_7883_ _0732_ VGND VGND VPWR VPWR _0733_ sky130_fd_sc_hd__clkbuf_8
XFILLER_0_9_301 VGND VGND VPWR VPWR sky130_fd_sc_hd__fill_1
XFILLER_0_49_237 VPWR VGND VPWR VGND sky130_ef_sc_hd__decap_12
X_6834_ _3808_ _3812_ _3800_ VGND VGND VPWR VPWR _3823_ sky130_fd_sc_hd__nand3b_1
XFILLER_0_107_309 VPWR VGND VPWR VGND sky130_ef_sc_hd__decap_12
XFILLER_0_57_281 VPWR VGND VPWR VGND sky130_ef_sc_hd__decap_12
XFILLER_0_18_613 VGND VGND VPWR VPWR sky130_fd_sc_hd__decap_4
X_6765_ _3723_ _3751_ _3753_ VGND VGND VPWR VPWR _3754_ sky130_fd_sc_hd__o21ai_2
X_8504_ clknet_leaf_25_clk _0164_ _0255_ VGND VGND VPWR VPWR final_sum\[10\] sky130_fd_sc_hd__dfrtp_1
X_5716_ _2484_ _2491_ VGND VGND VPWR VPWR _2732_ sky130_fd_sc_hd__nor2_1
X_8435_ _1264_ _1259_ net440 VGND VGND VPWR VPWR _1265_ sky130_fd_sc_hd__a21oi_1
X_6696_ _3660_ _3658_ _3666_ _3672_ VGND VGND VPWR VPWR _3689_ sky130_fd_sc_hd__a22oi_2
XFILLER_0_60_413 VGND VGND VPWR VPWR sky130_fd_sc_hd__fill_2
XFILLER_0_17_189 VGND VGND VPWR VPWR sky130_fd_sc_hd__decap_6
XFILLER_0_45_498 VGND VGND VPWR VPWR sky130_fd_sc_hd__decap_6
XFILLER_0_115_353 VPWR VGND VPWR VGND sky130_ef_sc_hd__decap_12
XFILLER_0_32_137 VGND VGND VPWR VPWR sky130_fd_sc_hd__decap_3
XFILLER_0_32_148 VGND VGND VPWR VPWR sky130_fd_sc_hd__fill_1
XFILLER_0_33_649 VGND VGND VPWR VPWR sky130_fd_sc_hd__fill_1
X_5647_ _2663_ _2664_ VGND VGND VPWR VPWR _2665_ sky130_fd_sc_hd__and2_1
X_8366_ _1197_ _1198_ carry5\[12\] VGND VGND VPWR VPWR _1200_ sky130_fd_sc_hd__o21bai_1
XFILLER_0_5_595 VPWR VGND VPWR VGND sky130_ef_sc_hd__decap_12
X_5578_ _2533_ _2536_ _2535_ VGND VGND VPWR VPWR _2597_ sky130_fd_sc_hd__a21bo_1
X_4529_ _1567_ _1570_ _1572_ VGND VGND VPWR VPWR _1573_ sky130_fd_sc_hd__a21oi_4
Xhold241 sh11\[3\] VGND VGND VPWR VPWR net283 sky130_fd_sc_hd__dlygate4sd3_1
Xhold252 sh10\[3\] VGND VGND VPWR VPWR net294 sky130_fd_sc_hd__dlygate4sd3_1
Xhold230 _0070_ VGND VGND VPWR VPWR net272 sky130_fd_sc_hd__dlygate4sd3_1
X_8297_ carry5\[5\] net302 VGND VGND VPWR VPWR _1137_ sky130_fd_sc_hd__nor2_1
XFILLER_0_13_373 VGND VGND VPWR VPWR sky130_fd_sc_hd__decap_6
X_7317_ _4139_ VGND VGND VPWR VPWR _0335_ sky130_fd_sc_hd__inv_2
Xhold285 _0044_ VGND VGND VPWR VPWR net327 sky130_fd_sc_hd__dlygate4sd3_1
X_7248_ _4132_ VGND VGND VPWR VPWR _0273_ sky130_fd_sc_hd__inv_2
Xhold274 _0708_ VGND VGND VPWR VPWR net316 sky130_fd_sc_hd__dlygate4sd3_1
Xhold296 sh6\[0\] VGND VGND VPWR VPWR net338 sky130_fd_sc_hd__dlygate4sd3_1
Xhold263 s3\[4\] VGND VGND VPWR VPWR net305 sky130_fd_sc_hd__buf_1
X_7179_ _4126_ VGND VGND VPWR VPWR _0210_ sky130_fd_sc_hd__inv_2
XFILLER_0_99_104 VGND VGND VPWR VPWR sky130_fd_sc_hd__fill_1
XTAP_590 VGND VPWR sky130_fd_sc_hd__tapvpwrvgnd_1
XFILLER_0_99_137 VGND VGND VPWR VPWR sky130_fd_sc_hd__decap_4
XFILLER_0_68_513 VGND VGND VPWR VPWR sky130_fd_sc_hd__fill_1
XFILLER_0_68_502 VGND VGND VPWR VPWR sky130_fd_sc_hd__decap_4
XTAP_1723 VGND VPWR sky130_fd_sc_hd__tapvpwrvgnd_1
XTAP_1734 VGND VPWR sky130_fd_sc_hd__tapvpwrvgnd_1
XTAP_1712 VGND VPWR sky130_fd_sc_hd__tapvpwrvgnd_1
XTAP_1701 VGND VPWR sky130_fd_sc_hd__tapvpwrvgnd_1
XTAP_1767 VGND VPWR sky130_fd_sc_hd__tapvpwrvgnd_1
XTAP_1756 VGND VPWR sky130_fd_sc_hd__tapvpwrvgnd_1
XTAP_1745 VGND VPWR sky130_fd_sc_hd__tapvpwrvgnd_1
XFILLER_0_83_516 VGND VGND VPWR VPWR sky130_fd_sc_hd__fill_1
XFILLER_0_55_207 VGND VGND VPWR VPWR sky130_fd_sc_hd__fill_2
XTAP_1789 VGND VPWR sky130_fd_sc_hd__tapvpwrvgnd_1
XTAP_1778 VGND VPWR sky130_fd_sc_hd__tapvpwrvgnd_1
XFILLER_0_36_421 VPWR VGND VPWR VGND sky130_ef_sc_hd__decap_12
XFILLER_0_118_180 VGND VGND VPWR VPWR sky130_fd_sc_hd__fill_1
XFILLER_0_11_27 VPWR VGND VPWR VGND sky130_ef_sc_hd__decap_12
XFILLER_0_31_181 VGND VGND VPWR VPWR sky130_fd_sc_hd__fill_1
Xinput9 x[7] VGND VGND VPWR VPWR net9 sky130_fd_sc_hd__clkbuf_1
XFILLER_0_99_671 VGND VGND VPWR VPWR sky130_fd_sc_hd__fill_1
XFILLER_0_86_321 VGND VGND VPWR VPWR sky130_fd_sc_hd__decap_8
X_4880_ _1652_ _1641_ VGND VGND VPWR VPWR _1915_ sky130_fd_sc_hd__and2_2
XFILLER_0_47_708 VGND VGND VPWR VPWR sky130_fd_sc_hd__decap_3
XFILLER_0_46_218 VGND VGND VPWR VPWR sky130_fd_sc_hd__decap_8
X_6550_ _3292_ _3288_ _3507_ VGND VGND VPWR VPWR _3546_ sky130_fd_sc_hd__a21o_1
XFILLER_0_39_281 VPWR VGND VPWR VGND sky130_ef_sc_hd__decap_12
XFILLER_0_6_337 VGND VGND VPWR VPWR sky130_fd_sc_hd__decap_3
X_5501_ net36 sh8\[0\] VGND VGND VPWR VPWR _2520_ sky130_fd_sc_hd__and2_1
XFILLER_0_42_413 VGND VGND VPWR VPWR sky130_fd_sc_hd__decap_6
X_6481_ _3474_ _3471_ VGND VGND VPWR VPWR _3479_ sky130_fd_sc_hd__nand2_1
XFILLER_0_15_638 VGND VGND VPWR VPWR sky130_fd_sc_hd__decap_8
XFILLER_0_42_446 VGND VGND VPWR VPWR sky130_fd_sc_hd__decap_8
X_8220_ _1052_ _1053_ _1055_ _1061_ _1064_ VGND VGND VPWR VPWR _1065_ sky130_fd_sc_hd__o2111ai_4
X_5432_ _2407_ _2404_ _2443_ _2444_ VGND VGND VPWR VPWR _2455_ sky130_fd_sc_hd__o211ai_2
XFILLER_0_112_345 VGND VGND VPWR VPWR sky130_fd_sc_hd__fill_1
X_8151_ _0942_ _0945_ VGND VGND VPWR VPWR _0997_ sky130_fd_sc_hd__nand2_1
X_5363_ _2383_ _2381_ _2384_ VGND VGND VPWR VPWR _2388_ sky130_fd_sc_hd__a21oi_2
X_4314_ _1288_ _1356_ _1357_ _1358_ _1360_ VGND VGND VPWR VPWR _1361_ sky130_fd_sc_hd__o221ai_4
X_7102_ _3986_ _4050_ _4051_ VGND VGND VPWR VPWR _4086_ sky130_fd_sc_hd__o21ai_2
XFILLER_0_10_321 VGND VGND VPWR VPWR sky130_fd_sc_hd__decap_4
XFILLER_0_2_587 VGND VGND VPWR VPWR sky130_fd_sc_hd__fill_1
X_8082_ _0877_ _0878_ _0928_ _0873_ VGND VGND VPWR VPWR _0929_ sky130_fd_sc_hd__o22ai_2
XFILLER_0_10_365 VPWR VGND VPWR VGND sky130_ef_sc_hd__decap_12
X_5294_ _2052_ net38 VGND VGND VPWR VPWR _2320_ sky130_fd_sc_hd__and2_1
X_4245_ sh0\[5\] sh3\[5\] _1242_ VGND VGND VPWR VPWR _1293_ sky130_fd_sc_hd__a21o_2
X_7033_ sh4\[1\] _3703_ VGND VGND VPWR VPWR _4018_ sky130_fd_sc_hd__and2_2
XFILLER_0_97_608 VGND VGND VPWR VPWR sky130_fd_sc_hd__decap_8
XTAP_1019 VGND VPWR sky130_fd_sc_hd__tapvpwrvgnd_1
XTAP_1008 VGND VPWR sky130_fd_sc_hd__tapvpwrvgnd_1
X_7935_ _0766_ _0770_ _0778_ _0783_ VGND VGND VPWR VPWR _0784_ sky130_fd_sc_hd__a22o_1
X_7866_ _0034_ net298 VGND VGND VPWR VPWR _0084_ sky130_fd_sc_hd__nor2_1
Xclkbuf_leaf_62_clk clknet_3_0__leaf_clk VGND VGND VPWR VPWR clknet_leaf_62_clk sky130_fd_sc_hd__clkbuf_16
X_6817_ _3802_ _3804_ _3805_ VGND VGND VPWR VPWR _3806_ sky130_fd_sc_hd__a21oi_1
XFILLER_0_18_421 VGND VGND VPWR VPWR sky130_fd_sc_hd__decap_3
X_7797_ net397 s1\[4\] net237 VGND VGND VPWR VPWR _0684_ sky130_fd_sc_hd__a21o_1
XFILLER_0_107_139 VGND VGND VPWR VPWR sky130_fd_sc_hd__fill_1
X_6748_ sh0\[1\] sh3\[1\] VGND VGND VPWR VPWR _3737_ sky130_fd_sc_hd__or2_1
XFILLER_0_122_109 VPWR VGND VPWR VGND sky130_ef_sc_hd__decap_12
X_6679_ _3576_ VGND VGND VPWR VPWR _3673_ sky130_fd_sc_hd__inv_2
XFILLER_0_33_446 VGND VGND VPWR VPWR sky130_fd_sc_hd__fill_2
X_8418_ _1246_ _1247_ VGND VGND VPWR VPWR _1248_ sky130_fd_sc_hd__nor2_1
XFILLER_0_103_301 VGND VGND VPWR VPWR sky130_fd_sc_hd__fill_1
XFILLER_0_103_356 VGND VGND VPWR VPWR sky130_fd_sc_hd__fill_2
X_8349_ _1183_ _1184_ VGND VGND VPWR VPWR _1185_ sky130_fd_sc_hd__nor2_1
XFILLER_0_14_693 VGND VGND VPWR VPWR sky130_fd_sc_hd__decap_6
XTAP_1542 VGND VPWR sky130_fd_sc_hd__tapvpwrvgnd_1
XTAP_1531 VGND VPWR sky130_fd_sc_hd__tapvpwrvgnd_1
XTAP_1520 VGND VPWR sky130_fd_sc_hd__tapvpwrvgnd_1
Xclkbuf_leaf_53_clk clknet_3_4__leaf_clk VGND VGND VPWR VPWR clknet_leaf_53_clk sky130_fd_sc_hd__clkbuf_16
XTAP_1575 VGND VPWR sky130_fd_sc_hd__tapvpwrvgnd_1
XTAP_1553 VGND VPWR sky130_fd_sc_hd__tapvpwrvgnd_1
XTAP_1564 VGND VPWR sky130_fd_sc_hd__tapvpwrvgnd_1
XFILLER_0_56_516 VPWR VGND VPWR VGND sky130_ef_sc_hd__decap_12
XFILLER_0_22_15 VPWR VGND VPWR VGND sky130_ef_sc_hd__decap_12
XPHY_60 VGND VGND VPWR VPWR sky130_fd_sc_hd__decap_3
XPHY_71 VGND VGND VPWR VPWR sky130_fd_sc_hd__decap_3
XPHY_82 VGND VGND VPWR VPWR sky130_fd_sc_hd__decap_3
XFILLER_0_113_39 VPWR VGND VPWR VGND sky130_ef_sc_hd__decap_12
XTAP_1597 VGND VPWR sky130_fd_sc_hd__tapvpwrvgnd_1
XTAP_1586 VGND VPWR sky130_fd_sc_hd__tapvpwrvgnd_1
XFILLER_0_95_195 VPWR VGND VPWR VGND sky130_ef_sc_hd__decap_12
XFILLER_0_83_335 VGND VGND VPWR VPWR sky130_fd_sc_hd__fill_1
XFILLER_0_22_37 VGND VGND VPWR VPWR sky130_fd_sc_hd__fill_1
XPHY_93 VGND VGND VPWR VPWR sky130_fd_sc_hd__decap_3
XFILLER_0_3_307 VGND VGND VPWR VPWR sky130_fd_sc_hd__decap_8
XFILLER_0_122_632 VPWR VGND VPWR VGND sky130_ef_sc_hd__decap_12
XFILLER_0_122_610 VGND VGND VPWR VPWR sky130_fd_sc_hd__decap_4
XFILLER_0_51_265 VGND VGND VPWR VPWR sky130_fd_sc_hd__fill_1
XFILLER_0_20_685 VPWR VGND VPWR VGND sky130_ef_sc_hd__decap_12
X_5981_ _2868_ _2905_ _2947_ _2948_ _2989_ VGND VGND VPWR VPWR _2990_ sky130_fd_sc_hd__o311a_1
XFILLER_0_78_129 VGND VGND VPWR VPWR sky130_fd_sc_hd__decap_8
XFILLER_0_59_321 VGND VGND VPWR VPWR sky130_fd_sc_hd__decap_6
X_4932_ _1963_ _1964_ sh14\[7\] VGND VGND VPWR VPWR _1966_ sky130_fd_sc_hd__o21a_2
XFILLER_0_63_99 VPWR VGND VPWR VGND sky130_ef_sc_hd__decap_12
XFILLER_0_63_77 VPWR VGND VPWR VGND sky130_ef_sc_hd__decap_12
XFILLER_0_47_505 VPWR VGND VPWR VGND sky130_ef_sc_hd__decap_12
X_7720_ carry1\[8\] sum1\[9\] VGND VGND VPWR VPWR _0632_ sky130_fd_sc_hd__xnor2_1
XFILLER_0_87_685 VPWR VGND VPWR VGND sky130_ef_sc_hd__decap_12
XFILLER_0_86_184 VGND VGND VPWR VPWR sky130_fd_sc_hd__decap_8
XFILLER_0_74_324 VGND VGND VPWR VPWR sky130_fd_sc_hd__decap_6
X_7651_ _4178_ _4179_ net373 VGND VGND VPWR VPWR _4180_ sky130_fd_sc_hd__o21ai_1
X_4863_ _1895_ _1898_ sh15\[7\] VGND VGND VPWR VPWR _1899_ sky130_fd_sc_hd__o21bai_2
X_6602_ _3414_ _3412_ _3597_ _3543_ _3544_ VGND VGND VPWR VPWR _3598_ sky130_fd_sc_hd__o41a_1
XFILLER_0_103_61 VGND VGND VPWR VPWR sky130_fd_sc_hd__fill_1
X_4794_ _1829_ _1674_ _1822_ VGND VGND VPWR VPWR _1831_ sky130_fd_sc_hd__nand3_2
X_7582_ _4165_ VGND VGND VPWR VPWR _0574_ sky130_fd_sc_hd__inv_2
XFILLER_0_70_530 VGND VGND VPWR VPWR sky130_fd_sc_hd__fill_2
X_6533_ _3417_ _3419_ _3456_ _3464_ VGND VGND VPWR VPWR _3530_ sky130_fd_sc_hd__o211a_1
XFILLER_0_42_221 VGND VGND VPWR VPWR sky130_fd_sc_hd__decap_6
X_6464_ _3369_ _3371_ _3461_ _3378_ VGND VGND VPWR VPWR _3462_ sky130_fd_sc_hd__a31oi_1
XFILLER_0_6_189 VGND VGND VPWR VPWR sky130_fd_sc_hd__decap_6
XFILLER_0_15_479 VGND VGND VPWR VPWR sky130_fd_sc_hd__decap_4
XFILLER_0_88_41 VPWR VGND VPWR VGND sky130_ef_sc_hd__decap_12
XFILLER_0_70_585 VGND VGND VPWR VPWR sky130_fd_sc_hd__decap_3
X_5415_ _2433_ _2438_ VGND VGND VPWR VPWR _2439_ sky130_fd_sc_hd__nand2_1
X_8203_ _0989_ sh15\[3\] _1041_ _1039_ _0984_ VGND VGND VPWR VPWR _1048_ sky130_fd_sc_hd__a221oi_2
XFILLER_0_112_153 VPWR VGND VPWR VGND sky130_ef_sc_hd__decap_12
X_6395_ net27 _3392_ VGND VGND VPWR VPWR _3394_ sky130_fd_sc_hd__nor2_2
XFILLER_0_63_3 VGND VGND VPWR VPWR sky130_fd_sc_hd__decap_3
XFILLER_0_112_197 VPWR VGND VPWR VGND sky130_ef_sc_hd__decap_12
XFILLER_0_11_685 VPWR VGND VPWR VGND sky130_ef_sc_hd__decap_12
X_5346_ _2329_ _2333_ _2323_ _2326_ VGND VGND VPWR VPWR _2371_ sky130_fd_sc_hd__o2bb2a_1
X_8134_ _0976_ _0977_ _0980_ VGND VGND VPWR VPWR _0981_ sky130_fd_sc_hd__a21oi_1
X_5277_ _2230_ _2231_ _2232_ _2303_ VGND VGND VPWR VPWR _2304_ sky130_fd_sc_hd__a31oi_2
X_8065_ _0846_ _0849_ _0851_ VGND VGND VPWR VPWR _0913_ sky130_fd_sc_hd__a21oi_1
X_4228_ net34 net32 VGND VGND VPWR VPWR _1276_ sky130_fd_sc_hd__and2_1
X_7016_ _3947_ _3951_ VGND VGND VPWR VPWR _4002_ sky130_fd_sc_hd__nand2_1
Xmax_cap27 _3391_ VGND VGND VPWR VPWR net27 sky130_fd_sc_hd__clkbuf_2
X_7918_ sh13\[3\] VGND VGND VPWR VPWR _0767_ sky130_fd_sc_hd__inv_2
XFILLER_0_93_633 VGND VGND VPWR VPWR sky130_fd_sc_hd__decap_4
XFILLER_0_93_611 VGND VGND VPWR VPWR sky130_fd_sc_hd__decap_4
Xclkbuf_leaf_35_clk clknet_3_4__leaf_clk VGND VGND VPWR VPWR clknet_leaf_35_clk sky130_fd_sc_hd__clkbuf_16
X_7849_ net354 s6\[7\] sum4\[7\] VGND VGND VPWR VPWR _0710_ sky130_fd_sc_hd__a21o_1
XFILLER_0_92_176 VPWR VGND VPWR VGND sky130_ef_sc_hd__decap_12
XFILLER_0_18_262 VGND VGND VPWR VPWR sky130_fd_sc_hd__fill_2
XFILLER_0_73_390 VGND VGND VPWR VPWR sky130_fd_sc_hd__fill_2
XFILLER_0_104_665 VGND VGND VPWR VPWR sky130_fd_sc_hd__decap_3
XFILLER_0_103_131 VGND VGND VPWR VPWR sky130_fd_sc_hd__decap_8
XFILLER_0_103_120 VGND VGND VPWR VPWR sky130_fd_sc_hd__decap_6
XFILLER_0_103_175 VGND VGND VPWR VPWR sky130_fd_sc_hd__fill_1
XFILLER_0_21_449 VGND VGND VPWR VPWR sky130_fd_sc_hd__fill_2
XFILLER_0_17_15 VPWR VGND VPWR VGND sky130_ef_sc_hd__decap_12
XFILLER_0_96_471 VGND VGND VPWR VPWR sky130_fd_sc_hd__fill_1
XTAP_1350 VGND VPWR sky130_fd_sc_hd__tapvpwrvgnd_1
Xclkbuf_leaf_26_clk clknet_3_7__leaf_clk VGND VGND VPWR VPWR clknet_leaf_26_clk sky130_fd_sc_hd__clkbuf_16
XTAP_1372 VGND VPWR sky130_fd_sc_hd__tapvpwrvgnd_1
XTAP_1383 VGND VPWR sky130_fd_sc_hd__tapvpwrvgnd_1
XTAP_1361 VGND VPWR sky130_fd_sc_hd__tapvpwrvgnd_1
XFILLER_0_56_335 VGND VGND VPWR VPWR sky130_fd_sc_hd__fill_1
XFILLER_0_56_324 VGND VGND VPWR VPWR sky130_fd_sc_hd__fill_1
XFILLER_0_29_549 VGND VGND VPWR VPWR sky130_fd_sc_hd__decap_3
XFILLER_0_123_6 VPWR VGND VPWR VGND sky130_ef_sc_hd__decap_12
XTAP_1394 VGND VPWR sky130_fd_sc_hd__tapvpwrvgnd_1
XFILLER_0_84_677 VGND VGND VPWR VPWR sky130_fd_sc_hd__fill_1
XFILLER_0_83_165 VGND VGND VPWR VPWR sky130_fd_sc_hd__decap_3
XFILLER_0_37_593 VPWR VGND VPWR VGND sky130_ef_sc_hd__decap_12
XFILLER_0_114_429 VGND VGND VPWR VPWR sky130_fd_sc_hd__fill_1
XFILLER_0_3_137 VPWR VGND VPWR VGND sky130_ef_sc_hd__decap_12
XFILLER_0_40_725 VGND VGND VPWR VPWR sky130_fd_sc_hd__decap_8
X_6180_ _3180_ _3184_ VGND VGND VPWR VPWR _3186_ sky130_fd_sc_hd__nand2_1
X_5200_ _2226_ _2227_ _2200_ VGND VGND VPWR VPWR _2228_ sky130_fd_sc_hd__o21ai_2
X_5131_ _2040_ sh12\[2\] VGND VGND VPWR VPWR _2160_ sky130_fd_sc_hd__nor2_1
X_5062_ sh2\[2\] VGND VGND VPWR VPWR _2091_ sky130_fd_sc_hd__inv_2
XFILLER_0_79_405 VGND VGND VPWR VPWR sky130_fd_sc_hd__decap_4
XFILLER_0_74_65 VPWR VGND VPWR VGND sky130_ef_sc_hd__decap_12
XFILLER_0_79_449 VPWR VGND VPWR VGND sky130_ef_sc_hd__decap_12
X_8821_ clknet_3_1__leaf_clk sh8\[1\] _0572_ VGND VGND VPWR VPWR sh9\[1\] sky130_fd_sc_hd__dfrtp_2
X_8752_ clknet_leaf_5_clk net6 _0503_ VGND VGND VPWR VPWR sh0\[4\] sky130_fd_sc_hd__dfrtp_1
Xclkbuf_leaf_17_clk clknet_3_6__leaf_clk VGND VGND VPWR VPWR clknet_leaf_17_clk sky130_fd_sc_hd__clkbuf_16
X_5964_ _2969_ _2971_ _2972_ VGND VGND VPWR VPWR _2973_ sky130_fd_sc_hd__nand3_2
XFILLER_0_90_53 VPWR VGND VPWR VGND sky130_ef_sc_hd__decap_12
X_7703_ carry1\[9\] net350 _4215_ VGND VGND VPWR VPWR _0010_ sky130_fd_sc_hd__o21a_1
XFILLER_0_118_713 VPWR VGND VPWR VGND sky130_ef_sc_hd__decap_12
X_4915_ _1833_ _1905_ _1906_ _1949_ VGND VGND VPWR VPWR _1950_ sky130_fd_sc_hd__o211a_1
X_5895_ _2876_ _2903_ _2904_ VGND VGND VPWR VPWR _2905_ sky130_fd_sc_hd__o21ai_2
XFILLER_0_74_121 VPWR VGND VPWR VGND sky130_ef_sc_hd__decap_12
X_8683_ clknet_leaf_52_clk _0148_ _0434_ VGND VGND VPWR VPWR bit_sum1\[4\] sky130_fd_sc_hd__dfrtp_1
X_4846_ _1664_ _1667_ _1859_ _1864_ VGND VGND VPWR VPWR _1882_ sky130_fd_sc_hd__a31o_1
XFILLER_0_75_688 VGND VGND VPWR VPWR sky130_fd_sc_hd__decap_8
X_7634_ _4122_ VGND VGND VPWR VPWR _0622_ sky130_fd_sc_hd__inv_2
XFILLER_0_90_636 VGND VGND VPWR VPWR sky130_fd_sc_hd__decap_4
X_7565_ _4158_ VGND VGND VPWR VPWR _4164_ sky130_fd_sc_hd__buf_8
XFILLER_0_7_465 VGND VGND VPWR VPWR sky130_fd_sc_hd__fill_2
XFILLER_0_28_582 VGND VGND VPWR VPWR sky130_fd_sc_hd__decap_6
XFILLER_0_117_278 VGND VGND VPWR VPWR sky130_fd_sc_hd__fill_2
X_4777_ _1811_ _1812_ _1813_ VGND VGND VPWR VPWR _1814_ sky130_fd_sc_hd__o21ai_1
X_6516_ _3445_ _3509_ _3511_ _3508_ VGND VGND VPWR VPWR _3513_ sky130_fd_sc_hd__o22ai_4
X_7496_ _4156_ VGND VGND VPWR VPWR _0497_ sky130_fd_sc_hd__inv_2
XFILLER_0_101_624 VGND VGND VPWR VPWR sky130_fd_sc_hd__decap_4
X_6447_ net33 sh9\[4\] VGND VGND VPWR VPWR _3445_ sky130_fd_sc_hd__and2_2
XFILLER_0_3_671 VGND VGND VPWR VPWR sky130_fd_sc_hd__fill_1
X_6378_ net33 VGND VGND VPWR VPWR _3377_ sky130_fd_sc_hd__clkbuf_4
X_8117_ _0956_ _0960_ _0958_ VGND VGND VPWR VPWR _0964_ sky130_fd_sc_hd__and3_1
X_5329_ _2270_ _2289_ _2349_ _2353_ VGND VGND VPWR VPWR _2355_ sky130_fd_sc_hd__a22o_1
X_8048_ _0797_ _0726_ VGND VGND VPWR VPWR _0896_ sky130_fd_sc_hd__nand2_1
XFILLER_0_98_725 VGND VGND VPWR VPWR sky130_fd_sc_hd__decap_8
XFILLER_0_93_430 VGND VGND VPWR VPWR sky130_fd_sc_hd__decap_8
XFILLER_0_108_223 VGND VGND VPWR VPWR sky130_fd_sc_hd__fill_1
XFILLER_0_65_154 VGND VGND VPWR VPWR sky130_fd_sc_hd__fill_1
XFILLER_0_123_259 VPWR VGND VPWR VGND sky130_ef_sc_hd__decap_12
XFILLER_0_123_237 VPWR VGND VPWR VGND sky130_ef_sc_hd__decap_12
XFILLER_0_110_29 VGND VGND VPWR VPWR sky130_fd_sc_hd__decap_4
XFILLER_0_110_18 VGND VGND VPWR VPWR sky130_fd_sc_hd__decap_6
XFILLER_0_22_725 VGND VGND VPWR VPWR sky130_fd_sc_hd__decap_8
XFILLER_0_61_393 VGND VGND VPWR VPWR sky130_fd_sc_hd__fill_2
XFILLER_0_119_27 VPWR VGND VPWR VGND sky130_ef_sc_hd__decap_12
XTAP_419 VGND VPWR sky130_fd_sc_hd__tapvpwrvgnd_1
XTAP_408 VGND VPWR sky130_fd_sc_hd__tapvpwrvgnd_1
XFILLER_0_88_235 VGND VGND VPWR VPWR sky130_fd_sc_hd__decap_8
XFILLER_0_76_419 VGND VGND VPWR VPWR sky130_fd_sc_hd__fill_1
XFILLER_0_57_633 VGND VGND VPWR VPWR sky130_fd_sc_hd__fill_1
X_4700_ _1692_ _1689_ _1680_ VGND VGND VPWR VPWR _1738_ sky130_fd_sc_hd__a21o_1
XTAP_1191 VGND VPWR sky130_fd_sc_hd__tapvpwrvgnd_1
XTAP_1180 VGND VPWR sky130_fd_sc_hd__tapvpwrvgnd_1
XFILLER_0_57_688 VGND VGND VPWR VPWR sky130_fd_sc_hd__decap_3
X_5680_ _2695_ _2696_ _2677_ VGND VGND VPWR VPWR _2697_ sky130_fd_sc_hd__o21bai_2
XFILLER_0_121_3 VPWR VGND VPWR VGND sky130_ef_sc_hd__decap_12
X_4631_ _1664_ _1667_ _1668_ VGND VGND VPWR VPWR _1670_ sky130_fd_sc_hd__a21oi_1
XFILLER_0_72_636 VGND VGND VPWR VPWR sky130_fd_sc_hd__decap_8
XFILLER_0_115_727 VGND VGND VPWR VPWR sky130_fd_sc_hd__fill_1
XFILLER_0_37_390 VGND VGND VPWR VPWR sky130_fd_sc_hd__fill_2
XFILLER_0_44_349 VPWR VGND VPWR VGND sky130_ef_sc_hd__decap_12
X_4562_ _1595_ _1603_ _1604_ VGND VGND VPWR VPWR _1605_ sky130_fd_sc_hd__nand3_2
XFILLER_0_12_202 VGND VGND VPWR VPWR sky130_fd_sc_hd__fill_1
X_7350_ _4142_ VGND VGND VPWR VPWR _0365_ sky130_fd_sc_hd__inv_2
X_4493_ _1522_ _1521_ _1529_ VGND VGND VPWR VPWR _1537_ sky130_fd_sc_hd__a21oi_1
X_6301_ _3300_ VGND VGND VPWR VPWR _3301_ sky130_fd_sc_hd__clkbuf_8
XFILLER_0_12_246 VGND VGND VPWR VPWR sky130_fd_sc_hd__decap_6
XFILLER_0_12_213 VGND VGND VPWR VPWR sky130_fd_sc_hd__decap_8
XFILLER_0_4_468 VGND VGND VPWR VPWR sky130_fd_sc_hd__fill_2
XFILLER_0_40_533 VGND VGND VPWR VPWR sky130_fd_sc_hd__fill_1
X_7281_ _4135_ VGND VGND VPWR VPWR _0303_ sky130_fd_sc_hd__inv_2
XFILLER_0_110_421 VGND VGND VPWR VPWR sky130_fd_sc_hd__decap_4
X_6232_ _3186_ _3236_ _3123_ _3129_ VGND VGND VPWR VPWR _3237_ sky130_fd_sc_hd__a2bb2oi_1
Xclkbuf_leaf_6_clk clknet_3_2__leaf_clk VGND VGND VPWR VPWR clknet_leaf_6_clk sky130_fd_sc_hd__clkbuf_16
XFILLER_0_0_641 VGND VGND VPWR VPWR sky130_fd_sc_hd__decap_3
XFILLER_0_40_599 VGND VGND VPWR VPWR sky130_fd_sc_hd__decap_8
X_6163_ _3135_ _3100_ _3136_ _3168_ VGND VGND VPWR VPWR _3169_ sky130_fd_sc_hd__o22ai_2
XFILLER_0_110_487 VGND VGND VPWR VPWR sky130_fd_sc_hd__decap_8
XTAP_942 VGND VPWR sky130_fd_sc_hd__tapvpwrvgnd_1
XTAP_953 VGND VPWR sky130_fd_sc_hd__tapvpwrvgnd_1
XFILLER_0_0_685 VPWR VGND VPWR VGND sky130_ef_sc_hd__decap_12
XTAP_920 VGND VPWR sky130_fd_sc_hd__tapvpwrvgnd_1
XTAP_931 VGND VPWR sky130_fd_sc_hd__tapvpwrvgnd_1
X_6094_ _2871_ _2874_ _3096_ VGND VGND VPWR VPWR _3101_ sky130_fd_sc_hd__a21o_1
XTAP_986 VGND VPWR sky130_fd_sc_hd__tapvpwrvgnd_1
XTAP_975 VGND VPWR sky130_fd_sc_hd__tapvpwrvgnd_1
XTAP_964 VGND VPWR sky130_fd_sc_hd__tapvpwrvgnd_1
X_5114_ _2141_ _2142_ _2138_ VGND VGND VPWR VPWR _2143_ sky130_fd_sc_hd__nand3_2
XFILLER_0_109_60 VGND VGND VPWR VPWR sky130_fd_sc_hd__fill_2
XTAP_997 VGND VPWR sky130_fd_sc_hd__tapvpwrvgnd_1
XFILLER_0_18_80 VGND VGND VPWR VPWR sky130_fd_sc_hd__fill_1
X_5045_ _2069_ _2073_ _2074_ VGND VGND VPWR VPWR _2075_ sky130_fd_sc_hd__nand3b_1
XFILLER_0_26_3 VGND VGND VPWR VPWR sky130_fd_sc_hd__decap_8
XFILLER_0_79_279 VGND VGND VPWR VPWR sky130_fd_sc_hd__fill_1
X_6996_ _3966_ _3980_ _3981_ VGND VGND VPWR VPWR _3982_ sky130_fd_sc_hd__nand3b_2
X_8804_ clknet_leaf_50_clk net338 _0555_ VGND VGND VPWR VPWR sh7\[0\] sky130_fd_sc_hd__dfrtp_1
X_5947_ _2949_ _2950_ _2886_ VGND VGND VPWR VPWR _2956_ sky130_fd_sc_hd__o21ai_2
X_8735_ clknet_leaf_16_clk _0141_ _0486_ VGND VGND VPWR VPWR bit_sum6\[6\] sky130_fd_sc_hd__dfrtp_1
XFILLER_0_47_121 VGND VGND VPWR VPWR sky130_fd_sc_hd__fill_2
X_8666_ clknet_leaf_24_clk net70 _0417_ VGND VGND VPWR VPWR s7\[13\] sky130_fd_sc_hd__dfrtp_1
XFILLER_0_75_441 VGND VGND VPWR VPWR sky130_fd_sc_hd__fill_1
XFILLER_0_118_543 VGND VGND VPWR VPWR sky130_fd_sc_hd__fill_1
X_5878_ _2884_ _2882_ _2883_ VGND VGND VPWR VPWR _2888_ sky130_fd_sc_hd__o21bai_1
XFILLER_0_75_496 VGND VGND VPWR VPWR sky130_fd_sc_hd__fill_2
X_7617_ _4168_ VGND VGND VPWR VPWR _0606_ sky130_fd_sc_hd__inv_2
XFILLER_0_62_102 VGND VGND VPWR VPWR sky130_fd_sc_hd__decap_8
X_4829_ _1664_ _1667_ _1859_ VGND VGND VPWR VPWR _1865_ sky130_fd_sc_hd__a21oi_2
XFILLER_0_7_251 VPWR VGND VPWR VGND sky130_ef_sc_hd__decap_12
X_8597_ clknet_leaf_54_clk _0059_ _0348_ VGND VGND VPWR VPWR sum1\[9\] sky130_fd_sc_hd__dfrtp_1
XFILLER_0_90_477 VPWR VGND VPWR VGND sky130_ef_sc_hd__decap_12
X_7548_ _4162_ VGND VGND VPWR VPWR _0543_ sky130_fd_sc_hd__inv_2
XFILLER_0_16_563 VGND VGND VPWR VPWR sky130_fd_sc_hd__decap_4
X_7479_ _4155_ VGND VGND VPWR VPWR _0481_ sky130_fd_sc_hd__inv_2
XFILLER_0_70_190 VGND VGND VPWR VPWR sky130_fd_sc_hd__decap_6
XFILLER_0_101_443 VGND VGND VPWR VPWR sky130_fd_sc_hd__fill_1
XFILLER_0_11_290 VGND VGND VPWR VPWR sky130_fd_sc_hd__decap_6
XFILLER_0_98_500 VGND VGND VPWR VPWR sky130_fd_sc_hd__fill_2
XFILLER_0_98_533 VGND VGND VPWR VPWR sky130_fd_sc_hd__decap_8
XFILLER_0_58_419 VGND VGND VPWR VPWR sky130_fd_sc_hd__fill_1
XFILLER_0_58_408 VGND VGND VPWR VPWR sky130_fd_sc_hd__decap_3
XFILLER_0_14_27 VGND VGND VPWR VPWR sky130_fd_sc_hd__fill_1
XPHY_241 VGND VGND VPWR VPWR sky130_fd_sc_hd__decap_3
XPHY_230 VGND VGND VPWR VPWR sky130_fd_sc_hd__decap_3
XFILLER_0_53_113 VGND VGND VPWR VPWR sky130_fd_sc_hd__fill_2
XFILLER_0_38_165 VPWR VGND VPWR VGND sky130_ef_sc_hd__decap_12
XFILLER_0_121_39 VPWR VGND VPWR VGND sky130_ef_sc_hd__decap_12
XFILLER_0_93_293 VPWR VGND VPWR VGND sky130_ef_sc_hd__decap_12
XFILLER_0_30_15 VPWR VGND VPWR VGND sky130_ef_sc_hd__decap_12
XFILLER_0_1_449 VPWR VGND VPWR VGND sky130_ef_sc_hd__decap_12
XFILLER_0_39_79 VGND VGND VPWR VPWR sky130_fd_sc_hd__fill_1
XTAP_249 VGND VPWR sky130_fd_sc_hd__tapvpwrvgnd_1
Xhold1 sh9\[1\] VGND VGND VPWR VPWR net43 sky130_fd_sc_hd__dlygate4sd3_1
X_6850_ sh1\[1\] sh2\[1\] VGND VGND VPWR VPWR _3838_ sky130_fd_sc_hd__and2_4
XFILLER_0_119_318 VPWR VGND VPWR VGND sky130_ef_sc_hd__decap_12
XFILLER_0_9_505 VGND VGND VPWR VPWR sky130_fd_sc_hd__fill_1
X_6781_ _3766_ _3767_ _3769_ VGND VGND VPWR VPWR _3770_ sky130_fd_sc_hd__nand3_1
X_5801_ _2809_ _2813_ _2815_ VGND VGND VPWR VPWR _2816_ sky130_fd_sc_hd__a21oi_2
XFILLER_0_91_219 VGND VGND VPWR VPWR sky130_fd_sc_hd__decap_4
X_8520_ clknet_leaf_27_clk _0090_ _0271_ VGND VGND VPWR VPWR sum5\[10\] sky130_fd_sc_hd__dfrtp_1
X_5732_ _2493_ _2518_ _2672_ VGND VGND VPWR VPWR _2748_ sky130_fd_sc_hd__o21ai_2
XFILLER_0_84_271 VGND VGND VPWR VPWR sky130_fd_sc_hd__fill_1
XFILLER_0_72_411 VGND VGND VPWR VPWR sky130_fd_sc_hd__fill_1
XFILLER_0_29_165 VGND VGND VPWR VPWR sky130_fd_sc_hd__decap_3
X_8451_ clknet_leaf_30_clk net311 _0202_ VGND VGND VPWR VPWR carry3\[6\] sky130_fd_sc_hd__dfrtp_1
X_5663_ sh1\[0\] _2477_ _2506_ VGND VGND VPWR VPWR _2680_ sky130_fd_sc_hd__o21a_1
X_4614_ _1652_ _1643_ net40 VGND VGND VPWR VPWR _1653_ sky130_fd_sc_hd__o21a_1
XFILLER_0_115_557 VGND VGND VPWR VPWR sky130_fd_sc_hd__decap_3
XFILLER_0_111_50 VGND VGND VPWR VPWR sky130_fd_sc_hd__decap_6
X_7402_ _4148_ VGND VGND VPWR VPWR _0411_ sky130_fd_sc_hd__inv_2
X_8382_ _1202_ _1206_ _1214_ VGND VGND VPWR VPWR _1215_ sky130_fd_sc_hd__o21a_1
XFILLER_0_60_617 VGND VGND VPWR VPWR sky130_fd_sc_hd__decap_6
XFILLER_0_13_511 VGND VGND VPWR VPWR sky130_fd_sc_hd__fill_1
X_5594_ _2518_ sh9\[0\] _2604_ VGND VGND VPWR VPWR _2612_ sky130_fd_sc_hd__a21o_1
XFILLER_0_32_319 VGND VGND VPWR VPWR sky130_fd_sc_hd__decap_4
XFILLER_0_115_579 VGND VGND VPWR VPWR sky130_fd_sc_hd__decap_4
XFILLER_0_115_568 VGND VGND VPWR VPWR sky130_fd_sc_hd__fill_1
X_4545_ _1531_ _1585_ _1588_ _1584_ VGND VGND VPWR VPWR _1589_ sky130_fd_sc_hd__a22oi_2
Xhold401 sum4\[5\] VGND VGND VPWR VPWR net443 sky130_fd_sc_hd__dlygate4sd3_1
X_7333_ _4141_ VGND VGND VPWR VPWR _0349_ sky130_fd_sc_hd__inv_2
X_4476_ _1484_ _1519_ _1520_ VGND VGND VPWR VPWR _1521_ sky130_fd_sc_hd__a21boi_1
X_7264_ _4133_ VGND VGND VPWR VPWR _0288_ sky130_fd_sc_hd__inv_2
X_6215_ _3218_ _3219_ _3214_ VGND VGND VPWR VPWR _3220_ sky130_fd_sc_hd__o21ai_4
XFILLER_0_96_85 VGND VGND VPWR VPWR sky130_fd_sc_hd__decap_6
X_7195_ _4127_ VGND VGND VPWR VPWR _0225_ sky130_fd_sc_hd__inv_2
X_6146_ _3150_ _3141_ _3144_ VGND VGND VPWR VPWR _3152_ sky130_fd_sc_hd__a21boi_1
XTAP_750 VGND VPWR sky130_fd_sc_hd__tapvpwrvgnd_1
XTAP_761 VGND VPWR sky130_fd_sc_hd__tapvpwrvgnd_1
XTAP_783 VGND VPWR sky130_fd_sc_hd__tapvpwrvgnd_1
XTAP_772 VGND VPWR sky130_fd_sc_hd__tapvpwrvgnd_1
XTAP_794 VGND VPWR sky130_fd_sc_hd__tapvpwrvgnd_1
X_6077_ _2927_ _3033_ _2974_ VGND VGND VPWR VPWR _3084_ sky130_fd_sc_hd__and3b_1
X_5028_ _2053_ _2055_ _2051_ VGND VGND VPWR VPWR _2058_ sky130_fd_sc_hd__o21ai_1
X_6979_ _3903_ _3965_ VGND VGND VPWR VPWR _0148_ sky130_fd_sc_hd__xor2_1
X_8718_ clknet_leaf_14_clk _0126_ _0469_ VGND VGND VPWR VPWR bit_sum4\[9\] sky130_fd_sc_hd__dfrtp_1
XFILLER_0_35_113 VGND VGND VPWR VPWR sky130_fd_sc_hd__decap_8
XFILLER_0_36_614 VPWR VGND VPWR VGND sky130_ef_sc_hd__decap_12
XFILLER_0_118_362 VGND VGND VPWR VPWR sky130_fd_sc_hd__fill_2
XFILLER_0_118_351 VGND VGND VPWR VPWR sky130_fd_sc_hd__fill_1
XFILLER_0_106_502 VGND VGND VPWR VPWR sky130_fd_sc_hd__fill_1
X_8649_ clknet_leaf_29_clk net149 _0400_ VGND VGND VPWR VPWR s5\[14\] sky130_fd_sc_hd__dfrtp_1
XFILLER_0_35_146 VGND VGND VPWR VPWR sky130_fd_sc_hd__decap_8
XFILLER_0_36_669 VPWR VGND VPWR VGND sky130_ef_sc_hd__decap_12
XFILLER_0_90_274 VGND VGND VPWR VPWR sky130_fd_sc_hd__fill_1
XFILLER_0_51_617 VGND VGND VPWR VPWR sky130_fd_sc_hd__fill_2
XFILLER_0_51_639 VGND VGND VPWR VPWR sky130_fd_sc_hd__decap_4
XFILLER_0_106_568 VGND VGND VPWR VPWR sky130_fd_sc_hd__fill_2
XFILLER_0_50_138 VGND VGND VPWR VPWR sky130_fd_sc_hd__fill_2
XFILLER_0_121_527 VGND VGND VPWR VPWR sky130_fd_sc_hd__fill_1
XFILLER_0_101_251 VPWR VGND VPWR VGND sky130_ef_sc_hd__decap_12
XFILLER_0_98_363 VGND VGND VPWR VPWR sky130_fd_sc_hd__fill_1
XFILLER_0_98_396 VGND VGND VPWR VPWR sky130_fd_sc_hd__decap_3
XFILLER_0_26_113 VPWR VGND VPWR VGND sky130_ef_sc_hd__decap_12
XFILLER_0_109_373 VGND VGND VPWR VPWR sky130_fd_sc_hd__fill_2
XFILLER_0_109_351 VGND VGND VPWR VPWR sky130_fd_sc_hd__fill_1
XFILLER_0_41_69 VPWR VGND VPWR VGND sky130_ef_sc_hd__decap_12
XFILLER_0_41_105 VGND VGND VPWR VPWR sky130_fd_sc_hd__decap_6
XFILLER_0_2_725 VGND VGND VPWR VPWR sky130_fd_sc_hd__decap_8
X_4330_ _1369_ _1375_ _1376_ VGND VGND VPWR VPWR _1377_ sky130_fd_sc_hd__a21oi_4
XFILLER_0_22_385 VGND VGND VPWR VPWR sky130_fd_sc_hd__decap_3
XFILLER_0_50_683 VPWR VGND VPWR VGND sky130_ef_sc_hd__decap_12
XFILLER_0_120_571 VPWR VGND VPWR VGND sky130_ef_sc_hd__decap_12
X_4261_ _1308_ _1302_ VGND VGND VPWR VPWR _1309_ sky130_fd_sc_hd__nand2_2
XFILLER_0_10_558 VGND VGND VPWR VPWR sky130_fd_sc_hd__decap_8
X_6000_ net39 _2894_ VGND VGND VPWR VPWR _3008_ sky130_fd_sc_hd__and2_2
XFILLER_0_66_33 VGND VGND VPWR VPWR sky130_fd_sc_hd__fill_1
XFILLER_0_5_69 VPWR VGND VPWR VGND sky130_ef_sc_hd__decap_12
X_7951_ _0795_ _0796_ _0799_ VGND VGND VPWR VPWR _0800_ sky130_fd_sc_hd__a21oi_1
XFILLER_0_82_65 VPWR VGND VPWR VGND sky130_ef_sc_hd__decap_12
XFILLER_0_77_514 VPWR VGND VPWR VGND sky130_ef_sc_hd__decap_12
X_7882_ sh1\[3\] net42 VGND VGND VPWR VPWR _0732_ sky130_fd_sc_hd__and2_1
X_6902_ _3790_ VGND VGND VPWR VPWR _3890_ sky130_fd_sc_hd__inv_2
X_6833_ _3706_ _3821_ _3705_ VGND VGND VPWR VPWR _3822_ sky130_fd_sc_hd__o21ba_1
XFILLER_0_49_249 VPWR VGND VPWR VGND sky130_ef_sc_hd__decap_12
XFILLER_0_65_709 VPWR VGND VPWR VGND sky130_ef_sc_hd__decap_12
XFILLER_0_17_113 VGND VGND VPWR VPWR sky130_fd_sc_hd__fill_2
X_6764_ _3722_ _3723_ _3752_ VGND VGND VPWR VPWR _3753_ sky130_fd_sc_hd__o21bai_1
XFILLER_0_45_422 VGND VGND VPWR VPWR sky130_fd_sc_hd__decap_3
X_6695_ _3660_ _3658_ _3666_ _3672_ VGND VGND VPWR VPWR _3688_ sky130_fd_sc_hd__and4_1
X_8503_ clknet_leaf_25_clk _0171_ _0254_ VGND VGND VPWR VPWR final_sum\[9\] sky130_fd_sc_hd__dfrtp_1
XFILLER_0_57_293 VPWR VGND VPWR VGND sky130_ef_sc_hd__decap_12
X_5715_ sh1\[0\] _2490_ _2489_ VGND VGND VPWR VPWR _2731_ sky130_fd_sc_hd__o21ai_2
XFILLER_0_45_433 VGND VGND VPWR VPWR sky130_fd_sc_hd__fill_1
XFILLER_0_115_332 VGND VGND VPWR VPWR sky130_fd_sc_hd__decap_4
X_8434_ _1260_ _1230_ _1257_ VGND VGND VPWR VPWR _1264_ sky130_fd_sc_hd__o21ai_1
XFILLER_0_93_3 VPWR VGND VPWR VGND sky130_ef_sc_hd__decap_12
XFILLER_0_5_541 VGND VGND VPWR VPWR sky130_fd_sc_hd__fill_1
XFILLER_0_17_157 VGND VGND VPWR VPWR sky130_fd_sc_hd__decap_8
X_5646_ _2660_ _2662_ _2601_ VGND VGND VPWR VPWR _2664_ sky130_fd_sc_hd__nand3_4
XFILLER_0_33_617 VPWR VGND VPWR VGND sky130_ef_sc_hd__decap_12
XFILLER_0_115_365 VPWR VGND VPWR VGND sky130_ef_sc_hd__decap_12
XFILLER_0_103_505 VGND VGND VPWR VPWR sky130_fd_sc_hd__decap_4
X_8365_ _1197_ _1198_ carry5\[12\] VGND VGND VPWR VPWR _1199_ sky130_fd_sc_hd__or3b_2
Xhold220 _0011_ VGND VGND VPWR VPWR net262 sky130_fd_sc_hd__dlygate4sd3_1
XFILLER_0_25_190 VGND VGND VPWR VPWR sky130_fd_sc_hd__decap_8
X_5577_ _2594_ _2587_ _2593_ VGND VGND VPWR VPWR _2596_ sky130_fd_sc_hd__nand3_2
X_4528_ _1504_ _1524_ _1510_ VGND VGND VPWR VPWR _1572_ sky130_fd_sc_hd__o21ai_2
Xhold253 carry3\[7\] VGND VGND VPWR VPWR net295 sky130_fd_sc_hd__dlygate4sd3_1
X_8296_ _0806_ _0810_ _1136_ VGND VGND VPWR VPWR _0109_ sky130_fd_sc_hd__o21a_1
X_7316_ _4139_ VGND VGND VPWR VPWR _0334_ sky130_fd_sc_hd__inv_2
Xhold242 s3\[3\] VGND VGND VPWR VPWR net284 sky130_fd_sc_hd__buf_1
Xhold231 carry1\[7\] VGND VGND VPWR VPWR net273 sky130_fd_sc_hd__dlygate4sd3_1
Xhold286 sh2\[5\] VGND VGND VPWR VPWR net328 sky130_fd_sc_hd__dlygate4sd3_1
X_4459_ _1422_ _1428_ _1437_ VGND VGND VPWR VPWR _1504_ sky130_fd_sc_hd__a21oi_4
X_7247_ _4132_ VGND VGND VPWR VPWR _0272_ sky130_fd_sc_hd__inv_2
Xhold264 s4\[11\] VGND VGND VPWR VPWR net306 sky130_fd_sc_hd__dlygate4sd3_1
Xhold275 sum2\[4\] VGND VGND VPWR VPWR net317 sky130_fd_sc_hd__dlygate4sd3_1
XFILLER_0_40_193 VGND VGND VPWR VPWR sky130_fd_sc_hd__decap_3
Xhold297 sh14\[1\] VGND VGND VPWR VPWR net339 sky130_fd_sc_hd__dlygate4sd3_1
X_7178_ _4126_ VGND VGND VPWR VPWR _0209_ sky130_fd_sc_hd__inv_2
X_6129_ _2871_ _2874_ _3096_ VGND VGND VPWR VPWR _3135_ sky130_fd_sc_hd__and3_1
XTAP_580 VGND VPWR sky130_fd_sc_hd__tapvpwrvgnd_1
XTAP_591 VGND VPWR sky130_fd_sc_hd__tapvpwrvgnd_1
XTAP_1724 VGND VPWR sky130_fd_sc_hd__tapvpwrvgnd_1
XTAP_1713 VGND VPWR sky130_fd_sc_hd__tapvpwrvgnd_1
XTAP_1702 VGND VPWR sky130_fd_sc_hd__tapvpwrvgnd_1
XFILLER_0_95_311 VPWR VGND VPWR VGND sky130_ef_sc_hd__decap_12
XFILLER_0_68_536 VGND VGND VPWR VPWR sky130_fd_sc_hd__decap_4
XFILLER_0_68_525 VGND VGND VPWR VPWR sky130_fd_sc_hd__decap_6
XTAP_1757 VGND VPWR sky130_fd_sc_hd__tapvpwrvgnd_1
XTAP_1746 VGND VPWR sky130_fd_sc_hd__tapvpwrvgnd_1
XTAP_1735 VGND VPWR sky130_fd_sc_hd__tapvpwrvgnd_1
XFILLER_0_95_355 VPWR VGND VPWR VGND sky130_ef_sc_hd__decap_12
XTAP_1779 VGND VPWR sky130_fd_sc_hd__tapvpwrvgnd_1
XTAP_1768 VGND VPWR sky130_fd_sc_hd__tapvpwrvgnd_1
XFILLER_0_36_433 VGND VGND VPWR VPWR sky130_fd_sc_hd__decap_4
XFILLER_0_48_282 VPWR VGND VPWR VGND sky130_ef_sc_hd__decap_12
XFILLER_0_106_321 VPWR VGND VPWR VGND sky130_ef_sc_hd__decap_12
XFILLER_0_63_274 VGND VGND VPWR VPWR sky130_fd_sc_hd__decap_6
XFILLER_0_11_39 VPWR VGND VPWR VGND sky130_ef_sc_hd__decap_12
XFILLER_0_106_365 VGND VGND VPWR VPWR sky130_fd_sc_hd__decap_8
XFILLER_0_106_398 VGND VGND VPWR VPWR sky130_fd_sc_hd__decap_4
XFILLER_0_32_661 VPWR VGND VPWR VGND sky130_ef_sc_hd__decap_12
XFILLER_0_86_333 VPWR VGND VPWR VGND sky130_ef_sc_hd__decap_12
XFILLER_0_86_377 VPWR VGND VPWR VGND sky130_ef_sc_hd__decap_12
XFILLER_0_39_293 VGND VGND VPWR VPWR sky130_fd_sc_hd__decap_4
XFILLER_0_109_181 VGND VGND VPWR VPWR sky130_fd_sc_hd__fill_1
XFILLER_0_70_701 VPWR VGND VPWR VGND sky130_ef_sc_hd__decap_12
XFILLER_0_15_617 VGND VGND VPWR VPWR sky130_fd_sc_hd__decap_8
X_5500_ net36 _2518_ VGND VGND VPWR VPWR _2519_ sky130_fd_sc_hd__nor2_2
XFILLER_0_27_477 VGND VGND VPWR VPWR sky130_fd_sc_hd__decap_3
X_6480_ _3472_ VGND VGND VPWR VPWR _3478_ sky130_fd_sc_hd__inv_2
XFILLER_0_54_274 VGND VGND VPWR VPWR sky130_fd_sc_hd__decap_6
XFILLER_0_2_533 VPWR VGND VPWR VGND sky130_ef_sc_hd__decap_12
XFILLER_0_23_661 VGND VGND VPWR VPWR sky130_fd_sc_hd__decap_8
X_5431_ _2411_ _2453_ _2445_ _2446_ VGND VGND VPWR VPWR _2454_ sky130_fd_sc_hd__a211o_1
X_8150_ _0946_ VGND VGND VPWR VPWR _0996_ sky130_fd_sc_hd__inv_2
XFILLER_0_22_171 VGND VGND VPWR VPWR sky130_fd_sc_hd__decap_8
X_5362_ _2321_ _2377_ _2378_ _2379_ _2381_ VGND VGND VPWR VPWR _2387_ sky130_fd_sc_hd__o221a_1
X_4313_ _1359_ _1357_ _1235_ VGND VGND VPWR VPWR _1360_ sky130_fd_sc_hd__o21bai_4
X_8081_ _0863_ _0861_ _0879_ VGND VGND VPWR VPWR _0928_ sky130_fd_sc_hd__o21ai_1
X_7101_ _4083_ _4043_ _4079_ VGND VGND VPWR VPWR _4085_ sky130_fd_sc_hd__nand3_4
XFILLER_0_10_377 VPWR VGND VPWR VGND sky130_ef_sc_hd__decap_12
X_7032_ sh4\[1\] _3703_ sh6\[1\] VGND VGND VPWR VPWR _4017_ sky130_fd_sc_hd__o21ai_4
X_5293_ _2060_ net38 sh6\[2\] VGND VGND VPWR VPWR _2319_ sky130_fd_sc_hd__o21ai_4
X_4244_ _1271_ _1287_ _1288_ _1289_ _1291_ VGND VGND VPWR VPWR _1292_ sky130_fd_sc_hd__o221ai_4
XFILLER_0_93_86 VGND VGND VPWR VPWR sky130_fd_sc_hd__decap_8
XFILLER_0_117_93 VGND VGND VPWR VPWR sky130_fd_sc_hd__fill_2
X_7934_ _0775_ _0780_ _0781_ _0782_ VGND VGND VPWR VPWR _0783_ sky130_fd_sc_hd__o211ai_4
XTAP_1009 VGND VPWR sky130_fd_sc_hd__tapvpwrvgnd_1
X_7865_ carry3\[3\] net297 VGND VGND VPWR VPWR _0718_ sky130_fd_sc_hd__nor2_1
XFILLER_0_77_377 VGND VGND VPWR VPWR sky130_fd_sc_hd__fill_1
X_6816_ _3701_ _3702_ VGND VGND VPWR VPWR _3805_ sky130_fd_sc_hd__nand2_1
X_7796_ net371 s1\[3\] _0683_ VGND VGND VPWR VPWR _0003_ sky130_fd_sc_hd__o21a_1
XFILLER_0_92_358 VGND VGND VPWR VPWR sky130_fd_sc_hd__decap_6
X_6747_ _3712_ _3710_ VGND VGND VPWR VPWR _3736_ sky130_fd_sc_hd__nand2_2
XFILLER_0_73_561 VPWR VGND VPWR VGND sky130_ef_sc_hd__decap_12
XFILLER_0_61_701 VGND VGND VPWR VPWR sky130_fd_sc_hd__fill_2
XFILLER_0_18_477 VPWR VGND VPWR VGND sky130_ef_sc_hd__decap_12
XFILLER_0_115_140 VGND VGND VPWR VPWR sky130_fd_sc_hd__fill_1
X_6678_ _3670_ _3627_ _3666_ VGND VGND VPWR VPWR _3672_ sky130_fd_sc_hd__nand3_2
XFILLER_0_33_414 VPWR VGND VPWR VGND sky130_ef_sc_hd__decap_12
X_8417_ sh5\[5\] VGND VGND VPWR VPWR _1247_ sky130_fd_sc_hd__clkbuf_4
XFILLER_0_103_313 VGND VGND VPWR VPWR sky130_fd_sc_hd__fill_1
X_5629_ _2615_ _2638_ _2639_ VGND VGND VPWR VPWR _2647_ sky130_fd_sc_hd__nand3_1
XFILLER_0_115_195 VPWR VGND VPWR VGND sky130_ef_sc_hd__decap_12
X_8348_ _1182_ _1170_ _1180_ _1181_ VGND VGND VPWR VPWR _1184_ sky130_fd_sc_hd__a211oi_2
X_8279_ _1089_ _1050_ _1090_ _1041_ VGND VGND VPWR VPWR _1122_ sky130_fd_sc_hd__a31oi_1
XFILLER_0_87_108 VGND VGND VPWR VPWR sky130_fd_sc_hd__fill_1
XTAP_1532 VGND VPWR sky130_fd_sc_hd__tapvpwrvgnd_1
XTAP_1521 VGND VPWR sky130_fd_sc_hd__tapvpwrvgnd_1
XFILLER_0_96_675 VPWR VGND VPWR VGND sky130_ef_sc_hd__decap_12
XFILLER_0_96_642 VGND VGND VPWR VPWR sky130_fd_sc_hd__fill_2
XTAP_1510 VGND VPWR sky130_fd_sc_hd__tapvpwrvgnd_1
XFILLER_0_68_344 VGND VGND VPWR VPWR sky130_fd_sc_hd__decap_8
XFILLER_0_29_709 VPWR VGND VPWR VGND sky130_ef_sc_hd__decap_12
XTAP_1576 VGND VPWR sky130_fd_sc_hd__tapvpwrvgnd_1
XTAP_1554 VGND VPWR sky130_fd_sc_hd__tapvpwrvgnd_1
XTAP_1565 VGND VPWR sky130_fd_sc_hd__tapvpwrvgnd_1
XTAP_1543 VGND VPWR sky130_fd_sc_hd__tapvpwrvgnd_1
XFILLER_0_83_303 VGND VGND VPWR VPWR sky130_fd_sc_hd__fill_1
XFILLER_0_68_399 VGND VGND VPWR VPWR sky130_fd_sc_hd__decap_8
XFILLER_0_56_528 VGND VGND VPWR VPWR sky130_fd_sc_hd__decap_4
XPHY_50 VGND VGND VPWR VPWR sky130_fd_sc_hd__decap_3
XPHY_61 VGND VGND VPWR VPWR sky130_fd_sc_hd__decap_3
XPHY_72 VGND VGND VPWR VPWR sky130_fd_sc_hd__decap_3
XPHY_83 VGND VGND VPWR VPWR sky130_fd_sc_hd__decap_3
XTAP_1598 VGND VPWR sky130_fd_sc_hd__tapvpwrvgnd_1
XTAP_1587 VGND VPWR sky130_fd_sc_hd__tapvpwrvgnd_1
XFILLER_0_22_27 VGND VGND VPWR VPWR sky130_fd_sc_hd__fill_1
XPHY_94 VGND VGND VPWR VPWR sky130_fd_sc_hd__decap_3
XFILLER_0_107_641 VGND VGND VPWR VPWR sky130_fd_sc_hd__fill_1
XFILLER_0_51_299 VGND VGND VPWR VPWR sky130_fd_sc_hd__fill_2
XFILLER_0_20_653 VGND VGND VPWR VPWR sky130_fd_sc_hd__fill_2
XFILLER_0_20_697 VGND VGND VPWR VPWR sky130_fd_sc_hd__decap_3
XFILLER_0_47_57 VGND VGND VPWR VPWR sky130_fd_sc_hd__decap_4
X_5980_ _2984_ _2985_ _2988_ VGND VGND VPWR VPWR _2989_ sky130_fd_sc_hd__o21ai_1
X_4931_ sh14\[7\] _1963_ _1964_ VGND VGND VPWR VPWR _1965_ sky130_fd_sc_hd__nor3_2
XFILLER_0_63_89 VGND VGND VPWR VPWR sky130_fd_sc_hd__decap_6
X_4862_ _1896_ _1897_ _1894_ _1892_ VGND VGND VPWR VPWR _1898_ sky130_fd_sc_hd__o211a_1
XFILLER_0_87_697 VGND VGND VPWR VPWR sky130_fd_sc_hd__decap_8
X_7650_ sum3\[7\] carry3\[6\] VGND VGND VPWR VPWR _4179_ sky130_fd_sc_hd__nor2_1
XFILLER_0_59_399 VGND VGND VPWR VPWR sky130_fd_sc_hd__fill_1
XFILLER_0_47_517 VGND VGND VPWR VPWR sky130_fd_sc_hd__decap_4
X_6601_ _3477_ _3480_ VGND VGND VPWR VPWR _3597_ sky130_fd_sc_hd__nand2_1
XFILLER_0_117_449 VGND VGND VPWR VPWR sky130_fd_sc_hd__decap_8
X_4793_ _1822_ _1829_ _1674_ VGND VGND VPWR VPWR _1830_ sky130_fd_sc_hd__a21o_1
XFILLER_0_55_561 VGND VGND VPWR VPWR sky130_fd_sc_hd__decap_6
X_7581_ _4165_ VGND VGND VPWR VPWR _0573_ sky130_fd_sc_hd__inv_2
X_6532_ _3521_ _3525_ _3528_ VGND VGND VPWR VPWR _3529_ sky130_fd_sc_hd__nand3_2
X_6463_ _3366_ _3460_ _3367_ VGND VGND VPWR VPWR _3461_ sky130_fd_sc_hd__nand3_1
XFILLER_0_113_655 VPWR VGND VPWR VGND sky130_ef_sc_hd__decap_12
XFILLER_0_88_53 VGND VGND VPWR VPWR sky130_fd_sc_hd__decap_6
X_5414_ _2107_ _2255_ _2434_ _2436_ _2437_ VGND VGND VPWR VPWR _2438_ sky130_fd_sc_hd__o2111ai_4
X_8202_ _1045_ _1047_ VGND VGND VPWR VPWR _0113_ sky130_fd_sc_hd__xnor2_1
XFILLER_0_112_165 VPWR VGND VPWR VGND sky130_ef_sc_hd__decap_12
X_6394_ _3382_ _3387_ net27 _3392_ VGND VGND VPWR VPWR _3393_ sky130_fd_sc_hd__o2bb2ai_1
XFILLER_0_2_363 VGND VGND VPWR VPWR sky130_fd_sc_hd__fill_1
X_8133_ _0843_ _0910_ _0978_ _0979_ VGND VGND VPWR VPWR _0980_ sky130_fd_sc_hd__o2bb2ai_2
XFILLER_0_10_141 VGND VGND VPWR VPWR sky130_fd_sc_hd__decap_6
X_5345_ _2346_ _2342_ _2369_ VGND VGND VPWR VPWR _2370_ sky130_fd_sc_hd__a21oi_1
XFILLER_0_11_697 VPWR VGND VPWR VGND sky130_ef_sc_hd__decap_12
X_5276_ _2163_ VGND VGND VPWR VPWR _2303_ sky130_fd_sc_hd__inv_2
X_8064_ _0906_ _0910_ _0843_ VGND VGND VPWR VPWR _0912_ sky130_fd_sc_hd__nand3_2
X_4227_ _1245_ net32 _1274_ VGND VGND VPWR VPWR _1275_ sky130_fd_sc_hd__o21ai_4
X_7015_ _3994_ _3999_ _4000_ VGND VGND VPWR VPWR _4001_ sky130_fd_sc_hd__a21oi_1
X_7917_ _0763_ _0765_ sh13\[3\] VGND VGND VPWR VPWR _0766_ sky130_fd_sc_hd__o21ai_2
XFILLER_0_93_623 VGND VGND VPWR VPWR sky130_fd_sc_hd__fill_1
XFILLER_0_77_163 VGND VGND VPWR VPWR sky130_fd_sc_hd__decap_4
XFILLER_0_92_111 VGND VGND VPWR VPWR sky130_fd_sc_hd__fill_2
X_7848_ net299 s6\[6\] _0709_ VGND VGND VPWR VPWR _0046_ sky130_fd_sc_hd__o21a_1
XFILLER_0_93_689 VPWR VGND VPWR VGND sky130_ef_sc_hd__decap_12
X_7779_ carry2\[6\] sum2\[7\] net217 VGND VGND VPWR VPWR _0675_ sky130_fd_sc_hd__a21o_1
XFILLER_0_53_509 VGND VGND VPWR VPWR sky130_fd_sc_hd__fill_1
XFILLER_0_34_701 VPWR VGND VPWR VGND sky130_ef_sc_hd__decap_12
XFILLER_0_92_188 VGND VGND VPWR VPWR sky130_fd_sc_hd__decap_8
XFILLER_0_104_600 VPWR VGND VPWR VGND sky130_ef_sc_hd__decap_12
XFILLER_0_21_406 VGND VGND VPWR VPWR sky130_fd_sc_hd__fill_1
XFILLER_0_108_29 VGND VGND VPWR VPWR sky130_fd_sc_hd__fill_2
XFILLER_0_17_27 VGND VGND VPWR VPWR sky130_fd_sc_hd__decap_8
XFILLER_0_69_620 VPWR VGND VPWR VGND sky130_ef_sc_hd__decap_12
XFILLER_0_33_15 VPWR VGND VPWR VGND sky130_ef_sc_hd__decap_12
XTAP_1340 VGND VPWR sky130_fd_sc_hd__tapvpwrvgnd_1
XFILLER_0_68_141 VGND VGND VPWR VPWR sky130_fd_sc_hd__decap_3
XFILLER_0_29_517 VPWR VGND VPWR VGND sky130_ef_sc_hd__decap_12
XTAP_1373 VGND VPWR sky130_fd_sc_hd__tapvpwrvgnd_1
XTAP_1384 VGND VPWR sky130_fd_sc_hd__tapvpwrvgnd_1
XFILLER_0_84_645 VGND VGND VPWR VPWR sky130_fd_sc_hd__decap_6
XTAP_1362 VGND VPWR sky130_fd_sc_hd__tapvpwrvgnd_1
XTAP_1351 VGND VPWR sky130_fd_sc_hd__tapvpwrvgnd_1
XFILLER_0_83_111 VGND VGND VPWR VPWR sky130_fd_sc_hd__fill_1
XTAP_1395 VGND VPWR sky130_fd_sc_hd__tapvpwrvgnd_1
XFILLER_0_64_380 VPWR VGND VPWR VGND sky130_ef_sc_hd__decap_12
XFILLER_0_52_531 VGND VGND VPWR VPWR sky130_fd_sc_hd__fill_1
XFILLER_0_3_105 VGND VGND VPWR VPWR sky130_fd_sc_hd__decap_6
XFILLER_0_12_406 VGND VGND VPWR VPWR sky130_fd_sc_hd__fill_1
XFILLER_0_3_149 VPWR VGND VPWR VGND sky130_ef_sc_hd__decap_12
XFILLER_0_122_452 VGND VGND VPWR VPWR sky130_fd_sc_hd__fill_1
XFILLER_0_58_56 VGND VGND VPWR VPWR sky130_fd_sc_hd__fill_1
X_5130_ _2072_ _2104_ _2106_ VGND VGND VPWR VPWR _2159_ sky130_fd_sc_hd__o21ai_2
X_5061_ sh0\[2\] VGND VGND VPWR VPWR _2090_ sky130_fd_sc_hd__inv_2
XFILLER_0_74_77 VGND VGND VPWR VPWR sky130_fd_sc_hd__decap_6
X_8820_ clknet_leaf_50_clk net356 _0571_ VGND VGND VPWR VPWR sh9\[0\] sky130_fd_sc_hd__dfrtp_4
X_5963_ _2958_ _2959_ _2961_ _2953_ _2957_ VGND VGND VPWR VPWR _2972_ sky130_fd_sc_hd__o2111ai_4
X_8751_ clknet_3_0__leaf_clk net5 _0502_ VGND VGND VPWR VPWR sh0\[3\] sky130_fd_sc_hd__dfrtp_1
X_4914_ _1947_ _1908_ VGND VGND VPWR VPWR _1949_ sky130_fd_sc_hd__nand2_2
X_7702_ carry1\[9\] sum1\[10\] net253 VGND VGND VPWR VPWR _4215_ sky130_fd_sc_hd__a21o_1
XFILLER_0_114_61 VGND VGND VPWR VPWR sky130_fd_sc_hd__fill_2
XFILLER_0_90_65 VGND VGND VPWR VPWR sky130_fd_sc_hd__fill_1
X_5894_ _2876_ _2877_ _2902_ VGND VGND VPWR VPWR _2904_ sky130_fd_sc_hd__o21ai_1
XFILLER_0_74_133 VGND VGND VPWR VPWR sky130_fd_sc_hd__decap_6
X_8682_ clknet_leaf_53_clk _0147_ _0433_ VGND VGND VPWR VPWR bit_sum1\[3\] sky130_fd_sc_hd__dfrtp_1
XFILLER_0_118_725 VGND VGND VPWR VPWR sky130_fd_sc_hd__decap_8
XFILLER_0_114_94 VGND VGND VPWR VPWR sky130_fd_sc_hd__decap_3
X_4845_ _1864_ _1860_ _1852_ _1867_ _1857_ VGND VGND VPWR VPWR _1881_ sky130_fd_sc_hd__o2111ai_4
XFILLER_0_90_98 VGND VGND VPWR VPWR sky130_fd_sc_hd__fill_1
XFILLER_0_16_701 VPWR VGND VPWR VGND sky130_ef_sc_hd__decap_12
X_7633_ _4122_ VGND VGND VPWR VPWR _0621_ sky130_fd_sc_hd__inv_2
X_4776_ _1794_ _1795_ _1713_ sh12\[7\] _1662_ VGND VGND VPWR VPWR _1813_ sky130_fd_sc_hd__o311a_2
X_7564_ _4163_ VGND VGND VPWR VPWR _0558_ sky130_fd_sc_hd__inv_2
XFILLER_0_62_339 VPWR VGND VPWR VGND sky130_ef_sc_hd__decap_12
X_6515_ _3510_ _3508_ _3511_ VGND VGND VPWR VPWR _3512_ sky130_fd_sc_hd__o21bai_2
XFILLER_0_113_430 VPWR VGND VPWR VGND sky130_ef_sc_hd__decap_12
XFILLER_0_99_85 VGND VGND VPWR VPWR sky130_fd_sc_hd__decap_3
X_7495_ _4156_ VGND VGND VPWR VPWR _0496_ sky130_fd_sc_hd__inv_2
X_6446_ net33 sh9\[4\] VGND VGND VPWR VPWR _3444_ sky130_fd_sc_hd__nor2_1
XFILLER_0_113_485 VPWR VGND VPWR VGND sky130_ef_sc_hd__decap_12
XFILLER_0_101_647 VGND VGND VPWR VPWR sky130_fd_sc_hd__fill_1
X_6377_ sh5\[4\] sh7\[4\] net33 VGND VGND VPWR VPWR _3376_ sky130_fd_sc_hd__o21ai_2
X_8116_ _0946_ _0950_ _0962_ VGND VGND VPWR VPWR _0963_ sky130_fd_sc_hd__nand3_2
X_5328_ _2270_ _2289_ _2349_ _2353_ VGND VGND VPWR VPWR _2354_ sky130_fd_sc_hd__nand4_1
XFILLER_0_100_168 VGND VGND VPWR VPWR sky130_fd_sc_hd__fill_1
X_8047_ _0890_ _0894_ VGND VGND VPWR VPWR _0895_ sky130_fd_sc_hd__nand2_1
X_5259_ _2200_ _2226_ _2224_ VGND VGND VPWR VPWR _2286_ sky130_fd_sc_hd__o21a_1
XFILLER_0_97_225 VGND VGND VPWR VPWR sky130_fd_sc_hd__fill_2
XFILLER_0_38_303 VGND VGND VPWR VPWR sky130_fd_sc_hd__fill_2
XFILLER_0_66_656 VPWR VGND VPWR VGND sky130_ef_sc_hd__decap_12
XFILLER_0_66_645 VGND VGND VPWR VPWR sky130_fd_sc_hd__decap_4
XFILLER_0_93_475 VPWR VGND VPWR VGND sky130_ef_sc_hd__decap_12
XFILLER_0_81_615 VGND VGND VPWR VPWR sky130_fd_sc_hd__fill_1
XFILLER_0_19_561 VGND VGND VPWR VPWR sky130_fd_sc_hd__decap_4
XFILLER_0_108_246 VGND VGND VPWR VPWR sky130_fd_sc_hd__decap_6
XFILLER_0_108_235 VGND VGND VPWR VPWR sky130_fd_sc_hd__decap_3
XFILLER_0_81_637 VPWR VGND VPWR VGND sky130_ef_sc_hd__decap_12
XFILLER_0_123_249 VGND VGND VPWR VPWR sky130_fd_sc_hd__decap_3
XFILLER_0_34_575 VGND VGND VPWR VPWR sky130_fd_sc_hd__fill_1
XFILLER_0_1_609 VGND VGND VPWR VPWR sky130_fd_sc_hd__decap_6
XFILLER_0_21_225 VGND VGND VPWR VPWR sky130_fd_sc_hd__decap_4
XTAP_409 VGND VPWR sky130_fd_sc_hd__tapvpwrvgnd_1
XFILLER_0_119_39 VPWR VGND VPWR VGND sky130_ef_sc_hd__decap_12
XFILLER_0_28_15 VPWR VGND VPWR VGND sky130_ef_sc_hd__decap_12
XFILLER_0_57_612 VGND VGND VPWR VPWR sky130_fd_sc_hd__fill_1
XFILLER_0_57_601 VGND VGND VPWR VPWR sky130_fd_sc_hd__decap_6
XFILLER_0_9_709 VPWR VGND VPWR VGND sky130_ef_sc_hd__decap_12
XTAP_1192 VGND VPWR sky130_fd_sc_hd__tapvpwrvgnd_1
XTAP_1181 VGND VPWR sky130_fd_sc_hd__tapvpwrvgnd_1
XTAP_1170 VGND VPWR sky130_fd_sc_hd__tapvpwrvgnd_1
X_4630_ _1664_ _1667_ _1668_ VGND VGND VPWR VPWR _1669_ sky130_fd_sc_hd__and3_2
XFILLER_0_44_317 VGND VGND VPWR VPWR sky130_fd_sc_hd__decap_8
XFILLER_0_114_3 VPWR VGND VPWR VGND sky130_ef_sc_hd__decap_12
X_4561_ _1545_ _1548_ _1599_ _1601_ VGND VGND VPWR VPWR _1604_ sky130_fd_sc_hd__o211ai_2
X_6300_ sh1\[4\] sh0\[4\] VGND VGND VPWR VPWR _3300_ sky130_fd_sc_hd__and2_1
XFILLER_0_69_11 VGND VGND VPWR VPWR sky130_fd_sc_hd__decap_3
X_4492_ _1535_ _1536_ VGND VGND VPWR VPWR _0131_ sky130_fd_sc_hd__xnor2_1
X_7280_ _4135_ VGND VGND VPWR VPWR _0302_ sky130_fd_sc_hd__inv_2
X_6231_ _3130_ sh15\[6\] _3120_ VGND VGND VPWR VPWR _3236_ sky130_fd_sc_hd__a21oi_1
X_6162_ _3155_ _3163_ _3167_ _3162_ VGND VGND VPWR VPWR _3168_ sky130_fd_sc_hd__a22oi_4
XFILLER_0_100_96 VPWR VGND VPWR VGND sky130_ef_sc_hd__decap_12
XFILLER_0_100_85 VGND VGND VPWR VPWR sky130_fd_sc_hd__decap_4
XFILLER_0_40_589 VGND VGND VPWR VPWR sky130_fd_sc_hd__decap_6
XTAP_910 VGND VPWR sky130_fd_sc_hd__tapvpwrvgnd_1
XFILLER_0_110_477 VGND VGND VPWR VPWR sky130_fd_sc_hd__fill_1
XTAP_943 VGND VPWR sky130_fd_sc_hd__tapvpwrvgnd_1
XFILLER_0_0_697 VGND VGND VPWR VPWR sky130_fd_sc_hd__decap_3
X_5113_ _2090_ _2051_ VGND VGND VPWR VPWR _2142_ sky130_fd_sc_hd__nand2_1
XTAP_921 VGND VPWR sky130_fd_sc_hd__tapvpwrvgnd_1
XTAP_932 VGND VPWR sky130_fd_sc_hd__tapvpwrvgnd_1
X_6093_ _3037_ _3032_ _3098_ _3099_ VGND VGND VPWR VPWR _3100_ sky130_fd_sc_hd__a22oi_4
XTAP_987 VGND VPWR sky130_fd_sc_hd__tapvpwrvgnd_1
XTAP_976 VGND VPWR sky130_fd_sc_hd__tapvpwrvgnd_1
XTAP_965 VGND VPWR sky130_fd_sc_hd__tapvpwrvgnd_1
XTAP_954 VGND VPWR sky130_fd_sc_hd__tapvpwrvgnd_1
XTAP_998 VGND VPWR sky130_fd_sc_hd__tapvpwrvgnd_1
X_5044_ net38 _2072_ VGND VGND VPWR VPWR _2074_ sky130_fd_sc_hd__nand2_2
X_8803_ clknet_leaf_19_clk net224 _0554_ VGND VGND VPWR VPWR sh6\[7\] sky130_fd_sc_hd__dfrtp_2
XFILLER_0_19_3 VPWR VGND VPWR VGND sky130_ef_sc_hd__decap_12
X_6995_ _3971_ _3976_ _3979_ VGND VGND VPWR VPWR _3981_ sky130_fd_sc_hd__a21o_1
X_5946_ _2910_ _2909_ _2912_ VGND VGND VPWR VPWR _2955_ sky130_fd_sc_hd__o21a_1
XFILLER_0_94_228 VPWR VGND VPWR VGND sky130_ef_sc_hd__decap_12
X_8734_ clknet_leaf_15_clk _0140_ _0485_ VGND VGND VPWR VPWR bit_sum6\[5\] sky130_fd_sc_hd__dfrtp_1
XFILLER_0_47_111 VGND VGND VPWR VPWR sky130_fd_sc_hd__fill_1
XFILLER_0_118_511 VPWR VGND VPWR VGND sky130_ef_sc_hd__decap_12
X_5877_ _2880_ _2882_ _2883_ _2885_ _2886_ VGND VGND VPWR VPWR _2887_ sky130_fd_sc_hd__o221a_1
X_8665_ clknet_leaf_24_clk net68 _0416_ VGND VGND VPWR VPWR s7\[12\] sky130_fd_sc_hd__dfrtp_1
X_4828_ _1792_ _1861_ _1862_ _1863_ VGND VGND VPWR VPWR _1864_ sky130_fd_sc_hd__a22o_2
XFILLER_0_75_486 VGND VGND VPWR VPWR sky130_fd_sc_hd__decap_6
XFILLER_0_7_241 VGND VGND VPWR VPWR sky130_fd_sc_hd__decap_4
X_7616_ _4168_ VGND VGND VPWR VPWR _0605_ sky130_fd_sc_hd__inv_2
XFILLER_0_16_531 VGND VGND VPWR VPWR sky130_fd_sc_hd__fill_1
X_8596_ clknet_leaf_52_clk _0058_ _0347_ VGND VGND VPWR VPWR sum1\[8\] sky130_fd_sc_hd__dfrtp_1
XFILLER_0_121_709 VPWR VGND VPWR VGND sky130_ef_sc_hd__decap_12
X_4759_ _1794_ _1795_ sh12\[7\] VGND VGND VPWR VPWR _1796_ sky130_fd_sc_hd__o21bai_2
X_7547_ _4162_ VGND VGND VPWR VPWR _0542_ sky130_fd_sc_hd__inv_2
XFILLER_0_16_586 VGND VGND VPWR VPWR sky130_fd_sc_hd__fill_2
XFILLER_0_31_501 VGND VGND VPWR VPWR sky130_fd_sc_hd__decap_3
X_7478_ _4155_ VGND VGND VPWR VPWR _0480_ sky130_fd_sc_hd__inv_2
X_6429_ _3425_ _3426_ _3298_ VGND VGND VPWR VPWR _3427_ sky130_fd_sc_hd__o21bai_4
XFILLER_0_98_556 VGND VGND VPWR VPWR sky130_fd_sc_hd__fill_2
XFILLER_0_86_729 VGND VGND VPWR VPWR sky130_fd_sc_hd__decap_6
XPHY_242 VGND VGND VPWR VPWR sky130_fd_sc_hd__decap_3
XPHY_231 VGND VGND VPWR VPWR sky130_fd_sc_hd__decap_3
XPHY_220 VGND VGND VPWR VPWR sky130_fd_sc_hd__decap_3
XFILLER_0_109_500 VGND VGND VPWR VPWR sky130_fd_sc_hd__decap_4
XFILLER_0_54_637 VGND VGND VPWR VPWR sky130_fd_sc_hd__decap_6
XFILLER_0_26_306 VGND VGND VPWR VPWR sky130_fd_sc_hd__fill_2
XFILLER_0_38_177 VPWR VGND VPWR VGND sky130_ef_sc_hd__decap_12
XFILLER_0_19_391 VGND VGND VPWR VPWR sky130_fd_sc_hd__fill_1
XFILLER_0_30_27 VGND VGND VPWR VPWR sky130_fd_sc_hd__fill_1
XFILLER_0_53_169 VGND VGND VPWR VPWR sky130_fd_sc_hd__decap_8
XFILLER_0_34_361 VGND VGND VPWR VPWR sky130_fd_sc_hd__decap_3
XFILLER_0_104_271 VGND VGND VPWR VPWR sky130_fd_sc_hd__decap_6
XFILLER_0_22_567 VGND VGND VPWR VPWR sky130_fd_sc_hd__decap_3
XFILLER_0_22_589 VGND VGND VPWR VPWR sky130_fd_sc_hd__fill_2
Xhold2 s3\[12\] VGND VGND VPWR VPWR net44 sky130_fd_sc_hd__dlygate4sd3_1
XFILLER_0_55_57 VPWR VGND VPWR VGND sky130_ef_sc_hd__decap_12
XFILLER_0_89_567 VGND VGND VPWR VPWR sky130_fd_sc_hd__fill_1
XFILLER_0_77_729 VGND VGND VPWR VPWR sky130_fd_sc_hd__decap_6
X_6780_ _3768_ sh8\[1\] VGND VGND VPWR VPWR _3769_ sky130_fd_sc_hd__nand2_2
XFILLER_0_29_111 VGND VGND VPWR VPWR sky130_fd_sc_hd__fill_1
X_5800_ _2809_ _2814_ _2765_ VGND VGND VPWR VPWR _2815_ sky130_fd_sc_hd__a21boi_1
X_5731_ _2744_ _2746_ _2729_ VGND VGND VPWR VPWR _2747_ sky130_fd_sc_hd__nand3_2
XFILLER_0_29_133 VPWR VGND VPWR VGND sky130_ef_sc_hd__decap_12
XFILLER_0_45_615 VGND VGND VPWR VPWR sky130_fd_sc_hd__fill_1
XFILLER_0_45_626 VPWR VGND VPWR VGND sky130_ef_sc_hd__decap_12
XFILLER_0_72_434 VGND VGND VPWR VPWR sky130_fd_sc_hd__decap_8
X_8450_ clknet_leaf_34_clk net414 _0201_ VGND VGND VPWR VPWR carry3\[5\] sky130_fd_sc_hd__dfrtp_1
X_5662_ _2672_ _2519_ _2520_ VGND VGND VPWR VPWR _2679_ sky130_fd_sc_hd__nor3_1
XFILLER_0_29_199 VPWR VGND VPWR VGND sky130_ef_sc_hd__decap_12
XFILLER_0_44_125 VGND VGND VPWR VPWR sky130_fd_sc_hd__fill_1
X_4613_ net41 VGND VGND VPWR VPWR _1652_ sky130_fd_sc_hd__clkbuf_4
X_7401_ _4148_ VGND VGND VPWR VPWR _0410_ sky130_fd_sc_hd__inv_2
X_8381_ _1212_ _1213_ VGND VGND VPWR VPWR _1214_ sky130_fd_sc_hd__nor2_1
X_5593_ _2605_ _2608_ _2607_ _2549_ VGND VGND VPWR VPWR _2611_ sky130_fd_sc_hd__o31ai_4
XFILLER_0_32_309 VGND VGND VPWR VPWR sky130_fd_sc_hd__decap_6
XFILLER_0_103_709 VGND VGND VPWR VPWR sky130_fd_sc_hd__decap_8
X_4544_ _1523_ _1586_ _1587_ _1579_ VGND VGND VPWR VPWR _1588_ sky130_fd_sc_hd__o211a_1
Xhold402 _0681_ VGND VGND VPWR VPWR net444 sky130_fd_sc_hd__dlygate4sd3_1
XFILLER_0_20_60 VGND VGND VPWR VPWR sky130_fd_sc_hd__fill_1
X_7332_ _4136_ VGND VGND VPWR VPWR _4141_ sky130_fd_sc_hd__buf_4
X_7263_ _4133_ VGND VGND VPWR VPWR _0287_ sky130_fd_sc_hd__inv_2
X_6214_ _3206_ _3210_ _3191_ VGND VGND VPWR VPWR _3219_ sky130_fd_sc_hd__a21boi_2
X_4475_ _1464_ _1468_ _1463_ VGND VGND VPWR VPWR _1520_ sky130_fd_sc_hd__a21boi_1
XFILLER_0_0_461 VPWR VGND VPWR VGND sky130_ef_sc_hd__decap_12
X_7194_ _4127_ VGND VGND VPWR VPWR _0224_ sky130_fd_sc_hd__inv_2
X_6145_ _2882_ _3137_ _3150_ _3141_ VGND VGND VPWR VPWR _3151_ sky130_fd_sc_hd__o211a_2
XTAP_740 VGND VPWR sky130_fd_sc_hd__tapvpwrvgnd_1
XTAP_751 VGND VPWR sky130_fd_sc_hd__tapvpwrvgnd_1
X_6076_ _3033_ _2928_ VGND VGND VPWR VPWR _3083_ sky130_fd_sc_hd__nor2_1
XTAP_762 VGND VPWR sky130_fd_sc_hd__tapvpwrvgnd_1
XTAP_784 VGND VPWR sky130_fd_sc_hd__tapvpwrvgnd_1
XTAP_773 VGND VPWR sky130_fd_sc_hd__tapvpwrvgnd_1
XTAP_795 VGND VPWR sky130_fd_sc_hd__tapvpwrvgnd_1
X_5027_ sh4\[2\] VGND VGND VPWR VPWR _2057_ sky130_fd_sc_hd__clkbuf_4
XFILLER_0_67_206 VGND VGND VPWR VPWR sky130_fd_sc_hd__fill_1
XFILLER_0_95_559 VGND VGND VPWR VPWR sky130_fd_sc_hd__fill_1
XFILLER_0_67_239 VGND VGND VPWR VPWR sky130_fd_sc_hd__fill_1
X_8717_ clknet_leaf_13_clk _0125_ _0468_ VGND VGND VPWR VPWR bit_sum4\[8\] sky130_fd_sc_hd__dfrtp_1
X_6978_ _3955_ _3959_ _3964_ VGND VGND VPWR VPWR _3965_ sky130_fd_sc_hd__o21bai_1
XFILLER_0_48_431 VGND VGND VPWR VPWR sky130_fd_sc_hd__fill_1
X_5929_ _2896_ _2937_ sh14\[6\] VGND VGND VPWR VPWR _2938_ sky130_fd_sc_hd__o21ai_1
XFILLER_0_0_81 VGND VGND VPWR VPWR sky130_fd_sc_hd__decap_3
XFILLER_0_36_626 VPWR VGND VPWR VGND sky130_ef_sc_hd__decap_12
X_8648_ clknet_leaf_15_clk net120 _0399_ VGND VGND VPWR VPWR s5\[13\] sky130_fd_sc_hd__dfrtp_1
XFILLER_0_23_309 VGND VGND VPWR VPWR sky130_fd_sc_hd__decap_3
X_8579_ clknet_leaf_35_clk net349 _0330_ VGND VGND VPWR VPWR carry1\[2\] sky130_fd_sc_hd__dfrtp_1
XFILLER_0_44_681 VPWR VGND VPWR VGND sky130_ef_sc_hd__decap_12
XFILLER_0_101_263 VGND VGND VPWR VPWR sky130_fd_sc_hd__decap_4
XFILLER_0_8_3 VPWR VGND VPWR VGND sky130_ef_sc_hd__decap_12
XFILLER_0_116_29 VPWR VGND VPWR VGND sky130_ef_sc_hd__decap_12
XFILLER_0_59_729 VGND VGND VPWR VPWR sky130_fd_sc_hd__decap_6
XFILLER_0_86_526 VGND VGND VPWR VPWR sky130_fd_sc_hd__decap_6
XFILLER_0_82_721 VPWR VGND VPWR VGND sky130_ef_sc_hd__decap_12
XFILLER_0_39_464 VGND VGND VPWR VPWR sky130_fd_sc_hd__fill_1
XFILLER_0_41_15 VPWR VGND VPWR VGND sky130_ef_sc_hd__decap_12
XFILLER_0_81_231 VPWR VGND VPWR VGND sky130_ef_sc_hd__decap_12
XFILLER_0_26_125 VGND VGND VPWR VPWR sky130_fd_sc_hd__decap_3
XFILLER_0_14_309 VPWR VGND VPWR VGND sky130_ef_sc_hd__decap_12
XFILLER_0_81_297 VGND VGND VPWR VPWR sky130_fd_sc_hd__fill_1
XFILLER_0_35_670 VGND VGND VPWR VPWR sky130_fd_sc_hd__fill_2
XFILLER_0_1_225 VPWR VGND VPWR VGND sky130_ef_sc_hd__decap_12
XFILLER_0_22_375 VGND VGND VPWR VPWR sky130_fd_sc_hd__decap_4
XFILLER_0_50_695 VGND VGND VPWR VPWR sky130_fd_sc_hd__decap_4
XFILLER_0_120_583 VGND VGND VPWR VPWR sky130_fd_sc_hd__decap_4
X_4260_ _1292_ _1296_ VGND VGND VPWR VPWR _1308_ sky130_fd_sc_hd__nand2_1
XFILLER_0_5_15 VPWR VGND VPWR VGND sky130_ef_sc_hd__decap_12
X_7950_ sh10\[3\] _0797_ _0798_ VGND VGND VPWR VPWR _0799_ sky130_fd_sc_hd__a21o_2
XFILLER_0_89_364 VGND VGND VPWR VPWR sky130_fd_sc_hd__decap_8
X_7881_ _0730_ net42 VGND VGND VPWR VPWR _0731_ sky130_fd_sc_hd__nor2_4
X_6901_ _3880_ _3888_ _3790_ VGND VGND VPWR VPWR _3889_ sky130_fd_sc_hd__a21o_1
XFILLER_0_82_77 VGND VGND VPWR VPWR sky130_fd_sc_hd__decap_6
XFILLER_0_77_526 VPWR VGND VPWR VGND sky130_ef_sc_hd__decap_12
X_6832_ _3820_ _3728_ _3727_ VGND VGND VPWR VPWR _3821_ sky130_fd_sc_hd__o21ai_1
XFILLER_0_119_127 VGND VGND VPWR VPWR sky130_fd_sc_hd__fill_1
XFILLER_0_85_581 VGND VGND VPWR VPWR sky130_fd_sc_hd__decap_3
X_6763_ sh8\[1\] VGND VGND VPWR VPWR _3752_ sky130_fd_sc_hd__clkbuf_4
XFILLER_0_73_732 VGND VGND VPWR VPWR sky130_fd_sc_hd__decap_3
X_6694_ _3646_ _3649_ _3686_ VGND VGND VPWR VPWR _3687_ sky130_fd_sc_hd__o21ai_1
X_8502_ clknet_leaf_25_clk _0170_ _0253_ VGND VGND VPWR VPWR final_sum\[8\] sky130_fd_sc_hd__dfrtp_1
XFILLER_0_9_369 VGND VGND VPWR VPWR sky130_fd_sc_hd__decap_8
X_5714_ _2484_ _2490_ VGND VGND VPWR VPWR _2730_ sky130_fd_sc_hd__and2_2
XFILLER_0_122_83 VGND VGND VPWR VPWR sky130_fd_sc_hd__fill_1
X_8433_ _1261_ _1257_ _1262_ VGND VGND VPWR VPWR _1263_ sky130_fd_sc_hd__a21oi_1
XFILLER_0_72_253 VGND VGND VPWR VPWR sky130_fd_sc_hd__fill_2
X_5645_ _2660_ _2662_ _2601_ VGND VGND VPWR VPWR _2663_ sky130_fd_sc_hd__a21o_1
XFILLER_0_33_607 VGND VGND VPWR VPWR sky130_fd_sc_hd__decap_8
XFILLER_0_33_629 VPWR VGND VPWR VGND sky130_ef_sc_hd__decap_12
XFILLER_0_86_3 VPWR VGND VPWR VGND sky130_ef_sc_hd__decap_12
XFILLER_0_115_377 VGND VGND VPWR VPWR sky130_fd_sc_hd__decap_6
X_8364_ sum5\[13\] s7\[13\] VGND VGND VPWR VPWR _1198_ sky130_fd_sc_hd__nor2_1
Xhold210 _0719_ VGND VGND VPWR VPWR net252 sky130_fd_sc_hd__dlygate4sd3_1
X_5576_ _2587_ _2593_ _2594_ VGND VGND VPWR VPWR _2595_ sky130_fd_sc_hd__a21o_1
X_4527_ _1501_ _1525_ _1567_ _1570_ VGND VGND VPWR VPWR _1571_ sky130_fd_sc_hd__o211a_1
Xhold221 sh12\[4\] VGND VGND VPWR VPWR net263 sky130_fd_sc_hd__dlygate4sd3_1
Xhold232 _0018_ VGND VGND VPWR VPWR net274 sky130_fd_sc_hd__dlygate4sd3_1
XFILLER_0_13_386 VGND VGND VPWR VPWR sky130_fd_sc_hd__fill_1
XFILLER_0_41_673 VPWR VGND VPWR VGND sky130_ef_sc_hd__decap_12
X_8295_ _0806_ _0809_ _0808_ VGND VGND VPWR VPWR _1136_ sky130_fd_sc_hd__o21ai_1
X_7315_ _4139_ VGND VGND VPWR VPWR _0333_ sky130_fd_sc_hd__inv_2
Xhold243 _0063_ VGND VGND VPWR VPWR net285 sky130_fd_sc_hd__dlygate4sd3_1
X_4458_ _1498_ _1491_ _1492_ VGND VGND VPWR VPWR _1503_ sky130_fd_sc_hd__a21oi_1
X_7246_ _4132_ VGND VGND VPWR VPWR _0271_ sky130_fd_sc_hd__inv_2
Xhold254 _0038_ VGND VGND VPWR VPWR net296 sky130_fd_sc_hd__dlygate4sd3_1
Xhold265 _0071_ VGND VGND VPWR VPWR net307 sky130_fd_sc_hd__dlygate4sd3_1
Xhold276 _0024_ VGND VGND VPWR VPWR net318 sky130_fd_sc_hd__dlygate4sd3_1
Xhold287 sh12\[2\] VGND VGND VPWR VPWR net329 sky130_fd_sc_hd__dlygate4sd3_1
XFILLER_0_40_183 VGND VGND VPWR VPWR sky130_fd_sc_hd__fill_2
Xhold298 sh7\[6\] VGND VGND VPWR VPWR net340 sky130_fd_sc_hd__dlygate4sd3_1
X_7177_ _4125_ VGND VGND VPWR VPWR _4126_ sky130_fd_sc_hd__buf_4
X_4389_ _1429_ _1432_ _1434_ VGND VGND VPWR VPWR _1435_ sky130_fd_sc_hd__o21bai_2
X_6128_ _3069_ _3134_ VGND VGND VPWR VPWR _0139_ sky130_fd_sc_hd__xnor2_2
XTAP_570 VGND VPWR sky130_fd_sc_hd__tapvpwrvgnd_1
XTAP_581 VGND VPWR sky130_fd_sc_hd__tapvpwrvgnd_1
XTAP_592 VGND VPWR sky130_fd_sc_hd__tapvpwrvgnd_1
X_6059_ _3063_ _3066_ _2923_ VGND VGND VPWR VPWR _3067_ sky130_fd_sc_hd__nand3b_1
XTAP_1725 VGND VPWR sky130_fd_sc_hd__tapvpwrvgnd_1
XTAP_1714 VGND VPWR sky130_fd_sc_hd__tapvpwrvgnd_1
XTAP_1703 VGND VPWR sky130_fd_sc_hd__tapvpwrvgnd_1
XFILLER_0_95_323 VPWR VGND VPWR VGND sky130_ef_sc_hd__decap_12
XTAP_1758 VGND VPWR sky130_fd_sc_hd__tapvpwrvgnd_1
XTAP_1747 VGND VPWR sky130_fd_sc_hd__tapvpwrvgnd_1
XTAP_1736 VGND VPWR sky130_fd_sc_hd__tapvpwrvgnd_1
XFILLER_0_95_367 VGND VGND VPWR VPWR sky130_fd_sc_hd__decap_4
XTAP_1769 VGND VPWR sky130_fd_sc_hd__tapvpwrvgnd_1
XFILLER_0_95_378 VGND VGND VPWR VPWR sky130_fd_sc_hd__decap_8
XFILLER_0_63_220 VGND VGND VPWR VPWR sky130_fd_sc_hd__decap_4
XFILLER_0_48_294 VPWR VGND VPWR VGND sky130_ef_sc_hd__decap_12
XFILLER_0_106_300 VGND VGND VPWR VPWR sky130_fd_sc_hd__decap_8
XFILLER_0_63_242 VPWR VGND VPWR VGND sky130_ef_sc_hd__decap_12
XFILLER_0_106_333 VPWR VGND VPWR VGND sky130_ef_sc_hd__decap_12
XFILLER_0_91_584 VPWR VGND VPWR VGND sky130_ef_sc_hd__decap_12
XFILLER_0_51_426 VGND VGND VPWR VPWR sky130_fd_sc_hd__fill_1
XFILLER_0_32_673 VPWR VGND VPWR VGND sky130_ef_sc_hd__decap_12
XFILLER_0_102_561 VGND VGND VPWR VPWR sky130_fd_sc_hd__fill_1
XFILLER_0_36_15 VPWR VGND VPWR VGND sky130_ef_sc_hd__decap_12
XFILLER_0_36_59 VPWR VGND VPWR VGND sky130_ef_sc_hd__decap_12
XFILLER_0_99_673 VPWR VGND VPWR VGND sky130_ef_sc_hd__decap_12
XFILLER_0_86_345 VPWR VGND VPWR VGND sky130_ef_sc_hd__decap_12
XFILLER_0_86_389 VGND VGND VPWR VPWR sky130_fd_sc_hd__fill_2
XFILLER_0_67_570 VGND VGND VPWR VPWR sky130_fd_sc_hd__fill_2
XFILLER_0_46_209 VGND VGND VPWR VPWR sky130_fd_sc_hd__fill_1
XFILLER_0_6_306 VGND VGND VPWR VPWR sky130_fd_sc_hd__fill_2
XFILLER_0_70_713 VGND VGND VPWR VPWR sky130_fd_sc_hd__fill_2
XFILLER_0_109_193 VGND VGND VPWR VPWR sky130_fd_sc_hd__decap_3
X_5430_ _2368_ _2415_ _2412_ _2362_ VGND VGND VPWR VPWR _2453_ sky130_fd_sc_hd__a31o_1
XFILLER_0_112_325 VGND VGND VPWR VPWR sky130_fd_sc_hd__fill_1
XFILLER_0_2_501 VPWR VGND VPWR VGND sky130_ef_sc_hd__decap_12
XFILLER_0_2_545 VPWR VGND VPWR VGND sky130_ef_sc_hd__decap_12
XFILLER_0_23_673 VPWR VGND VPWR VGND sky130_ef_sc_hd__decap_12
X_5361_ _2373_ _2374_ _2376_ _2382_ _2385_ VGND VGND VPWR VPWR _2386_ sky130_fd_sc_hd__o2111ai_4
X_4312_ _1231_ sh2\[5\] VGND VGND VPWR VPWR _1359_ sky130_fd_sc_hd__nor2_1
XFILLER_0_77_55 VGND VGND VPWR VPWR sky130_fd_sc_hd__fill_1
X_7100_ _4079_ _4083_ _3961_ _3978_ VGND VGND VPWR VPWR _4084_ sky130_fd_sc_hd__o2bb2ai_2
XFILLER_0_2_589 VPWR VGND VPWR VGND sky130_ef_sc_hd__decap_12
X_5292_ _2256_ _2260_ _2252_ VGND VGND VPWR VPWR _2318_ sky130_fd_sc_hd__a21oi_2
X_8080_ _0899_ _0904_ _0885_ VGND VGND VPWR VPWR _0927_ sky130_fd_sc_hd__o21ai_2
X_4243_ _1288_ _1290_ _1242_ VGND VGND VPWR VPWR _1291_ sky130_fd_sc_hd__o21bai_1
X_7031_ _3930_ _4004_ _3994_ VGND VGND VPWR VPWR _4016_ sky130_fd_sc_hd__o21a_1
XFILLER_0_10_389 VGND VGND VPWR VPWR sky130_fd_sc_hd__decap_6
X_7933_ _0774_ _0773_ _0746_ VGND VGND VPWR VPWR _0782_ sky130_fd_sc_hd__o21ai_2
XFILLER_0_26_81 VGND VGND VPWR VPWR sky130_fd_sc_hd__decap_3
X_7864_ net326 net269 _0717_ VGND VGND VPWR VPWR _0044_ sky130_fd_sc_hd__o21a_1
XFILLER_0_9_111 VGND VGND VPWR VPWR sky130_fd_sc_hd__fill_1
X_6815_ _3750_ _3768_ sh14\[1\] _3803_ VGND VGND VPWR VPWR _3804_ sky130_fd_sc_hd__o211ai_1
X_7795_ net371 s1\[3\] net257 VGND VGND VPWR VPWR _0683_ sky130_fd_sc_hd__a21o_1
XFILLER_0_92_348 VGND VGND VPWR VPWR sky130_fd_sc_hd__fill_1
X_6746_ _3733_ _3734_ _3715_ VGND VGND VPWR VPWR _3735_ sky130_fd_sc_hd__o21ai_2
XFILLER_0_46_721 VPWR VGND VPWR VGND sky130_ef_sc_hd__decap_12
XFILLER_0_116_631 VGND VGND VPWR VPWR sky130_fd_sc_hd__decap_4
XFILLER_0_73_573 VGND VGND VPWR VPWR sky130_fd_sc_hd__decap_3
XFILLER_0_73_540 VGND VGND VPWR VPWR sky130_fd_sc_hd__decap_4
XFILLER_0_18_467 VGND VGND VPWR VPWR sky130_fd_sc_hd__decap_8
XFILLER_0_33_404 VGND VGND VPWR VPWR sky130_fd_sc_hd__decap_6
XFILLER_0_116_653 VPWR VGND VPWR VGND sky130_ef_sc_hd__decap_12
X_6677_ _3666_ _3670_ _3536_ _3566_ VGND VGND VPWR VPWR _3671_ sky130_fd_sc_hd__o2bb2ai_2
XFILLER_0_33_426 VPWR VGND VPWR VGND sky130_ef_sc_hd__decap_12
XFILLER_0_116_697 VGND VGND VPWR VPWR sky130_fd_sc_hd__decap_3
X_8416_ sh6\[5\] VGND VGND VPWR VPWR _1246_ sky130_fd_sc_hd__buf_4
XFILLER_0_60_245 VGND VGND VPWR VPWR sky130_fd_sc_hd__decap_3
X_5628_ _2590_ _2591_ _2581_ VGND VGND VPWR VPWR _2646_ sky130_fd_sc_hd__a21oi_1
X_8347_ _1180_ _1181_ _1182_ _1170_ VGND VGND VPWR VPWR _1183_ sky130_fd_sc_hd__o211a_1
X_5559_ _2555_ _2554_ _2510_ _2557_ VGND VGND VPWR VPWR _2578_ sky130_fd_sc_hd__o211ai_4
X_8278_ _1120_ _1121_ VGND VGND VPWR VPWR _0115_ sky130_fd_sc_hd__nand2_1
XFILLER_0_111_391 VGND VGND VPWR VPWR sky130_fd_sc_hd__fill_1
X_7229_ _4130_ VGND VGND VPWR VPWR _0256_ sky130_fd_sc_hd__inv_2
XTAP_1533 VGND VPWR sky130_fd_sc_hd__tapvpwrvgnd_1
XTAP_1522 VGND VPWR sky130_fd_sc_hd__tapvpwrvgnd_1
XTAP_1511 VGND VPWR sky130_fd_sc_hd__tapvpwrvgnd_1
XTAP_1500 VGND VPWR sky130_fd_sc_hd__tapvpwrvgnd_1
XPHY_40 VGND VGND VPWR VPWR sky130_fd_sc_hd__decap_3
XTAP_1555 VGND VPWR sky130_fd_sc_hd__tapvpwrvgnd_1
XTAP_1566 VGND VPWR sky130_fd_sc_hd__tapvpwrvgnd_1
XTAP_1544 VGND VPWR sky130_fd_sc_hd__tapvpwrvgnd_1
XFILLER_0_96_687 VPWR VGND VPWR VGND sky130_ef_sc_hd__decap_12
XPHY_51 VGND VGND VPWR VPWR sky130_fd_sc_hd__decap_3
XPHY_62 VGND VGND VPWR VPWR sky130_fd_sc_hd__decap_3
XPHY_73 VGND VGND VPWR VPWR sky130_fd_sc_hd__decap_3
XTAP_1599 VGND VPWR sky130_fd_sc_hd__tapvpwrvgnd_1
XTAP_1588 VGND VPWR sky130_fd_sc_hd__tapvpwrvgnd_1
XTAP_1577 VGND VPWR sky130_fd_sc_hd__tapvpwrvgnd_1
XFILLER_0_83_337 VPWR VGND VPWR VGND sky130_ef_sc_hd__decap_12
XPHY_84 VGND VGND VPWR VPWR sky130_fd_sc_hd__decap_3
XPHY_95 VGND VGND VPWR VPWR sky130_fd_sc_hd__decap_3
XFILLER_0_36_253 VGND VGND VPWR VPWR sky130_fd_sc_hd__fill_2
XFILLER_0_91_370 VGND VGND VPWR VPWR sky130_fd_sc_hd__decap_8
XFILLER_0_64_595 VGND VGND VPWR VPWR sky130_fd_sc_hd__fill_1
XFILLER_0_64_573 VGND VGND VPWR VPWR sky130_fd_sc_hd__decap_8
XFILLER_0_36_275 VPWR VGND VPWR VGND sky130_ef_sc_hd__decap_12
XFILLER_0_122_645 VGND VGND VPWR VPWR sky130_fd_sc_hd__fill_2
XFILLER_0_121_111 VGND VGND VPWR VPWR sky130_fd_sc_hd__fill_1
XFILLER_0_20_643 VGND VGND VPWR VPWR sky130_fd_sc_hd__fill_1
XFILLER_0_2_27 VGND VGND VPWR VPWR sky130_fd_sc_hd__fill_1
XFILLER_0_63_46 VGND VGND VPWR VPWR sky130_fd_sc_hd__decap_8
X_4930_ sh13\[7\] _1791_ VGND VGND VPWR VPWR _1964_ sky130_fd_sc_hd__and2_1
X_4861_ _1888_ VGND VGND VPWR VPWR _1897_ sky130_fd_sc_hd__inv_2
X_6600_ _3539_ _3540_ _3593_ _3595_ VGND VGND VPWR VPWR _3596_ sky130_fd_sc_hd__a31oi_1
X_4792_ _1824_ _1825_ _1828_ VGND VGND VPWR VPWR _1829_ sky130_fd_sc_hd__nand3_2
XFILLER_0_74_359 VGND VGND VPWR VPWR sky130_fd_sc_hd__decap_4
XFILLER_0_55_551 VGND VGND VPWR VPWR sky130_fd_sc_hd__decap_8
X_7580_ _4165_ VGND VGND VPWR VPWR _0572_ sky130_fd_sc_hd__inv_2
X_6531_ _3453_ _3526_ VGND VGND VPWR VPWR _3528_ sky130_fd_sc_hd__nor2_1
XFILLER_0_55_573 VGND VGND VPWR VPWR sky130_fd_sc_hd__decap_4
X_6462_ _3297_ _3298_ VGND VGND VPWR VPWR _3460_ sky130_fd_sc_hd__or2_1
XFILLER_0_12_94 VPWR VGND VPWR VGND sky130_ef_sc_hd__decap_12
XFILLER_0_70_598 VGND VGND VPWR VPWR sky130_fd_sc_hd__fill_2
X_6393_ _3337_ _3333_ _3388_ _3389_ _3339_ VGND VGND VPWR VPWR _3392_ sky130_fd_sc_hd__o221a_1
X_5413_ _2431_ _2383_ _2382_ _2389_ _2388_ VGND VGND VPWR VPWR _2437_ sky130_fd_sc_hd__a221o_2
X_8201_ _0992_ _0985_ _0991_ _1046_ VGND VGND VPWR VPWR _1047_ sky130_fd_sc_hd__a31o_1
XFILLER_0_113_667 VGND VGND VPWR VPWR sky130_fd_sc_hd__decap_4
X_5344_ _2339_ VGND VGND VPWR VPWR _2369_ sky130_fd_sc_hd__inv_2
X_8132_ _0884_ _0885_ _0897_ VGND VGND VPWR VPWR _0979_ sky130_fd_sc_hd__and3_1
XFILLER_0_112_177 VPWR VGND VPWR VGND sky130_ef_sc_hd__decap_12
XFILLER_0_10_153 VGND VGND VPWR VPWR sky130_fd_sc_hd__decap_6
XFILLER_0_10_131 VGND VGND VPWR VPWR sky130_fd_sc_hd__decap_3
X_5275_ _2154_ _2188_ _2225_ _2228_ VGND VGND VPWR VPWR _2302_ sky130_fd_sc_hd__o211a_1
XFILLER_0_10_186 VGND VGND VPWR VPWR sky130_fd_sc_hd__decap_8
XFILLER_0_10_175 VGND VGND VPWR VPWR sky130_fd_sc_hd__decap_8
X_8063_ _0906_ _0910_ _0842_ _0839_ VGND VGND VPWR VPWR _0911_ sky130_fd_sc_hd__o2bb2ai_2
X_4226_ sh13\[5\] VGND VGND VPWR VPWR _1274_ sky130_fd_sc_hd__buf_4
XFILLER_0_10_197 VPWR VGND VPWR VGND sky130_ef_sc_hd__decap_12
X_7014_ _3931_ _3932_ _3930_ VGND VGND VPWR VPWR _4000_ sky130_fd_sc_hd__a21oi_1
XFILLER_0_49_3 VPWR VGND VPWR VGND sky130_ef_sc_hd__decap_12
XFILLER_0_97_418 VGND VGND VPWR VPWR sky130_fd_sc_hd__fill_1
X_7916_ _0764_ VGND VGND VPWR VPWR _0765_ sky130_fd_sc_hd__buf_2
X_7847_ net299 s6\[6\] sum4\[6\] VGND VGND VPWR VPWR _0709_ sky130_fd_sc_hd__a21o_1
XFILLER_0_92_123 VPWR VGND VPWR VGND sky130_ef_sc_hd__decap_12
XFILLER_0_19_721 VGND VGND VPWR VPWR sky130_fd_sc_hd__decap_6
X_7778_ carry2\[5\] net310 _0674_ VGND VGND VPWR VPWR _0026_ sky130_fd_sc_hd__o21a_1
XFILLER_0_18_220 VGND VGND VPWR VPWR sky130_fd_sc_hd__decap_8
XFILLER_0_73_370 VPWR VGND VPWR VGND sky130_ef_sc_hd__decap_12
X_6729_ _3718_ _3713_ _3715_ VGND VGND VPWR VPWR _3719_ sky130_fd_sc_hd__a21oi_1
XFILLER_0_33_212 VPWR VGND VPWR VGND sky130_ef_sc_hd__decap_12
XFILLER_0_34_713 VGND VGND VPWR VPWR sky130_fd_sc_hd__fill_2
XFILLER_0_46_584 VGND VGND VPWR VPWR sky130_fd_sc_hd__fill_1
XFILLER_0_104_612 VPWR VGND VPWR VGND sky130_ef_sc_hd__decap_12
XFILLER_0_61_543 VPWR VGND VPWR VGND sky130_ef_sc_hd__decap_12
XFILLER_0_6_681 VPWR VGND VPWR VGND sky130_ef_sc_hd__decap_12
XFILLER_0_104_645 VGND VGND VPWR VPWR sky130_fd_sc_hd__decap_6
XFILLER_0_21_429 VPWR VGND VPWR VGND sky130_ef_sc_hd__decap_12
XFILLER_0_103_166 VGND VGND VPWR VPWR sky130_fd_sc_hd__fill_2
XFILLER_0_69_610 VGND VGND VPWR VPWR sky130_fd_sc_hd__decap_6
XFILLER_0_69_632 VPWR VGND VPWR VGND sky130_ef_sc_hd__decap_12
XFILLER_0_68_120 VGND VGND VPWR VPWR sky130_fd_sc_hd__decap_3
XTAP_1341 VGND VPWR sky130_fd_sc_hd__tapvpwrvgnd_1
XTAP_1330 VGND VPWR sky130_fd_sc_hd__tapvpwrvgnd_1
XFILLER_0_69_687 VGND VGND VPWR VPWR sky130_fd_sc_hd__decap_6
XFILLER_0_29_529 VPWR VGND VPWR VGND sky130_ef_sc_hd__decap_12
XFILLER_0_33_27 VPWR VGND VPWR VGND sky130_ef_sc_hd__decap_12
XTAP_1374 VGND VPWR sky130_fd_sc_hd__tapvpwrvgnd_1
XTAP_1363 VGND VPWR sky130_fd_sc_hd__tapvpwrvgnd_1
XTAP_1352 VGND VPWR sky130_fd_sc_hd__tapvpwrvgnd_1
XFILLER_0_68_197 VGND VGND VPWR VPWR sky130_fd_sc_hd__decap_8
XTAP_1396 VGND VPWR sky130_fd_sc_hd__tapvpwrvgnd_1
XTAP_1385 VGND VPWR sky130_fd_sc_hd__tapvpwrvgnd_1
XFILLER_0_71_307 VGND VGND VPWR VPWR sky130_fd_sc_hd__decap_4
XFILLER_0_107_461 VGND VGND VPWR VPWR sky130_fd_sc_hd__fill_1
XFILLER_0_64_392 VPWR VGND VPWR VGND sky130_ef_sc_hd__decap_12
XFILLER_0_52_587 VGND VGND VPWR VPWR sky130_fd_sc_hd__fill_1
X_5060_ _2061_ _2038_ VGND VGND VPWR VPWR _2089_ sky130_fd_sc_hd__nand2_1
X_5962_ _2970_ _2961_ _2953_ _2957_ VGND VGND VPWR VPWR _2971_ sky130_fd_sc_hd__a22o_1
X_8750_ clknet_leaf_64_clk net4 _0501_ VGND VGND VPWR VPWR sh0\[2\] sky130_fd_sc_hd__dfrtp_4
X_4913_ _1908_ _1947_ VGND VGND VPWR VPWR _1948_ sky130_fd_sc_hd__or2_4
X_7701_ carry1\[8\] net369 _4214_ VGND VGND VPWR VPWR _0019_ sky130_fd_sc_hd__o21a_1
X_5893_ _2877_ _2902_ VGND VGND VPWR VPWR _2903_ sky130_fd_sc_hd__or2_1
X_8681_ clknet_leaf_53_clk _0146_ _0432_ VGND VGND VPWR VPWR bit_sum1\[2\] sky130_fd_sc_hd__dfrtp_1
XFILLER_0_117_225 VGND VGND VPWR VPWR sky130_fd_sc_hd__fill_2
X_4844_ _1870_ _1871_ _1816_ VGND VGND VPWR VPWR _1880_ sky130_fd_sc_hd__a21oi_1
XFILLER_0_74_145 VGND VGND VPWR VPWR sky130_fd_sc_hd__fill_1
XFILLER_0_62_307 VGND VGND VPWR VPWR sky130_fd_sc_hd__fill_1
XFILLER_0_23_71 VPWR VGND VPWR VGND sky130_ef_sc_hd__decap_12
X_7632_ _4122_ VGND VGND VPWR VPWR _0620_ sky130_fd_sc_hd__inv_2
X_4775_ _1792_ _1795_ _1796_ VGND VGND VPWR VPWR _1812_ sky130_fd_sc_hd__o21ai_1
XFILLER_0_74_189 VGND VGND VPWR VPWR sky130_fd_sc_hd__decap_6
XFILLER_0_16_713 VGND VGND VPWR VPWR sky130_fd_sc_hd__fill_2
X_7563_ _4163_ VGND VGND VPWR VPWR _0557_ sky130_fd_sc_hd__inv_2
XFILLER_0_23_93 VPWR VGND VPWR VGND sky130_ef_sc_hd__decap_12
X_6514_ _3291_ _3287_ _3507_ _3292_ VGND VGND VPWR VPWR _3511_ sky130_fd_sc_hd__o211a_2
XFILLER_0_15_223 VGND VGND VPWR VPWR sky130_fd_sc_hd__fill_1
XFILLER_0_15_234 VGND VGND VPWR VPWR sky130_fd_sc_hd__decap_4
X_7494_ _4156_ VGND VGND VPWR VPWR _0495_ sky130_fd_sc_hd__inv_2
XFILLER_0_31_727 VGND VGND VPWR VPWR sky130_fd_sc_hd__fill_1
XFILLER_0_113_442 VGND VGND VPWR VPWR sky130_fd_sc_hd__decap_6
X_6445_ _3384_ _3442_ _3434_ _3439_ _3372_ VGND VGND VPWR VPWR _3443_ sky130_fd_sc_hd__o2111ai_4
XFILLER_0_3_673 VPWR VGND VPWR VGND sky130_ef_sc_hd__decap_12
XFILLER_0_30_215 VGND VGND VPWR VPWR sky130_fd_sc_hd__decap_3
XFILLER_0_113_497 VGND VGND VPWR VPWR sky130_fd_sc_hd__decap_6
XFILLER_0_100_114 VGND VGND VPWR VPWR sky130_fd_sc_hd__fill_1
X_6376_ _3367_ _3370_ _3373_ _3374_ VGND VGND VPWR VPWR _3375_ sky130_fd_sc_hd__o211ai_4
X_8115_ _0957_ _0961_ VGND VGND VPWR VPWR _0962_ sky130_fd_sc_hd__nand2_1
X_5327_ _2350_ _2351_ _2352_ VGND VGND VPWR VPWR _2353_ sky130_fd_sc_hd__nand3_2
X_8046_ _0893_ _0889_ _0830_ VGND VGND VPWR VPWR _0894_ sky130_fd_sc_hd__a21o_1
X_5258_ _2276_ _2278_ _2279_ _2284_ VGND VGND VPWR VPWR _2285_ sky130_fd_sc_hd__o211ai_4
X_5189_ _2211_ _2208_ VGND VGND VPWR VPWR _2217_ sky130_fd_sc_hd__nand2_2
XFILLER_0_3_81 VPWR VGND VPWR VGND sky130_ef_sc_hd__decap_12
XFILLER_0_66_668 VPWR VGND VPWR VGND sky130_ef_sc_hd__decap_12
XFILLER_0_65_134 VGND VGND VPWR VPWR sky130_fd_sc_hd__fill_1
XFILLER_0_93_487 VPWR VGND VPWR VGND sky130_ef_sc_hd__decap_12
XFILLER_0_81_649 VGND VGND VPWR VPWR sky130_fd_sc_hd__decap_6
XFILLER_0_65_167 VGND VGND VPWR VPWR sky130_fd_sc_hd__fill_1
XFILLER_0_61_362 VGND VGND VPWR VPWR sky130_fd_sc_hd__decap_3
XFILLER_0_34_587 VGND VGND VPWR VPWR sky130_fd_sc_hd__fill_1
XFILLER_0_104_464 VGND VGND VPWR VPWR sky130_fd_sc_hd__decap_6
XFILLER_0_0_109 VGND VGND VPWR VPWR sky130_fd_sc_hd__decap_3
XFILLER_0_104_497 VGND VGND VPWR VPWR sky130_fd_sc_hd__fill_1
XFILLER_0_21_248 VPWR VGND VPWR VGND sky130_ef_sc_hd__decap_12
XFILLER_0_28_27 VGND VGND VPWR VPWR sky130_fd_sc_hd__fill_1
XFILLER_0_89_727 VGND VGND VPWR VPWR sky130_fd_sc_hd__fill_1
XFILLER_0_44_15 VPWR VGND VPWR VGND sky130_ef_sc_hd__decap_12
XFILLER_0_69_495 VGND VGND VPWR VPWR sky130_fd_sc_hd__decap_8
XFILLER_0_8_209 VGND VGND VPWR VPWR sky130_fd_sc_hd__decap_6
XFILLER_0_29_326 VGND VGND VPWR VPWR sky130_fd_sc_hd__decap_4
XFILLER_0_29_337 VGND VGND VPWR VPWR sky130_fd_sc_hd__decap_8
XTAP_1182 VGND VPWR sky130_fd_sc_hd__tapvpwrvgnd_1
XTAP_1171 VGND VPWR sky130_fd_sc_hd__tapvpwrvgnd_1
XTAP_1160 VGND VPWR sky130_fd_sc_hd__tapvpwrvgnd_1
XFILLER_0_57_657 VPWR VGND VPWR VGND sky130_ef_sc_hd__decap_12
XFILLER_0_56_156 VPWR VGND VPWR VGND sky130_ef_sc_hd__decap_12
XTAP_1193 VGND VPWR sky130_fd_sc_hd__tapvpwrvgnd_1
XFILLER_0_71_104 VGND VGND VPWR VPWR sky130_fd_sc_hd__decap_8
X_4560_ _1599_ _1601_ _1602_ VGND VGND VPWR VPWR _1603_ sky130_fd_sc_hd__a21o_1
XFILLER_0_107_3 VPWR VGND VPWR VGND sky130_ef_sc_hd__decap_12
XFILLER_0_8_15 VPWR VGND VPWR VGND sky130_ef_sc_hd__decap_12
XFILLER_0_13_727 VGND VGND VPWR VPWR sky130_fd_sc_hd__fill_1
X_4491_ _1417_ _1482_ _1480_ _1475_ VGND VGND VPWR VPWR _1536_ sky130_fd_sc_hd__a2bb2o_1
X_6230_ _3232_ _3233_ _3234_ VGND VGND VPWR VPWR _3235_ sky130_fd_sc_hd__nand3_1
X_6161_ _3164_ _3154_ _3166_ VGND VGND VPWR VPWR _3167_ sky130_fd_sc_hd__o21ai_2
XFILLER_0_100_75 VGND VGND VPWR VPWR sky130_fd_sc_hd__decap_8
XTAP_900 VGND VPWR sky130_fd_sc_hd__tapvpwrvgnd_1
XTAP_944 VGND VPWR sky130_fd_sc_hd__tapvpwrvgnd_1
X_5112_ _2061_ sh3\[2\] VGND VGND VPWR VPWR _2141_ sky130_fd_sc_hd__nand2_1
XTAP_911 VGND VPWR sky130_fd_sc_hd__tapvpwrvgnd_1
XTAP_922 VGND VPWR sky130_fd_sc_hd__tapvpwrvgnd_1
XTAP_933 VGND VPWR sky130_fd_sc_hd__tapvpwrvgnd_1
X_6092_ _3095_ _3009_ VGND VGND VPWR VPWR _3099_ sky130_fd_sc_hd__and2_1
XFILLER_0_85_55 VGND VGND VPWR VPWR sky130_fd_sc_hd__fill_1
XTAP_977 VGND VPWR sky130_fd_sc_hd__tapvpwrvgnd_1
XTAP_966 VGND VPWR sky130_fd_sc_hd__tapvpwrvgnd_1
XTAP_955 VGND VPWR sky130_fd_sc_hd__tapvpwrvgnd_1
XTAP_999 VGND VPWR sky130_fd_sc_hd__tapvpwrvgnd_1
XTAP_988 VGND VPWR sky130_fd_sc_hd__tapvpwrvgnd_1
X_5043_ _2071_ _2072_ VGND VGND VPWR VPWR _2073_ sky130_fd_sc_hd__or2_2
XFILLER_0_95_708 VPWR VGND VPWR VGND sky130_ef_sc_hd__decap_12
X_8802_ clknet_leaf_6_clk net163 _0553_ VGND VGND VPWR VPWR sh6\[6\] sky130_fd_sc_hd__dfrtp_1
X_6994_ _3971_ _3976_ _3979_ VGND VGND VPWR VPWR _3980_ sky130_fd_sc_hd__nand3_1
X_5945_ _2890_ _2883_ net39 VGND VGND VPWR VPWR _2954_ sky130_fd_sc_hd__a21o_2
X_8733_ clknet_leaf_15_clk _0139_ _0484_ VGND VGND VPWR VPWR bit_sum6\[4\] sky130_fd_sc_hd__dfrtp_1
XFILLER_0_87_281 VGND VGND VPWR VPWR sky130_fd_sc_hd__decap_4
XFILLER_0_87_270 VGND VGND VPWR VPWR sky130_fd_sc_hd__decap_8
XFILLER_0_118_523 VGND VGND VPWR VPWR sky130_fd_sc_hd__decap_8
X_5876_ net39 VGND VGND VPWR VPWR _2886_ sky130_fd_sc_hd__clkbuf_4
X_8664_ clknet_leaf_24_clk net50 _0415_ VGND VGND VPWR VPWR s7\[11\] sky130_fd_sc_hd__dfrtp_1
X_4827_ _1768_ _1858_ VGND VGND VPWR VPWR _1863_ sky130_fd_sc_hd__and2_1
X_7615_ _4168_ VGND VGND VPWR VPWR _0604_ sky130_fd_sc_hd__inv_2
XFILLER_0_118_589 VGND VGND VPWR VPWR sky130_fd_sc_hd__decap_8
X_8595_ clknet_leaf_52_clk net226 _0346_ VGND VGND VPWR VPWR sum1\[7\] sky130_fd_sc_hd__dfrtp_1
X_4758_ net31 sh9\[7\] VGND VGND VPWR VPWR _1795_ sky130_fd_sc_hd__and2_1
X_7546_ _4162_ VGND VGND VPWR VPWR _0541_ sky130_fd_sc_hd__inv_2
XFILLER_0_120_209 VPWR VGND VPWR VGND sky130_ef_sc_hd__decap_12
X_4689_ _1724_ _1726_ VGND VGND VPWR VPWR _1727_ sky130_fd_sc_hd__or2_1
X_7477_ _4155_ VGND VGND VPWR VPWR _0479_ sky130_fd_sc_hd__inv_2
XFILLER_0_71_693 VPWR VGND VPWR VGND sky130_ef_sc_hd__decap_12
X_6428_ _3294_ sh2\[4\] VGND VGND VPWR VPWR _3426_ sky130_fd_sc_hd__and2_2
X_6359_ _3311_ _3357_ _3308_ VGND VGND VPWR VPWR _3358_ sky130_fd_sc_hd__a21oi_1
X_8029_ _0736_ _0723_ _0874_ VGND VGND VPWR VPWR _0877_ sky130_fd_sc_hd__a21oi_2
XPHY_210 VGND VGND VPWR VPWR sky130_fd_sc_hd__decap_3
XFILLER_0_14_29 VPWR VGND VPWR VGND sky130_ef_sc_hd__decap_12
XFILLER_0_38_101 VGND VGND VPWR VPWR sky130_fd_sc_hd__decap_8
XPHY_243 VGND VGND VPWR VPWR sky130_fd_sc_hd__decap_3
XPHY_232 VGND VGND VPWR VPWR sky130_fd_sc_hd__decap_3
XPHY_221 VGND VGND VPWR VPWR sky130_fd_sc_hd__decap_3
XFILLER_0_38_189 VGND VGND VPWR VPWR sky130_fd_sc_hd__decap_6
XFILLER_0_81_435 VGND VGND VPWR VPWR sky130_fd_sc_hd__decap_8
XFILLER_0_53_148 VGND VGND VPWR VPWR sky130_fd_sc_hd__decap_4
XFILLER_0_53_126 VGND VGND VPWR VPWR sky130_fd_sc_hd__fill_2
XFILLER_0_62_660 VPWR VGND VPWR VGND sky130_ef_sc_hd__decap_12
XFILLER_0_39_15 VPWR VGND VPWR VGND sky130_ef_sc_hd__decap_12
Xhold3 sum4\[0\] VGND VGND VPWR VPWR net45 sky130_fd_sc_hd__dlygate4sd3_1
XFILLER_0_89_524 VPWR VGND VPWR VGND sky130_ef_sc_hd__decap_12
XFILLER_0_89_513 VGND VGND VPWR VPWR sky130_fd_sc_hd__decap_8
XFILLER_0_77_719 VGND VGND VPWR VPWR sky130_fd_sc_hd__decap_8
XFILLER_0_119_309 VGND VGND VPWR VPWR sky130_fd_sc_hd__fill_2
XFILLER_0_69_281 VPWR VGND VPWR VGND sky130_ef_sc_hd__decap_12
XFILLER_0_69_270 VGND VGND VPWR VPWR sky130_fd_sc_hd__decap_8
XFILLER_0_71_57 VGND VGND VPWR VPWR sky130_fd_sc_hd__decap_3
X_5730_ _2734_ _2739_ _2745_ VGND VGND VPWR VPWR _2746_ sky130_fd_sc_hd__nand3_1
XFILLER_0_29_145 VPWR VGND VPWR VGND sky130_ef_sc_hd__decap_12
XFILLER_0_45_638 VPWR VGND VPWR VGND sky130_ef_sc_hd__decap_12
X_7400_ _4148_ VGND VGND VPWR VPWR _0409_ sky130_fd_sc_hd__inv_2
XFILLER_0_72_424 VGND VGND VPWR VPWR sky130_fd_sc_hd__fill_2
X_5661_ _2519_ _2520_ _2672_ VGND VGND VPWR VPWR _2678_ sky130_fd_sc_hd__o21a_1
X_4612_ sh0\[7\] VGND VGND VPWR VPWR _1651_ sky130_fd_sc_hd__clkinv_4
X_8380_ _1209_ _1210_ _1211_ VGND VGND VPWR VPWR _1213_ sky130_fd_sc_hd__a21oi_1
X_5592_ _2604_ _2605_ _2607_ _2609_ VGND VGND VPWR VPWR _2610_ sky130_fd_sc_hd__o211a_4
X_4543_ _1519_ _1580_ _1520_ VGND VGND VPWR VPWR _1587_ sky130_fd_sc_hd__a21oi_1
XFILLER_0_53_671 VGND VGND VPWR VPWR sky130_fd_sc_hd__fill_1
X_7331_ _4140_ VGND VGND VPWR VPWR _0348_ sky130_fd_sc_hd__inv_2
X_7262_ _4133_ VGND VGND VPWR VPWR _0286_ sky130_fd_sc_hd__inv_2
XFILLER_0_20_83 VGND VGND VPWR VPWR sky130_fd_sc_hd__fill_1
Xhold403 sh7\[0\] VGND VGND VPWR VPWR net445 sky130_fd_sc_hd__dlygate4sd3_1
X_6213_ _3151_ _3217_ _3206_ _3210_ VGND VGND VPWR VPWR _3218_ sky130_fd_sc_hd__o211a_2
X_4474_ _1514_ _1518_ VGND VGND VPWR VPWR _1519_ sky130_fd_sc_hd__nand2_1
XFILLER_0_40_365 VPWR VGND VPWR VGND sky130_ef_sc_hd__decap_12
XFILLER_0_110_253 VGND VGND VPWR VPWR sky130_fd_sc_hd__decap_4
XFILLER_0_96_65 VPWR VGND VPWR VGND sky130_ef_sc_hd__decap_12
XFILLER_0_0_473 VGND VGND VPWR VPWR sky130_fd_sc_hd__decap_3
X_7193_ _4127_ VGND VGND VPWR VPWR _0223_ sky130_fd_sc_hd__inv_2
X_6144_ _2889_ _2936_ _3139_ VGND VGND VPWR VPWR _3150_ sky130_fd_sc_hd__a21o_1
XTAP_730 VGND VPWR sky130_fd_sc_hd__tapvpwrvgnd_1
XTAP_741 VGND VPWR sky130_fd_sc_hd__tapvpwrvgnd_1
XTAP_752 VGND VPWR sky130_fd_sc_hd__tapvpwrvgnd_1
X_6075_ _3000_ _3016_ _3080_ _2882_ _3081_ VGND VGND VPWR VPWR _3082_ sky130_fd_sc_hd__o221ai_4
XTAP_763 VGND VPWR sky130_fd_sc_hd__tapvpwrvgnd_1
XTAP_785 VGND VPWR sky130_fd_sc_hd__tapvpwrvgnd_1
XTAP_774 VGND VPWR sky130_fd_sc_hd__tapvpwrvgnd_1
X_5026_ _2051_ _2053_ _2055_ VGND VGND VPWR VPWR _2056_ sky130_fd_sc_hd__or3_1
XFILLER_0_31_3 VPWR VGND VPWR VGND sky130_ef_sc_hd__decap_12
XTAP_796 VGND VPWR sky130_fd_sc_hd__tapvpwrvgnd_1
XFILLER_0_45_80 VPWR VGND VPWR VGND sky130_ef_sc_hd__decap_12
X_6977_ _3962_ _3963_ _3958_ VGND VGND VPWR VPWR _3964_ sky130_fd_sc_hd__a21oi_1
XFILLER_0_48_421 VGND VGND VPWR VPWR sky130_fd_sc_hd__decap_3
X_5928_ net37 _2936_ _2893_ VGND VGND VPWR VPWR _2937_ sky130_fd_sc_hd__o21a_1
X_8716_ clknet_leaf_13_clk _0124_ _0467_ VGND VGND VPWR VPWR bit_sum4\[7\] sky130_fd_sc_hd__dfrtp_1
X_5859_ sh10\[6\] sh11\[6\] VGND VGND VPWR VPWR _2869_ sky130_fd_sc_hd__nor2_1
XFILLER_0_90_221 VGND VGND VPWR VPWR sky130_fd_sc_hd__decap_4
X_8647_ clknet_leaf_15_clk net52 _0398_ VGND VGND VPWR VPWR s5\[12\] sky130_fd_sc_hd__dfrtp_1
XFILLER_0_75_284 VGND VGND VPWR VPWR sky130_fd_sc_hd__fill_2
XFILLER_0_36_638 VGND VGND VPWR VPWR sky130_fd_sc_hd__decap_6
X_8578_ clknet_leaf_37_clk _0001_ _0329_ VGND VGND VPWR VPWR carry1\[1\] sky130_fd_sc_hd__dfrtp_1
X_7529_ _4160_ VGND VGND VPWR VPWR _0526_ sky130_fd_sc_hd__inv_2
XFILLER_0_31_310 VGND VGND VPWR VPWR sky130_fd_sc_hd__decap_6
XFILLER_0_44_693 VGND VGND VPWR VPWR sky130_fd_sc_hd__decap_6
XFILLER_0_50_118 VPWR VGND VPWR VGND sky130_ef_sc_hd__decap_12
XFILLER_0_16_395 VGND VGND VPWR VPWR sky130_fd_sc_hd__decap_3
XFILLER_0_43_192 VGND VGND VPWR VPWR sky130_fd_sc_hd__fill_2
XFILLER_0_101_242 VGND VGND VPWR VPWR sky130_fd_sc_hd__fill_1
XFILLER_0_86_505 VGND VGND VPWR VPWR sky130_fd_sc_hd__fill_1
XFILLER_0_25_39 VGND VGND VPWR VPWR sky130_fd_sc_hd__decap_8
XFILLER_0_54_402 VPWR VGND VPWR VGND sky130_ef_sc_hd__decap_12
XFILLER_0_41_27 VPWR VGND VPWR VGND sky130_ef_sc_hd__decap_12
XFILLER_0_82_733 VGND VGND VPWR VPWR sky130_fd_sc_hd__fill_2
XFILLER_0_81_221 VGND VGND VPWR VPWR sky130_fd_sc_hd__decap_3
XFILLER_0_54_446 VPWR VGND VPWR VGND sky130_ef_sc_hd__decap_12
XFILLER_0_27_649 VGND VGND VPWR VPWR sky130_fd_sc_hd__decap_3
XFILLER_0_81_243 VPWR VGND VPWR VGND sky130_ef_sc_hd__decap_12
XFILLER_0_105_581 VGND VGND VPWR VPWR sky130_fd_sc_hd__decap_3
XFILLER_0_34_192 VGND VGND VPWR VPWR sky130_fd_sc_hd__decap_4
XFILLER_0_1_237 VPWR VGND VPWR VGND sky130_ef_sc_hd__decap_12
XFILLER_0_22_365 VGND VGND VPWR VPWR sky130_fd_sc_hd__fill_1
XFILLER_0_50_663 VGND VGND VPWR VPWR sky130_fd_sc_hd__fill_1
XFILLER_0_5_27 VPWR VGND VPWR VGND sky130_ef_sc_hd__decap_12
XFILLER_0_77_505 VGND VGND VPWR VPWR sky130_fd_sc_hd__fill_1
X_7880_ sh1\[3\] VGND VGND VPWR VPWR _0730_ sky130_fd_sc_hd__buf_4
X_6900_ _3884_ _3885_ _3887_ VGND VGND VPWR VPWR _3888_ sky130_fd_sc_hd__nand3_1
X_6831_ _3711_ _3714_ _3715_ VGND VGND VPWR VPWR _3820_ sky130_fd_sc_hd__and3_1
XFILLER_0_106_85 VGND VGND VPWR VPWR sky130_fd_sc_hd__decap_6
XFILLER_0_119_139 VGND VGND VPWR VPWR sky130_fd_sc_hd__fill_1
X_8501_ clknet_leaf_40_clk _0163_ _0252_ VGND VGND VPWR VPWR final_sum\[7\] sky130_fd_sc_hd__dfrtp_1
X_6762_ _3750_ sh7\[1\] sh8\[1\] VGND VGND VPWR VPWR _3751_ sky130_fd_sc_hd__o21ai_4
X_6693_ _3638_ _3641_ _3643_ _3599_ _3683_ VGND VGND VPWR VPWR _3686_ sky130_fd_sc_hd__o2111a_1
X_5713_ _2688_ _2692_ _2683_ VGND VGND VPWR VPWR _2729_ sky130_fd_sc_hd__a21boi_1
X_8432_ sh15\[5\] VGND VGND VPWR VPWR _1262_ sky130_fd_sc_hd__inv_2
XFILLER_0_60_405 VGND VGND VPWR VPWR sky130_fd_sc_hd__decap_8
XFILLER_0_5_510 VGND VGND VPWR VPWR sky130_fd_sc_hd__fill_2
XFILLER_0_26_660 VPWR VGND VPWR VGND sky130_ef_sc_hd__decap_12
X_5644_ _2650_ _2661_ _2653_ _2521_ VGND VGND VPWR VPWR _2662_ sky130_fd_sc_hd__o211ai_2
XFILLER_0_115_345 VGND VGND VPWR VPWR sky130_fd_sc_hd__fill_2
X_8363_ sum5\[13\] s7\[13\] VGND VGND VPWR VPWR _1197_ sky130_fd_sc_hd__and2_1
XFILLER_0_72_276 VGND VGND VPWR VPWR sky130_fd_sc_hd__decap_4
XFILLER_0_31_93 VGND VGND VPWR VPWR sky130_fd_sc_hd__fill_2
XFILLER_0_32_118 VGND VGND VPWR VPWR sky130_fd_sc_hd__fill_1
XFILLER_0_79_3 VPWR VGND VPWR VGND sky130_ef_sc_hd__decap_12
Xhold200 _0068_ VGND VGND VPWR VPWR net242 sky130_fd_sc_hd__dlygate4sd3_1
Xhold211 s3\[10\] VGND VGND VPWR VPWR net253 sky130_fd_sc_hd__dlygate4sd3_1
X_5575_ _2538_ _2541_ _2532_ VGND VGND VPWR VPWR _2594_ sky130_fd_sc_hd__o21ai_2
X_7314_ _4139_ VGND VGND VPWR VPWR _0332_ sky130_fd_sc_hd__inv_2
X_4526_ _1541_ _1542_ _1568_ _1569_ VGND VGND VPWR VPWR _1570_ sky130_fd_sc_hd__o22ai_4
Xhold244 sh6\[5\] VGND VGND VPWR VPWR net286 sky130_fd_sc_hd__dlygate4sd3_1
Xhold233 s5\[13\] VGND VGND VPWR VPWR net275 sky130_fd_sc_hd__dlygate4sd3_1
Xhold222 sum4\[13\] VGND VGND VPWR VPWR net264 sky130_fd_sc_hd__dlygate4sd3_1
X_8294_ _1134_ _1135_ VGND VGND VPWR VPWR _0117_ sky130_fd_sc_hd__nand2_1
XFILLER_0_41_685 VPWR VGND VPWR VGND sky130_ef_sc_hd__decap_12
X_4457_ _1491_ _1492_ _1498_ VGND VGND VPWR VPWR _1502_ sky130_fd_sc_hd__and3_1
Xhold277 s6\[6\] VGND VGND VPWR VPWR net319 sky130_fd_sc_hd__dlygate4sd3_1
X_7245_ _4132_ VGND VGND VPWR VPWR _0270_ sky130_fd_sc_hd__inv_2
Xhold255 sum3\[4\] VGND VGND VPWR VPWR net297 sky130_fd_sc_hd__dlygate4sd3_1
XFILLER_0_13_398 VPWR VGND VPWR VGND sky130_ef_sc_hd__decap_12
Xhold266 sh2\[2\] VGND VGND VPWR VPWR net308 sky130_fd_sc_hd__dlygate4sd3_1
Xhold288 sh9\[3\] VGND VGND VPWR VPWR net330 sky130_fd_sc_hd__dlygate4sd3_1
X_7176_ _4121_ VGND VGND VPWR VPWR _4125_ sky130_fd_sc_hd__clkbuf_4
XFILLER_0_0_281 VPWR VGND VPWR VGND sky130_ef_sc_hd__decap_12
Xhold299 sh4\[2\] VGND VGND VPWR VPWR net341 sky130_fd_sc_hd__dlygate4sd3_1
X_4388_ _1433_ _1373_ _1361_ VGND VGND VPWR VPWR _1434_ sky130_fd_sc_hd__o21ai_4
X_6127_ _3123_ _3129_ _3133_ VGND VGND VPWR VPWR _3134_ sky130_fd_sc_hd__a21oi_1
XTAP_560 VGND VPWR sky130_fd_sc_hd__tapvpwrvgnd_1
XTAP_571 VGND VPWR sky130_fd_sc_hd__tapvpwrvgnd_1
XTAP_582 VGND VPWR sky130_fd_sc_hd__tapvpwrvgnd_1
XTAP_593 VGND VPWR sky130_fd_sc_hd__tapvpwrvgnd_1
X_6058_ _3061_ _3062_ _3059_ VGND VGND VPWR VPWR _3066_ sky130_fd_sc_hd__nand3_1
X_5009_ sh10\[2\] sh11\[2\] VGND VGND VPWR VPWR _2039_ sky130_fd_sc_hd__and2_2
XTAP_1715 VGND VPWR sky130_fd_sc_hd__tapvpwrvgnd_1
XTAP_1704 VGND VPWR sky130_fd_sc_hd__tapvpwrvgnd_1
XTAP_1748 VGND VPWR sky130_fd_sc_hd__tapvpwrvgnd_1
XTAP_1726 VGND VPWR sky130_fd_sc_hd__tapvpwrvgnd_1
XTAP_1737 VGND VPWR sky130_fd_sc_hd__tapvpwrvgnd_1
XFILLER_0_95_335 VGND VGND VPWR VPWR sky130_fd_sc_hd__fill_1
XFILLER_0_68_549 VGND VGND VPWR VPWR sky130_fd_sc_hd__fill_1
XTAP_1759 VGND VPWR sky130_fd_sc_hd__tapvpwrvgnd_1
XFILLER_0_48_251 VGND VGND VPWR VPWR sky130_fd_sc_hd__fill_1
XFILLER_0_119_673 VPWR VGND VPWR VGND sky130_ef_sc_hd__decap_12
XFILLER_0_64_733 VGND VGND VPWR VPWR sky130_fd_sc_hd__fill_2
XFILLER_0_63_254 VGND VGND VPWR VPWR sky130_fd_sc_hd__fill_2
XFILLER_0_36_468 VGND VGND VPWR VPWR sky130_fd_sc_hd__decap_8
XFILLER_0_106_345 VGND VGND VPWR VPWR sky130_fd_sc_hd__fill_1
XFILLER_0_32_685 VPWR VGND VPWR VGND sky130_ef_sc_hd__decap_12
XFILLER_0_36_27 VGND VGND VPWR VPWR sky130_fd_sc_hd__fill_1
XFILLER_0_99_641 VPWR VGND VPWR VGND sky130_ef_sc_hd__decap_12
Xclkbuf_leaf_56_clk clknet_3_1__leaf_clk VGND VGND VPWR VPWR clknet_leaf_56_clk sky130_fd_sc_hd__clkbuf_16
XFILLER_0_99_685 VPWR VGND VPWR VGND sky130_ef_sc_hd__decap_12
XFILLER_0_86_357 VGND VGND VPWR VPWR sky130_fd_sc_hd__decap_4
XFILLER_0_52_37 VPWR VGND VPWR VGND sky130_ef_sc_hd__decap_12
XFILLER_0_39_240 VGND VGND VPWR VPWR sky130_fd_sc_hd__decap_3
XFILLER_0_27_435 VPWR VGND VPWR VGND sky130_ef_sc_hd__decap_12
XFILLER_0_6_329 VGND VGND VPWR VPWR sky130_fd_sc_hd__decap_8
XFILLER_0_82_585 VGND VGND VPWR VPWR sky130_fd_sc_hd__decap_3
XFILLER_0_2_513 VPWR VGND VPWR VGND sky130_ef_sc_hd__decap_12
XFILLER_0_2_557 VPWR VGND VPWR VGND sky130_ef_sc_hd__decap_12
XFILLER_0_23_685 VPWR VGND VPWR VGND sky130_ef_sc_hd__decap_12
X_5360_ _2383_ _2381_ _2384_ VGND VGND VPWR VPWR _2385_ sky130_fd_sc_hd__a21o_1
X_4311_ _1237_ _1268_ _1235_ VGND VGND VPWR VPWR _1358_ sky130_fd_sc_hd__o21ai_2
XFILLER_0_22_195 VGND VGND VPWR VPWR sky130_fd_sc_hd__fill_1
X_5291_ _2249_ _2267_ _2276_ VGND VGND VPWR VPWR _2317_ sky130_fd_sc_hd__o21ai_1
X_4242_ _1239_ _1235_ VGND VGND VPWR VPWR _1290_ sky130_fd_sc_hd__nor2_1
X_7030_ _3999_ VGND VGND VPWR VPWR _4015_ sky130_fd_sc_hd__inv_2
XFILLER_0_93_55 VGND VGND VPWR VPWR sky130_fd_sc_hd__fill_1
XFILLER_0_117_51 VGND VGND VPWR VPWR sky130_fd_sc_hd__decap_4
XFILLER_0_93_77 VGND VGND VPWR VPWR sky130_fd_sc_hd__fill_1
X_7932_ _0736_ _0737_ _0771_ VGND VGND VPWR VPWR _0781_ sky130_fd_sc_hd__a21oi_1
XFILLER_0_117_84 VGND VGND VPWR VPWR sky130_fd_sc_hd__fill_1
XFILLER_0_89_151 VGND VGND VPWR VPWR sky130_fd_sc_hd__decap_8
Xclkbuf_leaf_47_clk clknet_3_4__leaf_clk VGND VGND VPWR VPWR clknet_leaf_47_clk sky130_fd_sc_hd__clkbuf_16
X_7863_ carry4\[13\] net269 sum4\[14\] VGND VGND VPWR VPWR _0717_ sky130_fd_sc_hd__a21o_1
XFILLER_0_77_357 VPWR VGND VPWR VGND sky130_ef_sc_hd__decap_12
XFILLER_0_77_335 VGND VGND VPWR VPWR sky130_fd_sc_hd__fill_1
XFILLER_0_65_508 VPWR VGND VPWR VGND sky130_ef_sc_hd__decap_12
X_6814_ _3750_ _3768_ _3724_ VGND VGND VPWR VPWR _3803_ sky130_fd_sc_hd__a21o_1
X_7794_ net348 s1\[2\] _0682_ VGND VGND VPWR VPWR _0002_ sky130_fd_sc_hd__o21a_1
X_6745_ sh0\[1\] sh3\[1\] VGND VGND VPWR VPWR _3734_ sky130_fd_sc_hd__and2_2
XFILLER_0_9_167 VGND VGND VPWR VPWR sky130_fd_sc_hd__fill_1
XFILLER_0_46_733 VGND VGND VPWR VPWR sky130_fd_sc_hd__fill_2
XFILLER_0_18_446 VPWR VGND VPWR VGND sky130_ef_sc_hd__decap_12
XFILLER_0_116_665 VPWR VGND VPWR VGND sky130_ef_sc_hd__decap_12
XFILLER_0_116_643 VGND VGND VPWR VPWR sky130_fd_sc_hd__fill_1
X_8415_ sh7\[5\] VGND VGND VPWR VPWR _1245_ sky130_fd_sc_hd__buf_4
X_6676_ _3667_ _3668_ _3669_ VGND VGND VPWR VPWR _3670_ sky130_fd_sc_hd__o21ai_2
XFILLER_0_33_438 VGND VGND VPWR VPWR sky130_fd_sc_hd__decap_8
XFILLER_0_45_265 VGND VGND VPWR VPWR sky130_fd_sc_hd__fill_1
XFILLER_0_14_641 VGND VGND VPWR VPWR sky130_fd_sc_hd__decap_3
X_5627_ _2641_ _2642_ _2615_ VGND VGND VPWR VPWR _2645_ sky130_fd_sc_hd__o21bai_2
XFILLER_0_26_490 VGND VGND VPWR VPWR sky130_fd_sc_hd__decap_4
XFILLER_0_33_449 VGND VGND VPWR VPWR sky130_fd_sc_hd__decap_4
X_8346_ sum5\[10\] s7\[10\] VGND VGND VPWR VPWR _1182_ sky130_fd_sc_hd__nand2_1
X_5558_ _2491_ _2493_ _2560_ VGND VGND VPWR VPWR _2577_ sky130_fd_sc_hd__a21oi_2
X_4509_ _1552_ _1550_ _1246_ VGND VGND VPWR VPWR _1553_ sky130_fd_sc_hd__o21bai_4
X_8277_ _1099_ _1097_ _1119_ VGND VGND VPWR VPWR _1121_ sky130_fd_sc_hd__nand3_1
XFILLER_0_41_482 VGND VGND VPWR VPWR sky130_fd_sc_hd__fill_1
X_7228_ _4130_ VGND VGND VPWR VPWR _0255_ sky130_fd_sc_hd__inv_2
X_5489_ _2479_ _2506_ VGND VGND VPWR VPWR _2508_ sky130_fd_sc_hd__nand2_1
X_7159_ _4123_ VGND VGND VPWR VPWR _0193_ sky130_fd_sc_hd__inv_2
XTAP_390 VGND VPWR sky130_fd_sc_hd__tapvpwrvgnd_1
Xclkbuf_leaf_38_clk clknet_3_5__leaf_clk VGND VGND VPWR VPWR clknet_leaf_38_clk sky130_fd_sc_hd__clkbuf_16
XTAP_1523 VGND VPWR sky130_fd_sc_hd__tapvpwrvgnd_1
XFILLER_0_96_633 VGND VGND VPWR VPWR sky130_fd_sc_hd__decap_3
XTAP_1512 VGND VPWR sky130_fd_sc_hd__tapvpwrvgnd_1
XTAP_1501 VGND VPWR sky130_fd_sc_hd__tapvpwrvgnd_1
XPHY_30 VGND VGND VPWR VPWR sky130_fd_sc_hd__decap_3
XTAP_1556 VGND VPWR sky130_fd_sc_hd__tapvpwrvgnd_1
XTAP_1567 VGND VPWR sky130_fd_sc_hd__tapvpwrvgnd_1
XTAP_1545 VGND VPWR sky130_fd_sc_hd__tapvpwrvgnd_1
XTAP_1534 VGND VPWR sky130_fd_sc_hd__tapvpwrvgnd_1
XFILLER_0_96_699 VGND VGND VPWR VPWR sky130_fd_sc_hd__fill_1
XFILLER_0_95_165 VGND VGND VPWR VPWR sky130_fd_sc_hd__decap_3
XPHY_41 VGND VGND VPWR VPWR sky130_fd_sc_hd__decap_3
XPHY_52 VGND VGND VPWR VPWR sky130_fd_sc_hd__decap_3
XPHY_63 VGND VGND VPWR VPWR sky130_fd_sc_hd__decap_3
XPHY_74 VGND VGND VPWR VPWR sky130_fd_sc_hd__decap_3
XTAP_1589 VGND VPWR sky130_fd_sc_hd__tapvpwrvgnd_1
XTAP_1578 VGND VPWR sky130_fd_sc_hd__tapvpwrvgnd_1
XFILLER_0_83_349 VPWR VGND VPWR VGND sky130_ef_sc_hd__decap_12
XFILLER_0_83_327 VGND VGND VPWR VPWR sky130_fd_sc_hd__decap_8
XFILLER_0_22_29 VGND VGND VPWR VPWR sky130_fd_sc_hd__decap_8
XPHY_85 VGND VGND VPWR VPWR sky130_fd_sc_hd__decap_3
XPHY_96 VGND VGND VPWR VPWR sky130_fd_sc_hd__decap_3
XFILLER_0_49_593 VGND VGND VPWR VPWR sky130_fd_sc_hd__fill_1
XFILLER_0_76_390 VGND VGND VPWR VPWR sky130_fd_sc_hd__fill_1
XFILLER_0_106_131 VGND VGND VPWR VPWR sky130_fd_sc_hd__decap_8
XFILLER_0_64_585 VGND VGND VPWR VPWR sky130_fd_sc_hd__decap_3
XFILLER_0_24_416 VGND VGND VPWR VPWR sky130_fd_sc_hd__decap_4
XFILLER_0_24_427 VGND VGND VPWR VPWR sky130_fd_sc_hd__fill_1
XFILLER_0_36_287 VPWR VGND VPWR VGND sky130_ef_sc_hd__decap_12
XFILLER_0_24_438 VPWR VGND VPWR VGND sky130_ef_sc_hd__decap_12
XFILLER_0_51_235 VGND VGND VPWR VPWR sky130_fd_sc_hd__fill_2
XFILLER_0_51_257 VGND VGND VPWR VPWR sky130_fd_sc_hd__decap_8
XFILLER_0_51_279 VGND VGND VPWR VPWR sky130_fd_sc_hd__fill_1
XFILLER_0_121_167 VGND VGND VPWR VPWR sky130_fd_sc_hd__fill_1
XFILLER_0_47_15 VPWR VGND VPWR VGND sky130_ef_sc_hd__decap_12
Xclkbuf_leaf_29_clk clknet_3_6__leaf_clk VGND VGND VPWR VPWR clknet_leaf_29_clk sky130_fd_sc_hd__clkbuf_16
XFILLER_0_59_335 VGND VGND VPWR VPWR sky130_fd_sc_hd__fill_1
X_4860_ _1798_ _1813_ _1869_ _1879_ VGND VGND VPWR VPWR _1896_ sky130_fd_sc_hd__o22ai_2
XFILLER_0_59_357 VGND VGND VPWR VPWR sky130_fd_sc_hd__decap_3
XFILLER_0_74_349 VGND VGND VPWR VPWR sky130_fd_sc_hd__decap_6
XFILLER_0_28_733 VGND VGND VPWR VPWR sky130_fd_sc_hd__fill_2
X_4791_ _1826_ _1827_ _1808_ _1823_ VGND VGND VPWR VPWR _1828_ sky130_fd_sc_hd__o211ai_1
X_6530_ _3521_ _3525_ _3526_ _3453_ VGND VGND VPWR VPWR _3527_ sky130_fd_sc_hd__o2bb2ai_2
X_6461_ _3434_ _3439_ _3440_ VGND VGND VPWR VPWR _3459_ sky130_fd_sc_hd__a21oi_4
XFILLER_0_70_544 VGND VGND VPWR VPWR sky130_fd_sc_hd__fill_2
XFILLER_0_15_449 VPWR VGND VPWR VGND sky130_ef_sc_hd__decap_12
X_6392_ _3388_ _3389_ _3390_ VGND VGND VPWR VPWR _3391_ sky130_fd_sc_hd__nor3_1
XFILLER_0_30_419 VGND VGND VPWR VPWR sky130_fd_sc_hd__fill_1
X_5412_ _2388_ _2435_ _2429_ VGND VGND VPWR VPWR _2436_ sky130_fd_sc_hd__o21bai_2
X_8200_ _0925_ _0993_ VGND VGND VPWR VPWR _1046_ sky130_fd_sc_hd__nor2_1
XFILLER_0_112_145 VGND VGND VPWR VPWR sky130_fd_sc_hd__fill_1
XFILLER_0_112_134 VGND VGND VPWR VPWR sky130_fd_sc_hd__fill_1
XFILLER_0_2_365 VPWR VGND VPWR VGND sky130_ef_sc_hd__decap_12
X_5343_ _2360_ _2353_ _2358_ VGND VGND VPWR VPWR _2368_ sky130_fd_sc_hd__a21oi_1
X_8131_ _0838_ _0860_ _0905_ VGND VGND VPWR VPWR _0978_ sky130_fd_sc_hd__o21ai_1
XFILLER_0_112_189 VGND VGND VPWR VPWR sky130_fd_sc_hd__decap_6
XFILLER_0_10_121 VGND VGND VPWR VPWR sky130_fd_sc_hd__decap_6
X_5274_ _2285_ _2292_ _2300_ VGND VGND VPWR VPWR _2301_ sky130_fd_sc_hd__a21oi_4
X_8062_ _0907_ _0908_ _0909_ VGND VGND VPWR VPWR _0910_ sky130_fd_sc_hd__nand3_2
X_4225_ _1271_ _1272_ _1246_ VGND VGND VPWR VPWR _1273_ sky130_fd_sc_hd__o21bai_4
X_7013_ _3924_ _3997_ _3990_ _3998_ VGND VGND VPWR VPWR _3999_ sky130_fd_sc_hd__o211ai_4
XFILLER_0_78_633 VGND VGND VPWR VPWR sky130_fd_sc_hd__fill_1
X_7915_ net35 sh8\[3\] VGND VGND VPWR VPWR _0764_ sky130_fd_sc_hd__and2_1
X_7846_ _0045_ net316 VGND VGND VPWR VPWR _0095_ sky130_fd_sc_hd__nor2_1
XFILLER_0_78_699 VGND VGND VPWR VPWR sky130_fd_sc_hd__fill_1
XFILLER_0_65_316 VPWR VGND VPWR VGND sky130_ef_sc_hd__decap_12
X_4989_ _1990_ _2016_ _2014_ _2012_ VGND VGND VPWR VPWR _2022_ sky130_fd_sc_hd__a2bb2o_1
XFILLER_0_92_135 VGND VGND VPWR VPWR sky130_fd_sc_hd__decap_4
X_7777_ carry2\[5\] net310 net222 VGND VGND VPWR VPWR _0674_ sky130_fd_sc_hd__a21o_1
X_6728_ _3717_ _3712_ _3710_ VGND VGND VPWR VPWR _3718_ sky130_fd_sc_hd__o21ba_1
XFILLER_0_18_276 VPWR VGND VPWR VGND sky130_ef_sc_hd__decap_12
XFILLER_0_33_202 VGND VGND VPWR VPWR sky130_fd_sc_hd__decap_4
X_6659_ _3618_ _3614_ VGND VGND VPWR VPWR _3653_ sky130_fd_sc_hd__nand2_1
XFILLER_0_73_382 VGND VGND VPWR VPWR sky130_fd_sc_hd__decap_8
XFILLER_0_61_555 VGND VGND VPWR VPWR sky130_fd_sc_hd__decap_4
XFILLER_0_104_624 VPWR VGND VPWR VGND sky130_ef_sc_hd__decap_12
XFILLER_0_6_693 VGND VGND VPWR VPWR sky130_fd_sc_hd__decap_6
XFILLER_0_5_181 VPWR VGND VPWR VGND sky130_ef_sc_hd__decap_12
X_8329_ _1166_ VGND VGND VPWR VPWR _0171_ sky130_fd_sc_hd__clkbuf_1
XFILLER_0_14_460 VPWR VGND VPWR VGND sky130_ef_sc_hd__decap_12
XFILLER_0_88_408 VPWR VGND VPWR VGND sky130_ef_sc_hd__decap_12
XFILLER_0_69_644 VPWR VGND VPWR VGND sky130_ef_sc_hd__decap_12
XTAP_1331 VGND VPWR sky130_fd_sc_hd__tapvpwrvgnd_1
XTAP_1320 VGND VPWR sky130_fd_sc_hd__tapvpwrvgnd_1
XFILLER_0_33_39 VGND VGND VPWR VPWR sky130_fd_sc_hd__fill_1
XFILLER_0_96_485 VPWR VGND VPWR VGND sky130_ef_sc_hd__decap_12
XTAP_1375 VGND VPWR sky130_fd_sc_hd__tapvpwrvgnd_1
XTAP_1364 VGND VPWR sky130_fd_sc_hd__tapvpwrvgnd_1
XFILLER_0_84_636 VGND VGND VPWR VPWR sky130_fd_sc_hd__decap_8
XTAP_1353 VGND VPWR sky130_fd_sc_hd__tapvpwrvgnd_1
XTAP_1342 VGND VPWR sky130_fd_sc_hd__tapvpwrvgnd_1
XFILLER_0_83_113 VPWR VGND VPWR VGND sky130_ef_sc_hd__decap_12
XTAP_1397 VGND VPWR sky130_fd_sc_hd__tapvpwrvgnd_1
XTAP_1386 VGND VPWR sky130_fd_sc_hd__tapvpwrvgnd_1
XFILLER_0_107_440 VGND VGND VPWR VPWR sky130_fd_sc_hd__decap_8
XFILLER_0_52_533 VGND VGND VPWR VPWR sky130_fd_sc_hd__decap_3
XFILLER_0_12_419 VGND VGND VPWR VPWR sky130_fd_sc_hd__fill_1
XFILLER_0_110_616 VGND VGND VPWR VPWR sky130_fd_sc_hd__decap_8
X_5961_ _2936_ _2893_ _2959_ VGND VGND VPWR VPWR _2970_ sky130_fd_sc_hd__a21o_1
X_4912_ _1945_ _1946_ VGND VGND VPWR VPWR _1947_ sky130_fd_sc_hd__nor2_1
X_8680_ clknet_leaf_53_clk _0145_ _0431_ VGND VGND VPWR VPWR bit_sum1\[1\] sky130_fd_sc_hd__dfrtp_1
X_7700_ carry1\[8\] sum1\[9\] net268 VGND VGND VPWR VPWR _4214_ sky130_fd_sc_hd__a21o_1
XFILLER_0_114_41 VPWR VGND VPWR VGND sky130_ef_sc_hd__decap_12
X_5892_ _2900_ _2901_ VGND VGND VPWR VPWR _2902_ sky130_fd_sc_hd__or2_2
XFILLER_0_75_636 VPWR VGND VPWR VGND sky130_ef_sc_hd__decap_12
X_7631_ _4122_ VGND VGND VPWR VPWR _0619_ sky130_fd_sc_hd__inv_2
X_4843_ _1870_ _1871_ _1874_ _1878_ VGND VGND VPWR VPWR _1879_ sky130_fd_sc_hd__o211ai_4
XFILLER_0_75_669 VGND VGND VPWR VPWR sky130_fd_sc_hd__decap_3
XFILLER_0_7_413 VGND VGND VPWR VPWR sky130_fd_sc_hd__decap_3
X_4774_ _1637_ _1639_ _1696_ VGND VGND VPWR VPWR _1811_ sky130_fd_sc_hd__a21oi_1
X_7562_ _4163_ VGND VGND VPWR VPWR _0556_ sky130_fd_sc_hd__inv_2
XFILLER_0_23_83 VGND VGND VPWR VPWR sky130_fd_sc_hd__fill_2
X_7493_ _4156_ VGND VGND VPWR VPWR _0494_ sky130_fd_sc_hd__inv_2
XFILLER_0_83_691 VGND VGND VPWR VPWR sky130_fd_sc_hd__decap_8
X_6513_ _3377_ _3451_ _3509_ VGND VGND VPWR VPWR _3510_ sky130_fd_sc_hd__a21oi_1
XFILLER_0_55_393 VGND VGND VPWR VPWR sky130_fd_sc_hd__decap_3
XFILLER_0_7_479 VGND VGND VPWR VPWR sky130_fd_sc_hd__decap_6
XFILLER_0_28_596 VGND VGND VPWR VPWR sky130_fd_sc_hd__decap_8
XFILLER_0_43_533 VGND VGND VPWR VPWR sky130_fd_sc_hd__decap_3
Xclkbuf_leaf_9_clk clknet_3_3__leaf_clk VGND VGND VPWR VPWR clknet_leaf_9_clk sky130_fd_sc_hd__clkbuf_16
XFILLER_0_99_98 VGND VGND VPWR VPWR sky130_fd_sc_hd__decap_6
X_6444_ _3367_ _3370_ _3373_ _3374_ VGND VGND VPWR VPWR _3442_ sky130_fd_sc_hd__o211a_1
XFILLER_0_70_363 VGND VGND VPWR VPWR sky130_fd_sc_hd__fill_1
XFILLER_0_43_555 VGND VGND VPWR VPWR sky130_fd_sc_hd__decap_4
XFILLER_0_101_605 VGND VGND VPWR VPWR sky130_fd_sc_hd__decap_4
XFILLER_0_3_641 VPWR VGND VPWR VGND sky130_ef_sc_hd__decap_12
X_6375_ _3370_ _3365_ _3302_ VGND VGND VPWR VPWR _3374_ sky130_fd_sc_hd__o21bai_2
XFILLER_0_61_3 VPWR VGND VPWR VGND sky130_ef_sc_hd__decap_12
XFILLER_0_3_685 VPWR VGND VPWR VGND sky130_ef_sc_hd__decap_12
XFILLER_0_30_249 VGND VGND VPWR VPWR sky130_fd_sc_hd__decap_3
X_8114_ _0958_ _0959_ _0960_ VGND VGND VPWR VPWR _0961_ sky130_fd_sc_hd__nand3_2
XFILLER_0_2_195 VGND VGND VPWR VPWR sky130_fd_sc_hd__fill_1
X_5326_ _2344_ _2345_ _2339_ _2342_ VGND VGND VPWR VPWR _2352_ sky130_fd_sc_hd__o211ai_2
X_5257_ _2278_ _2281_ _2283_ VGND VGND VPWR VPWR _2284_ sky130_fd_sc_hd__o21ai_1
X_8045_ _0826_ _0892_ _0886_ VGND VGND VPWR VPWR _0893_ sky130_fd_sc_hd__a21o_1
X_5188_ _2060_ _2038_ _2213_ VGND VGND VPWR VPWR _2216_ sky130_fd_sc_hd__a21oi_2
XFILLER_0_3_93 VPWR VGND VPWR VGND sky130_ef_sc_hd__decap_12
XFILLER_0_78_485 VGND VGND VPWR VPWR sky130_fd_sc_hd__fill_1
XFILLER_0_109_727 VGND VGND VPWR VPWR sky130_fd_sc_hd__fill_1
XFILLER_0_93_444 VGND VGND VPWR VPWR sky130_fd_sc_hd__fill_1
X_7829_ sum3\[6\] net259 s5\[6\] VGND VGND VPWR VPWR _0700_ sky130_fd_sc_hd__a21o_1
XFILLER_0_93_499 VGND VGND VPWR VPWR sky130_fd_sc_hd__decap_4
XFILLER_0_34_533 VGND VGND VPWR VPWR sky130_fd_sc_hd__fill_1
XFILLER_0_61_341 VGND VGND VPWR VPWR sky130_fd_sc_hd__fill_1
XFILLER_0_61_374 VGND VGND VPWR VPWR sky130_fd_sc_hd__decap_4
XFILLER_0_34_599 VGND VGND VPWR VPWR sky130_fd_sc_hd__decap_3
XFILLER_0_44_27 VGND VGND VPWR VPWR sky130_fd_sc_hd__fill_1
XTAP_1150 VGND VPWR sky130_fd_sc_hd__tapvpwrvgnd_1
XTAP_1183 VGND VPWR sky130_fd_sc_hd__tapvpwrvgnd_1
XTAP_1172 VGND VPWR sky130_fd_sc_hd__tapvpwrvgnd_1
XTAP_1161 VGND VPWR sky130_fd_sc_hd__tapvpwrvgnd_1
XFILLER_0_60_37 VGND VGND VPWR VPWR sky130_fd_sc_hd__decap_3
XFILLER_0_57_669 VGND VGND VPWR VPWR sky130_fd_sc_hd__decap_3
Xclkbuf_3_4__f_clk clknet_0_clk VGND VGND VPWR VPWR clknet_3_4__leaf_clk sky130_fd_sc_hd__clkbuf_16
XFILLER_0_84_477 VGND VGND VPWR VPWR sky130_fd_sc_hd__decap_4
XTAP_1194 VGND VPWR sky130_fd_sc_hd__tapvpwrvgnd_1
XFILLER_0_71_116 VPWR VGND VPWR VGND sky130_ef_sc_hd__decap_12
XFILLER_0_56_168 VGND VGND VPWR VPWR sky130_fd_sc_hd__decap_8
XFILLER_0_25_500 VGND VGND VPWR VPWR sky130_fd_sc_hd__decap_4
XFILLER_0_37_393 VGND VGND VPWR VPWR sky130_fd_sc_hd__fill_2
XFILLER_0_114_218 VGND VGND VPWR VPWR sky130_fd_sc_hd__decap_4
XFILLER_0_107_281 VGND VGND VPWR VPWR sky130_fd_sc_hd__fill_2
XFILLER_0_107_270 VGND VGND VPWR VPWR sky130_fd_sc_hd__decap_8
XFILLER_0_52_363 VGND VGND VPWR VPWR sky130_fd_sc_hd__fill_1
XFILLER_0_8_27 VGND VGND VPWR VPWR sky130_fd_sc_hd__fill_1
X_4490_ _1530_ _1534_ VGND VGND VPWR VPWR _1535_ sky130_fd_sc_hd__nand2_1
XFILLER_0_69_57 VGND VGND VPWR VPWR sky130_fd_sc_hd__fill_2
XFILLER_0_40_525 VGND VGND VPWR VPWR sky130_fd_sc_hd__decap_6
XFILLER_0_12_238 VGND VGND VPWR VPWR sky130_fd_sc_hd__decap_3
X_6160_ _3156_ _3153_ _3165_ VGND VGND VPWR VPWR _3166_ sky130_fd_sc_hd__a21o_1
XTAP_901 VGND VPWR sky130_fd_sc_hd__tapvpwrvgnd_1
XFILLER_0_110_468 VGND VGND VPWR VPWR sky130_fd_sc_hd__fill_1
X_5111_ _2138_ _2139_ _2057_ VGND VGND VPWR VPWR _2140_ sky130_fd_sc_hd__o21ai_2
XTAP_912 VGND VPWR sky130_fd_sc_hd__tapvpwrvgnd_1
XTAP_923 VGND VPWR sky130_fd_sc_hd__tapvpwrvgnd_1
XTAP_934 VGND VPWR sky130_fd_sc_hd__tapvpwrvgnd_1
XFILLER_0_109_41 VGND VGND VPWR VPWR sky130_fd_sc_hd__decap_4
X_6091_ _2871_ _2874_ VGND VGND VPWR VPWR _3098_ sky130_fd_sc_hd__nand2_1
XTAP_978 VGND VPWR sky130_fd_sc_hd__tapvpwrvgnd_1
XTAP_967 VGND VPWR sky130_fd_sc_hd__tapvpwrvgnd_1
XTAP_945 VGND VPWR sky130_fd_sc_hd__tapvpwrvgnd_1
XTAP_956 VGND VPWR sky130_fd_sc_hd__tapvpwrvgnd_1
XTAP_989 VGND VPWR sky130_fd_sc_hd__tapvpwrvgnd_1
X_5042_ sh7\[2\] VGND VGND VPWR VPWR _2072_ sky130_fd_sc_hd__clkbuf_4
XFILLER_0_18_72 VGND VGND VPWR VPWR sky130_fd_sc_hd__decap_8
X_8801_ clknet_leaf_9_clk net429 _0552_ VGND VGND VPWR VPWR sh6\[5\] sky130_fd_sc_hd__dfrtp_4
X_6993_ _3977_ _3978_ VGND VGND VPWR VPWR _3979_ sky130_fd_sc_hd__nor2b_2
X_5944_ _2949_ _2950_ _2913_ _2952_ VGND VGND VPWR VPWR _2953_ sky130_fd_sc_hd__o211ai_4
X_8732_ clknet_leaf_15_clk _0138_ _0483_ VGND VGND VPWR VPWR bit_sum6\[3\] sky130_fd_sc_hd__dfrtp_1
XFILLER_0_47_113 VGND VGND VPWR VPWR sky130_fd_sc_hd__decap_8
X_5875_ _2884_ _2882_ VGND VGND VPWR VPWR _2885_ sky130_fd_sc_hd__nor2_1
X_8663_ clknet_leaf_23_clk net137 _0414_ VGND VGND VPWR VPWR s7\[10\] sky130_fd_sc_hd__dfrtp_1
X_4826_ _1663_ _1666_ _1667_ VGND VGND VPWR VPWR _1862_ sky130_fd_sc_hd__o21ai_1
XFILLER_0_90_414 VGND VGND VPWR VPWR sky130_fd_sc_hd__decap_6
XFILLER_0_75_477 VGND VGND VPWR VPWR sky130_fd_sc_hd__fill_1
XFILLER_0_63_617 VGND VGND VPWR VPWR sky130_fd_sc_hd__decap_4
XFILLER_0_8_733 VGND VGND VPWR VPWR sky130_fd_sc_hd__fill_2
X_7614_ _4168_ VGND VGND VPWR VPWR _0603_ sky130_fd_sc_hd__inv_2
X_8594_ clknet_leaf_35_clk _0056_ _0345_ VGND VGND VPWR VPWR sum1\[6\] sky130_fd_sc_hd__dfrtp_1
XFILLER_0_62_149 VGND VGND VPWR VPWR sky130_fd_sc_hd__fill_2
X_7545_ _4162_ VGND VGND VPWR VPWR _0540_ sky130_fd_sc_hd__inv_2
XFILLER_0_16_533 VGND VGND VPWR VPWR sky130_fd_sc_hd__fill_2
X_4757_ sh8\[7\] sh9\[7\] VGND VGND VPWR VPWR _1794_ sky130_fd_sc_hd__nor2_1
X_4688_ _1677_ _1725_ _1718_ _1720_ VGND VGND VPWR VPWR _1726_ sky130_fd_sc_hd__o22a_1
X_7476_ _4147_ VGND VGND VPWR VPWR _4155_ sky130_fd_sc_hd__buf_4
X_6427_ _3294_ _3326_ VGND VGND VPWR VPWR _3425_ sky130_fd_sc_hd__nor2_1
XFILLER_0_31_547 VPWR VGND VPWR VGND sky130_ef_sc_hd__decap_12
X_6358_ _3306_ _3307_ VGND VGND VPWR VPWR _3357_ sky130_fd_sc_hd__nand2_1
X_5309_ _2060_ _2071_ VGND VGND VPWR VPWR _2335_ sky130_fd_sc_hd__nor2_1
X_6289_ sh2\[4\] VGND VGND VPWR VPWR _3289_ sky130_fd_sc_hd__clkbuf_4
X_8028_ _0862_ _0865_ _0873_ _0875_ VGND VGND VPWR VPWR _0876_ sky130_fd_sc_hd__o22ai_4
XPHY_200 VGND VGND VPWR VPWR sky130_fd_sc_hd__decap_3
XFILLER_0_38_113 VGND VGND VPWR VPWR sky130_fd_sc_hd__decap_6
XPHY_233 VGND VGND VPWR VPWR sky130_fd_sc_hd__decap_3
XPHY_222 VGND VGND VPWR VPWR sky130_fd_sc_hd__decap_3
XPHY_211 VGND VGND VPWR VPWR sky130_fd_sc_hd__decap_3
XFILLER_0_66_444 VGND VGND VPWR VPWR sky130_fd_sc_hd__decap_6
XFILLER_0_38_146 VGND VGND VPWR VPWR sky130_fd_sc_hd__fill_1
XPHY_244 VGND VGND VPWR VPWR sky130_fd_sc_hd__decap_3
XFILLER_0_66_477 VGND VGND VPWR VPWR sky130_fd_sc_hd__fill_1
XFILLER_0_53_105 VGND VGND VPWR VPWR sky130_fd_sc_hd__fill_2
XFILLER_0_19_393 VPWR VGND VPWR VGND sky130_ef_sc_hd__decap_12
XFILLER_0_30_29 VGND VGND VPWR VPWR sky130_fd_sc_hd__fill_2
XFILLER_0_117_590 VPWR VGND VPWR VGND sky130_ef_sc_hd__decap_12
XFILLER_0_62_672 VPWR VGND VPWR VGND sky130_ef_sc_hd__decap_12
XFILLER_0_22_536 VGND VGND VPWR VPWR sky130_fd_sc_hd__decap_4
XFILLER_0_104_251 VGND VGND VPWR VPWR sky130_fd_sc_hd__fill_1
XFILLER_0_39_27 VPWR VGND VPWR VGND sky130_ef_sc_hd__decap_12
XFILLER_0_30_580 VGND VGND VPWR VPWR sky130_fd_sc_hd__decap_8
Xhold4 bit_sum3\[5\] VGND VGND VPWR VPWR net46 sky130_fd_sc_hd__dlygate4sd3_1
XFILLER_0_89_536 VGND VGND VPWR VPWR sky130_fd_sc_hd__fill_2
XFILLER_0_89_558 VGND VGND VPWR VPWR sky130_fd_sc_hd__fill_2
XFILLER_0_69_293 VPWR VGND VPWR VGND sky130_ef_sc_hd__decap_12
XFILLER_0_29_113 VGND VGND VPWR VPWR sky130_fd_sc_hd__decap_3
X_5660_ _2676_ _2628_ _2633_ VGND VGND VPWR VPWR _2677_ sky130_fd_sc_hd__o21ai_2
XFILLER_0_29_157 VGND VGND VPWR VPWR sky130_fd_sc_hd__decap_8
XFILLER_0_45_617 VGND VGND VPWR VPWR sky130_fd_sc_hd__decap_6
X_4611_ net41 VGND VGND VPWR VPWR _1650_ sky130_fd_sc_hd__inv_2
XFILLER_0_115_505 VPWR VGND VPWR VGND sky130_ef_sc_hd__decap_12
X_5591_ _2605_ _2608_ _2469_ VGND VGND VPWR VPWR _2609_ sky130_fd_sc_hd__o21ai_2
X_4542_ _1447_ _1445_ _1518_ VGND VGND VPWR VPWR _1586_ sky130_fd_sc_hd__o21ai_1
XFILLER_0_80_480 VPWR VGND VPWR VGND sky130_ef_sc_hd__decap_12
XFILLER_0_13_503 VGND VGND VPWR VPWR sky130_fd_sc_hd__fill_1
X_7330_ _4140_ VGND VGND VPWR VPWR _0347_ sky130_fd_sc_hd__inv_2
X_4473_ _1516_ _1517_ _1513_ VGND VGND VPWR VPWR _1518_ sky130_fd_sc_hd__o21bai_4
X_7261_ _4133_ VGND VGND VPWR VPWR _0285_ sky130_fd_sc_hd__inv_2
XFILLER_0_13_558 VGND VGND VPWR VPWR sky130_fd_sc_hd__fill_2
Xhold404 s0\[3\] VGND VGND VPWR VPWR net446 sky130_fd_sc_hd__dlygate4sd3_1
X_6212_ _3143_ _3144_ _3148_ VGND VGND VPWR VPWR _3217_ sky130_fd_sc_hd__a21boi_1
XFILLER_0_40_377 VGND VGND VPWR VPWR sky130_fd_sc_hd__decap_6
XFILLER_0_96_77 VGND VGND VPWR VPWR sky130_fd_sc_hd__decap_6
X_7192_ _4127_ VGND VGND VPWR VPWR _0222_ sky130_fd_sc_hd__inv_2
X_6143_ _3088_ _3079_ VGND VGND VPWR VPWR _3149_ sky130_fd_sc_hd__and2_1
XTAP_720 VGND VPWR sky130_fd_sc_hd__tapvpwrvgnd_1
XTAP_731 VGND VPWR sky130_fd_sc_hd__tapvpwrvgnd_1
XTAP_742 VGND VPWR sky130_fd_sc_hd__tapvpwrvgnd_1
X_6074_ _2884_ _2882_ _2875_ VGND VGND VPWR VPWR _3081_ sky130_fd_sc_hd__o21bai_2
XTAP_753 VGND VPWR sky130_fd_sc_hd__tapvpwrvgnd_1
XTAP_764 VGND VPWR sky130_fd_sc_hd__tapvpwrvgnd_1
XTAP_786 VGND VPWR sky130_fd_sc_hd__tapvpwrvgnd_1
XTAP_775 VGND VPWR sky130_fd_sc_hd__tapvpwrvgnd_1
X_5025_ _2054_ VGND VGND VPWR VPWR _2055_ sky130_fd_sc_hd__buf_4
XTAP_797 VGND VPWR sky130_fd_sc_hd__tapvpwrvgnd_1
XFILLER_0_24_3 VPWR VGND VPWR VGND sky130_ef_sc_hd__decap_12
XFILLER_0_45_92 VPWR VGND VPWR VGND sky130_ef_sc_hd__decap_12
X_6976_ _3953_ _3954_ sh15\[1\] VGND VGND VPWR VPWR _3963_ sky130_fd_sc_hd__nand3_1
X_5927_ sh5\[6\] VGND VGND VPWR VPWR _2936_ sky130_fd_sc_hd__clkbuf_4
X_8715_ clknet_leaf_13_clk _0123_ _0466_ VGND VGND VPWR VPWR bit_sum4\[6\] sky130_fd_sc_hd__dfrtp_1
XFILLER_0_91_723 VGND VGND VPWR VPWR sky130_fd_sc_hd__decap_4
XFILLER_0_91_712 VGND VGND VPWR VPWR sky130_fd_sc_hd__decap_3
XFILLER_0_75_241 VGND VGND VPWR VPWR sky130_fd_sc_hd__fill_1
XFILLER_0_48_477 VGND VGND VPWR VPWR sky130_fd_sc_hd__fill_1
XFILLER_0_118_365 VGND VGND VPWR VPWR sky130_fd_sc_hd__decap_4
X_5858_ net426 VGND VGND VPWR VPWR _2868_ sky130_fd_sc_hd__inv_2
X_8646_ clknet_leaf_15_clk net64 _0397_ VGND VGND VPWR VPWR s5\[11\] sky130_fd_sc_hd__dfrtp_1
XFILLER_0_75_296 VGND VGND VPWR VPWR sky130_fd_sc_hd__decap_6
X_4809_ _1677_ _1838_ _1839_ _1844_ VGND VGND VPWR VPWR _1845_ sky130_fd_sc_hd__o211ai_4
X_8577_ clknet_leaf_31_clk net44 _0328_ VGND VGND VPWR VPWR sum2\[12\] sky130_fd_sc_hd__dfrtp_1
XFILLER_0_16_330 VGND VGND VPWR VPWR sky130_fd_sc_hd__decap_8
X_5789_ _2755_ _2756_ _2728_ VGND VGND VPWR VPWR _2804_ sky130_fd_sc_hd__a21oi_1
XFILLER_0_16_363 VGND VGND VPWR VPWR sky130_fd_sc_hd__fill_1
X_7528_ _4160_ VGND VGND VPWR VPWR _0525_ sky130_fd_sc_hd__inv_2
X_7459_ _4153_ VGND VGND VPWR VPWR _0463_ sky130_fd_sc_hd__inv_2
XFILLER_0_9_81 VPWR VGND VPWR VGND sky130_ef_sc_hd__decap_12
XFILLER_0_31_333 VGND VGND VPWR VPWR sky130_fd_sc_hd__decap_3
XFILLER_0_43_182 VGND VGND VPWR VPWR sky130_fd_sc_hd__fill_2
XFILLER_0_101_210 VGND VGND VPWR VPWR sky130_fd_sc_hd__fill_1
XFILLER_0_101_232 VGND VGND VPWR VPWR sky130_fd_sc_hd__fill_2
XFILLER_0_39_444 VGND VGND VPWR VPWR sky130_fd_sc_hd__decap_4
XFILLER_0_41_39 VPWR VGND VPWR VGND sky130_ef_sc_hd__decap_12
XFILLER_0_66_274 VGND VGND VPWR VPWR sky130_fd_sc_hd__decap_4
XFILLER_0_54_414 VGND VGND VPWR VPWR sky130_fd_sc_hd__decap_6
XFILLER_0_26_105 VGND VGND VPWR VPWR sky130_fd_sc_hd__fill_2
XFILLER_0_81_255 VPWR VGND VPWR VGND sky130_ef_sc_hd__decap_12
XFILLER_0_54_458 VGND VGND VPWR VPWR sky130_fd_sc_hd__decap_3
XFILLER_0_26_149 VGND VGND VPWR VPWR sky130_fd_sc_hd__fill_1
XFILLER_0_1_205 VPWR VGND VPWR VGND sky130_ef_sc_hd__decap_12
XFILLER_0_50_653 VGND VGND VPWR VPWR sky130_fd_sc_hd__decap_3
XFILLER_0_1_249 VPWR VGND VPWR VGND sky130_ef_sc_hd__decap_12
XFILLER_0_120_552 VGND VGND VPWR VPWR sky130_fd_sc_hd__fill_1
XFILLER_0_10_528 VGND VGND VPWR VPWR sky130_fd_sc_hd__decap_4
XFILLER_0_5_39 VPWR VGND VPWR VGND sky130_ef_sc_hd__decap_12
X_6830_ _3817_ _3814_ _3815_ VGND VGND VPWR VPWR _3819_ sky130_fd_sc_hd__and3_1
XFILLER_0_49_219 VGND VGND VPWR VPWR sky130_fd_sc_hd__decap_4
XFILLER_0_106_64 VPWR VGND VPWR VGND sky130_ef_sc_hd__decap_12
X_6761_ sh5\[1\] VGND VGND VPWR VPWR _3750_ sky130_fd_sc_hd__clkbuf_4
XFILLER_0_15_51 VGND VGND VPWR VPWR sky130_fd_sc_hd__decap_4
XFILLER_0_15_84 VPWR VGND VPWR VGND sky130_ef_sc_hd__decap_12
XFILLER_0_85_561 VGND VGND VPWR VPWR sky130_fd_sc_hd__decap_3
X_8500_ clknet_leaf_40_clk net304 _0251_ VGND VGND VPWR VPWR final_sum\[6\] sky130_fd_sc_hd__dfrtp_1
X_5712_ _2725_ _2727_ _2694_ VGND VGND VPWR VPWR _2728_ sky130_fd_sc_hd__o21ai_2
XFILLER_0_122_41 VPWR VGND VPWR VGND sky130_ef_sc_hd__decap_12
X_6692_ _3684_ _3685_ VGND VGND VPWR VPWR _0124_ sky130_fd_sc_hd__nand2_1
X_8431_ _1260_ _1230_ VGND VGND VPWR VPWR _1261_ sky130_fd_sc_hd__or2_1
X_5643_ _2654_ _2655_ VGND VGND VPWR VPWR _2661_ sky130_fd_sc_hd__nand2_1
XFILLER_0_122_85 VPWR VGND VPWR VGND sky130_ef_sc_hd__decap_12
X_8362_ _1195_ _1196_ VGND VGND VPWR VPWR _0166_ sky130_fd_sc_hd__nor2_1
XFILLER_0_5_533 VGND VGND VPWR VPWR sky130_fd_sc_hd__decap_8
X_5574_ _2590_ _2591_ _2592_ VGND VGND VPWR VPWR _2593_ sky130_fd_sc_hd__nand3_2
XFILLER_0_26_672 VPWR VGND VPWR VGND sky130_ef_sc_hd__decap_12
XFILLER_0_31_83 VGND VGND VPWR VPWR sky130_fd_sc_hd__decap_3
X_4525_ _1564_ _1558_ _1562_ VGND VGND VPWR VPWR _1569_ sky130_fd_sc_hd__and3_1
Xhold201 sum2\[11\] VGND VGND VPWR VPWR net243 sky130_fd_sc_hd__dlygate4sd3_1
XFILLER_0_53_491 VGND VGND VPWR VPWR sky130_fd_sc_hd__fill_1
X_7313_ _4139_ VGND VGND VPWR VPWR _0331_ sky130_fd_sc_hd__inv_2
Xhold234 sh14\[4\] VGND VGND VPWR VPWR net276 sky130_fd_sc_hd__dlygate4sd3_1
X_8293_ _1117_ _1127_ _1126_ VGND VGND VPWR VPWR _1135_ sky130_fd_sc_hd__a21o_1
XFILLER_0_40_130 VGND VGND VPWR VPWR sky130_fd_sc_hd__fill_2
Xhold212 s2\[5\] VGND VGND VPWR VPWR net254 sky130_fd_sc_hd__buf_1
Xhold223 s3\[5\] VGND VGND VPWR VPWR net265 sky130_fd_sc_hd__buf_1
X_4456_ _1485_ _1499_ _1500_ VGND VGND VPWR VPWR _1501_ sky130_fd_sc_hd__and3_2
Xhold267 sum4\[11\] VGND VGND VPWR VPWR net309 sky130_fd_sc_hd__dlygate4sd3_1
X_7244_ _4132_ VGND VGND VPWR VPWR _0269_ sky130_fd_sc_hd__inv_2
Xhold278 _0638_ VGND VGND VPWR VPWR net320 sky130_fd_sc_hd__dlygate4sd3_1
Xhold245 sum2\[8\] VGND VGND VPWR VPWR net287 sky130_fd_sc_hd__dlygate4sd3_1
Xhold256 _0718_ VGND VGND VPWR VPWR net298 sky130_fd_sc_hd__dlygate4sd3_1
XFILLER_0_41_697 VPWR VGND VPWR VGND sky130_ef_sc_hd__decap_12
X_4387_ _1355_ _1354_ _1363_ VGND VGND VPWR VPWR _1433_ sky130_fd_sc_hd__o21ai_2
X_7175_ _4124_ VGND VGND VPWR VPWR _0208_ sky130_fd_sc_hd__inv_2
Xhold289 s0\[1\] VGND VGND VPWR VPWR net331 sky130_fd_sc_hd__dlygate4sd3_1
X_6126_ _3123_ _3131_ _3132_ VGND VGND VPWR VPWR _3133_ sky130_fd_sc_hd__a21oi_1
XFILLER_0_0_293 VPWR VGND VPWR VGND sky130_ef_sc_hd__decap_12
XTAP_550 VGND VPWR sky130_fd_sc_hd__tapvpwrvgnd_1
XTAP_561 VGND VPWR sky130_fd_sc_hd__tapvpwrvgnd_1
XTAP_572 VGND VPWR sky130_fd_sc_hd__tapvpwrvgnd_1
XTAP_583 VGND VPWR sky130_fd_sc_hd__tapvpwrvgnd_1
XTAP_594 VGND VPWR sky130_fd_sc_hd__tapvpwrvgnd_1
X_6057_ _3063_ _3064_ _2978_ VGND VGND VPWR VPWR _3065_ sky130_fd_sc_hd__o21ai_1
XFILLER_0_68_506 VGND VGND VPWR VPWR sky130_fd_sc_hd__fill_1
X_5008_ _2037_ VGND VGND VPWR VPWR _2038_ sky130_fd_sc_hd__clkbuf_4
XTAP_1705 VGND VPWR sky130_fd_sc_hd__tapvpwrvgnd_1
XTAP_1749 VGND VPWR sky130_fd_sc_hd__tapvpwrvgnd_1
XTAP_1727 VGND VPWR sky130_fd_sc_hd__tapvpwrvgnd_1
XTAP_1738 VGND VPWR sky130_fd_sc_hd__tapvpwrvgnd_1
XTAP_1716 VGND VPWR sky130_fd_sc_hd__tapvpwrvgnd_1
XFILLER_0_119_630 VPWR VGND VPWR VGND sky130_ef_sc_hd__decap_12
XFILLER_0_64_701 VPWR VGND VPWR VGND sky130_ef_sc_hd__decap_12
X_6959_ _3924_ _3926_ _3941_ VGND VGND VPWR VPWR _3946_ sky130_fd_sc_hd__o21ai_2
XFILLER_0_48_230 VPWR VGND VPWR VGND sky130_ef_sc_hd__decap_12
XFILLER_0_119_685 VPWR VGND VPWR VGND sky130_ef_sc_hd__decap_12
XFILLER_0_91_542 VPWR VGND VPWR VGND sky130_ef_sc_hd__decap_12
X_8629_ clknet_leaf_32_clk net116 _0380_ VGND VGND VPWR VPWR s3\[12\] sky130_fd_sc_hd__dfrtp_1
XFILLER_0_8_371 VGND VGND VPWR VPWR sky130_fd_sc_hd__fill_1
XFILLER_0_36_447 VGND VGND VPWR VPWR sky130_fd_sc_hd__fill_1
XFILLER_0_118_195 VGND VGND VPWR VPWR sky130_fd_sc_hd__fill_1
XFILLER_0_8_393 VPWR VGND VPWR VGND sky130_ef_sc_hd__decap_12
XFILLER_0_16_182 VPWR VGND VPWR VGND sky130_ef_sc_hd__decap_12
XFILLER_0_32_697 VGND VGND VPWR VPWR sky130_fd_sc_hd__decap_3
XFILLER_0_102_574 VPWR VGND VPWR VGND sky130_ef_sc_hd__decap_12
XFILLER_0_99_653 VPWR VGND VPWR VGND sky130_ef_sc_hd__decap_12
XFILLER_0_98_141 VGND VGND VPWR VPWR sky130_fd_sc_hd__fill_2
XFILLER_0_99_697 VPWR VGND VPWR VGND sky130_ef_sc_hd__decap_12
XFILLER_0_86_303 VGND VGND VPWR VPWR sky130_fd_sc_hd__decap_4
XFILLER_0_74_509 VGND VGND VPWR VPWR sky130_fd_sc_hd__decap_3
XFILLER_0_52_49 VPWR VGND VPWR VGND sky130_ef_sc_hd__decap_12
XFILLER_0_67_594 VGND VGND VPWR VPWR sky130_fd_sc_hd__decap_4
XFILLER_0_67_583 VGND VGND VPWR VPWR sky130_fd_sc_hd__decap_3
XFILLER_0_27_425 VGND VGND VPWR VPWR sky130_fd_sc_hd__decap_6
XFILLER_0_109_173 VGND VGND VPWR VPWR sky130_fd_sc_hd__decap_8
XFILLER_0_82_531 VGND VGND VPWR VPWR sky130_fd_sc_hd__fill_1
XFILLER_0_27_447 VGND VGND VPWR VPWR sky130_fd_sc_hd__fill_1
XFILLER_0_27_469 VGND VGND VPWR VPWR sky130_fd_sc_hd__decap_8
XFILLER_0_70_726 VGND VGND VPWR VPWR sky130_fd_sc_hd__decap_3
XFILLER_0_2_525 VGND VGND VPWR VPWR sky130_fd_sc_hd__decap_6
X_4310_ _1231_ sh2\[5\] VGND VGND VPWR VPWR _1357_ sky130_fd_sc_hd__and2_4
XFILLER_0_2_569 VPWR VGND VPWR VGND sky130_ef_sc_hd__decap_12
XFILLER_0_23_697 VPWR VGND VPWR VGND sky130_ef_sc_hd__decap_12
X_5290_ _2315_ _2299_ VGND VGND VPWR VPWR _2316_ sky130_fd_sc_hd__nor2_1
X_4241_ _1239_ sh3\[5\] _1242_ VGND VGND VPWR VPWR _1289_ sky130_fd_sc_hd__o21ai_2
XFILLER_0_77_57 VPWR VGND VPWR VGND sky130_ef_sc_hd__decap_12
XFILLER_0_10_336 VGND VGND VPWR VPWR sky130_fd_sc_hd__decap_4
X_7931_ _0776_ _0775_ _0779_ VGND VGND VPWR VPWR _0780_ sky130_fd_sc_hd__o21ai_1
XFILLER_0_26_61 VGND VGND VPWR VPWR sky130_fd_sc_hd__fill_1
XFILLER_0_89_185 VGND VGND VPWR VPWR sky130_fd_sc_hd__fill_2
X_7862_ carry4\[12\] net379 _0716_ VGND VGND VPWR VPWR _0043_ sky130_fd_sc_hd__a21o_1
XFILLER_0_77_369 VGND VGND VPWR VPWR sky130_fd_sc_hd__decap_8
XFILLER_0_58_561 VPWR VGND VPWR VGND sky130_ef_sc_hd__decap_12
XFILLER_0_9_113 VPWR VGND VPWR VGND sky130_ef_sc_hd__decap_12
X_6813_ _3750_ _3724_ sh14\[1\] _3801_ VGND VGND VPWR VPWR _3802_ sky130_fd_sc_hd__a211o_1
X_7793_ net348 s1\[2\] net266 VGND VGND VPWR VPWR _0682_ sky130_fd_sc_hd__a21o_1
XFILLER_0_92_317 VPWR VGND VPWR VGND sky130_ef_sc_hd__decap_12
X_6744_ _3712_ _3710_ sh4\[1\] VGND VGND VPWR VPWR _3733_ sky130_fd_sc_hd__o21ai_4
X_6675_ _3620_ _3630_ _3626_ VGND VGND VPWR VPWR _3669_ sky130_fd_sc_hd__a21boi_1
XFILLER_0_73_531 VGND VGND VPWR VPWR sky130_fd_sc_hd__fill_2
XFILLER_0_18_458 VGND VGND VPWR VPWR sky130_fd_sc_hd__decap_6
X_8414_ _1236_ _1241_ _1243_ VGND VGND VPWR VPWR _1244_ sky130_fd_sc_hd__a21oi_2
XFILLER_0_91_3 VPWR VGND VPWR VGND sky130_ef_sc_hd__decap_12
X_5626_ _2581_ _2603_ _2640_ _2643_ VGND VGND VPWR VPWR _2644_ sky130_fd_sc_hd__o211ai_2
XFILLER_0_45_277 VGND VGND VPWR VPWR sky130_fd_sc_hd__decap_3
XFILLER_0_116_677 VPWR VGND VPWR VGND sky130_ef_sc_hd__decap_12
XFILLER_0_60_225 VGND VGND VPWR VPWR sky130_fd_sc_hd__decap_3
XFILLER_0_14_620 VGND VGND VPWR VPWR sky130_fd_sc_hd__decap_6
X_8345_ _1178_ _1179_ carry5\[10\] VGND VGND VPWR VPWR _1181_ sky130_fd_sc_hd__o21ba_1
XFILLER_0_13_130 VPWR VGND VPWR VGND sky130_ef_sc_hd__decap_12
X_5557_ _2561_ _2559_ _2518_ VGND VGND VPWR VPWR _2576_ sky130_fd_sc_hd__o21ba_1
X_4508_ _1242_ _1268_ VGND VGND VPWR VPWR _1552_ sky130_fd_sc_hd__nor2_1
X_8276_ _1099_ _1097_ _1119_ VGND VGND VPWR VPWR _1120_ sky130_fd_sc_hd__a21o_1
X_5488_ _2477_ _2506_ VGND VGND VPWR VPWR _2507_ sky130_fd_sc_hd__nor2_1
X_4439_ _1226_ _1229_ _1446_ _1445_ VGND VGND VPWR VPWR _1484_ sky130_fd_sc_hd__a31o_1
X_7227_ _4130_ VGND VGND VPWR VPWR _0254_ sky130_fd_sc_hd__inv_2
XFILLER_0_111_393 VGND VGND VPWR VPWR sky130_fd_sc_hd__decap_3
X_7158_ _4123_ VGND VGND VPWR VPWR _0192_ sky130_fd_sc_hd__inv_2
X_6109_ _3073_ _3113_ _3115_ VGND VGND VPWR VPWR _3116_ sky130_fd_sc_hd__nand3b_4
XTAP_391 VGND VPWR sky130_fd_sc_hd__tapvpwrvgnd_1
XTAP_380 VGND VPWR sky130_fd_sc_hd__tapvpwrvgnd_1
X_7089_ _4018_ _4071_ _4072_ VGND VGND VPWR VPWR _4073_ sky130_fd_sc_hd__o21ai_2
XTAP_1524 VGND VPWR sky130_fd_sc_hd__tapvpwrvgnd_1
XFILLER_0_96_645 VPWR VGND VPWR VGND sky130_ef_sc_hd__decap_12
XTAP_1513 VGND VPWR sky130_fd_sc_hd__tapvpwrvgnd_1
XTAP_1502 VGND VPWR sky130_fd_sc_hd__tapvpwrvgnd_1
XPHY_20 VGND VGND VPWR VPWR sky130_fd_sc_hd__decap_3
XPHY_31 VGND VGND VPWR VPWR sky130_fd_sc_hd__decap_3
XTAP_1557 VGND VPWR sky130_fd_sc_hd__tapvpwrvgnd_1
XTAP_1546 VGND VPWR sky130_fd_sc_hd__tapvpwrvgnd_1
XTAP_1535 VGND VPWR sky130_fd_sc_hd__tapvpwrvgnd_1
XFILLER_0_95_155 VGND VGND VPWR VPWR sky130_fd_sc_hd__decap_4
XPHY_42 VGND VGND VPWR VPWR sky130_fd_sc_hd__decap_3
XPHY_53 VGND VGND VPWR VPWR sky130_fd_sc_hd__decap_3
XPHY_64 VGND VGND VPWR VPWR sky130_fd_sc_hd__decap_3
XFILLER_0_49_561 VGND VGND VPWR VPWR sky130_fd_sc_hd__decap_4
XTAP_1579 VGND VPWR sky130_fd_sc_hd__tapvpwrvgnd_1
XTAP_1568 VGND VPWR sky130_fd_sc_hd__tapvpwrvgnd_1
XPHY_75 VGND VGND VPWR VPWR sky130_fd_sc_hd__decap_3
XPHY_86 VGND VGND VPWR VPWR sky130_fd_sc_hd__decap_3
XPHY_97 VGND VGND VPWR VPWR sky130_fd_sc_hd__decap_3
XFILLER_0_64_542 VGND VGND VPWR VPWR sky130_fd_sc_hd__fill_1
XFILLER_0_36_222 VGND VGND VPWR VPWR sky130_fd_sc_hd__fill_1
XFILLER_0_122_614 VGND VGND VPWR VPWR sky130_fd_sc_hd__fill_1
XFILLER_0_36_299 VGND VGND VPWR VPWR sky130_fd_sc_hd__decap_8
XFILLER_0_51_214 VGND VGND VPWR VPWR sky130_fd_sc_hd__decap_3
XFILLER_0_121_113 VPWR VGND VPWR VGND sky130_ef_sc_hd__decap_12
XFILLER_0_106_176 VPWR VGND VPWR VGND sky130_ef_sc_hd__decap_12
XFILLER_0_122_658 VPWR VGND VPWR VGND sky130_ef_sc_hd__decap_12
XFILLER_0_20_623 VGND VGND VPWR VPWR sky130_fd_sc_hd__decap_3
XFILLER_0_32_483 VGND VGND VPWR VPWR sky130_fd_sc_hd__fill_1
XFILLER_0_20_645 VGND VGND VPWR VPWR sky130_fd_sc_hd__decap_8
XFILLER_0_47_27 VGND VGND VPWR VPWR sky130_fd_sc_hd__decap_8
XFILLER_0_2_29 VPWR VGND VPWR VGND sky130_ef_sc_hd__decap_12
XFILLER_0_99_461 VPWR VGND VPWR VGND sky130_ef_sc_hd__decap_12
XFILLER_0_87_623 VGND VGND VPWR VPWR sky130_fd_sc_hd__fill_1
XFILLER_0_28_701 VPWR VGND VPWR VGND sky130_ef_sc_hd__decap_12
X_4790_ _1730_ _1809_ _1817_ VGND VGND VPWR VPWR _1827_ sky130_fd_sc_hd__o21ai_1
XFILLER_0_27_200 VGND VGND VPWR VPWR sky130_fd_sc_hd__fill_1
XFILLER_0_7_617 VPWR VGND VPWR VGND sky130_ef_sc_hd__decap_12
XFILLER_0_27_222 VGND VGND VPWR VPWR sky130_fd_sc_hd__fill_2
XFILLER_0_103_54 VGND VGND VPWR VPWR sky130_fd_sc_hd__fill_2
XFILLER_0_70_512 VGND VGND VPWR VPWR sky130_fd_sc_hd__fill_1
XFILLER_0_12_41 VGND VGND VPWR VPWR sky130_fd_sc_hd__fill_2
X_6460_ _3454_ VGND VGND VPWR VPWR _3458_ sky130_fd_sc_hd__inv_2
XFILLER_0_12_85 VGND VGND VPWR VPWR sky130_fd_sc_hd__fill_1
XFILLER_0_113_625 VGND VGND VPWR VPWR sky130_fd_sc_hd__decap_3
XFILLER_0_70_589 VGND VGND VPWR VPWR sky130_fd_sc_hd__fill_1
X_6391_ _3337_ _3333_ _3339_ VGND VGND VPWR VPWR _3390_ sky130_fd_sc_hd__o21a_1
XFILLER_0_2_300 VGND VGND VPWR VPWR sky130_fd_sc_hd__decap_4
X_5411_ _2384_ _2383_ _2381_ _2434_ _2376_ VGND VGND VPWR VPWR _2435_ sky130_fd_sc_hd__a32oi_2
XFILLER_0_11_601 VGND VGND VPWR VPWR sky130_fd_sc_hd__decap_4
XFILLER_0_2_344 VGND VGND VPWR VPWR sky130_fd_sc_hd__decap_8
XFILLER_0_23_472 VGND VGND VPWR VPWR sky130_fd_sc_hd__decap_3
X_5342_ _2366_ _2367_ VGND VGND VPWR VPWR _0158_ sky130_fd_sc_hd__xor2_1
X_8130_ _0901_ _0891_ _0967_ _0974_ VGND VGND VPWR VPWR _0977_ sky130_fd_sc_hd__o211ai_2
XFILLER_0_2_377 VPWR VGND VPWR VGND sky130_ef_sc_hd__decap_12
X_8061_ _0904_ _0884_ _0885_ VGND VGND VPWR VPWR _0909_ sky130_fd_sc_hd__nand3_1
XFILLER_0_56_6 VGND VGND VPWR VPWR sky130_fd_sc_hd__decap_6
X_7012_ _3982_ _3985_ _3989_ VGND VGND VPWR VPWR _3998_ sky130_fd_sc_hd__a21o_1
X_5273_ _2192_ _2197_ _2194_ _2295_ VGND VGND VPWR VPWR _2300_ sky130_fd_sc_hd__a31o_1
X_4224_ _1238_ _1268_ VGND VGND VPWR VPWR _1272_ sky130_fd_sc_hd__nor2_2
XFILLER_0_78_601 VGND VGND VPWR VPWR sky130_fd_sc_hd__decap_8
XFILLER_0_77_111 VGND VGND VPWR VPWR sky130_fd_sc_hd__fill_1
X_7914_ net35 _0762_ VGND VGND VPWR VPWR _0763_ sky130_fd_sc_hd__nor2_2
XFILLER_0_93_615 VGND VGND VPWR VPWR sky130_fd_sc_hd__fill_1
X_7845_ carry4\[4\] net315 VGND VGND VPWR VPWR _0708_ sky130_fd_sc_hd__nor2_1
XFILLER_0_65_328 VGND VGND VPWR VPWR sky130_fd_sc_hd__decap_8
X_4988_ _1990_ _2016_ _2020_ VGND VGND VPWR VPWR _2021_ sky130_fd_sc_hd__or3_1
XFILLER_0_92_147 VGND VGND VPWR VPWR sky130_fd_sc_hd__fill_2
X_7776_ carry2\[4\] net413 _0673_ VGND VGND VPWR VPWR _0025_ sky130_fd_sc_hd__o21a_1
XFILLER_0_116_430 VGND VGND VPWR VPWR sky130_fd_sc_hd__fill_1
XFILLER_0_80_309 VPWR VGND VPWR VGND sky130_ef_sc_hd__decap_12
XFILLER_0_61_501 VGND VGND VPWR VPWR sky130_fd_sc_hd__decap_3
X_6727_ sh1\[1\] VGND VGND VPWR VPWR _3717_ sky130_fd_sc_hd__clkbuf_4
X_6658_ _3591_ _3642_ _3638_ VGND VGND VPWR VPWR _3652_ sky130_fd_sc_hd__or3_1
XFILLER_0_18_288 VGND VGND VPWR VPWR sky130_fd_sc_hd__fill_2
XFILLER_0_33_225 VGND VGND VPWR VPWR sky130_fd_sc_hd__fill_1
XFILLER_0_116_474 VGND VGND VPWR VPWR sky130_fd_sc_hd__fill_2
XFILLER_0_104_636 VGND VGND VPWR VPWR sky130_fd_sc_hd__decap_8
X_5609_ _2565_ _2555_ VGND VGND VPWR VPWR _2627_ sky130_fd_sc_hd__nand2_2
X_6589_ _3503_ _3551_ _3579_ _3580_ VGND VGND VPWR VPWR _3585_ sky130_fd_sc_hd__o211ai_1
X_8328_ _1164_ _1165_ VGND VGND VPWR VPWR _1166_ sky130_fd_sc_hd__and2_1
XFILLER_0_5_193 VPWR VGND VPWR VGND sky130_ef_sc_hd__decap_12
XFILLER_0_14_472 VGND VGND VPWR VPWR sky130_fd_sc_hd__decap_4
X_8259_ _1064_ _1101_ _1102_ VGND VGND VPWR VPWR _1103_ sky130_fd_sc_hd__a21oi_2
XTAP_1332 VGND VPWR sky130_fd_sc_hd__tapvpwrvgnd_1
XTAP_1321 VGND VPWR sky130_fd_sc_hd__tapvpwrvgnd_1
XTAP_1310 VGND VPWR sky130_fd_sc_hd__tapvpwrvgnd_1
XFILLER_0_69_656 VPWR VGND VPWR VGND sky130_ef_sc_hd__decap_12
XFILLER_0_96_475 VGND VGND VPWR VPWR sky130_fd_sc_hd__fill_1
XTAP_1365 VGND VPWR sky130_fd_sc_hd__tapvpwrvgnd_1
XTAP_1354 VGND VPWR sky130_fd_sc_hd__tapvpwrvgnd_1
XTAP_1343 VGND VPWR sky130_fd_sc_hd__tapvpwrvgnd_1
XTAP_1398 VGND VPWR sky130_fd_sc_hd__tapvpwrvgnd_1
XTAP_1376 VGND VPWR sky130_fd_sc_hd__tapvpwrvgnd_1
XTAP_1387 VGND VPWR sky130_fd_sc_hd__tapvpwrvgnd_1
XFILLER_0_83_125 VPWR VGND VPWR VGND sky130_ef_sc_hd__decap_12
XFILLER_0_49_391 VGND VGND VPWR VPWR sky130_fd_sc_hd__fill_1
XFILLER_0_92_681 VPWR VGND VPWR VGND sky130_ef_sc_hd__decap_12
XFILLER_0_4_609 VPWR VGND VPWR VGND sky130_ef_sc_hd__decap_12
XFILLER_0_24_236 VPWR VGND VPWR VGND sky130_ef_sc_hd__decap_12
XFILLER_0_122_400 VGND VGND VPWR VPWR sky130_fd_sc_hd__fill_1
XFILLER_0_107_496 VGND VGND VPWR VPWR sky130_fd_sc_hd__decap_8
XFILLER_0_107_485 VGND VGND VPWR VPWR sky130_fd_sc_hd__fill_1
XFILLER_0_52_567 VPWR VGND VPWR VGND sky130_ef_sc_hd__decap_12
XFILLER_0_24_258 VGND VGND VPWR VPWR sky130_fd_sc_hd__fill_1
XFILLER_0_122_444 VGND VGND VPWR VPWR sky130_fd_sc_hd__decap_8
XFILLER_0_122_477 VGND VGND VPWR VPWR sky130_fd_sc_hd__decap_4
XFILLER_0_58_26 VGND VGND VPWR VPWR sky130_fd_sc_hd__fill_2
XFILLER_0_20_464 VPWR VGND VPWR VGND sky130_ef_sc_hd__decap_12
XFILLER_0_79_409 VGND VGND VPWR VPWR sky130_fd_sc_hd__fill_1
X_5960_ _2929_ _2968_ _2921_ VGND VGND VPWR VPWR _2969_ sky130_fd_sc_hd__o21ai_2
XFILLER_0_59_111 VGND VGND VPWR VPWR sky130_fd_sc_hd__fill_1
X_4911_ _1944_ _1941_ _1943_ VGND VGND VPWR VPWR _1946_ sky130_fd_sc_hd__and3_2
X_5891_ _2899_ _2887_ _2892_ VGND VGND VPWR VPWR _2901_ sky130_fd_sc_hd__nor3_1
X_7630_ _4169_ VGND VGND VPWR VPWR _0618_ sky130_fd_sc_hd__inv_2
XFILLER_0_75_615 VGND VGND VPWR VPWR sky130_fd_sc_hd__fill_1
XFILLER_0_114_53 VGND VGND VPWR VPWR sky130_fd_sc_hd__decap_8
X_4842_ _1876_ _1877_ _1868_ _1857_ VGND VGND VPWR VPWR _1878_ sky130_fd_sc_hd__o211ai_2
XFILLER_0_75_648 VGND VGND VPWR VPWR sky130_fd_sc_hd__decap_4
X_4773_ _1797_ _1798_ _1720_ VGND VGND VPWR VPWR _1810_ sky130_fd_sc_hd__o21bai_1
XFILLER_0_90_618 VGND VGND VPWR VPWR sky130_fd_sc_hd__decap_3
XFILLER_0_83_670 VGND VGND VPWR VPWR sky130_fd_sc_hd__fill_2
XFILLER_0_62_309 VGND VGND VPWR VPWR sky130_fd_sc_hd__decap_3
X_7561_ _4163_ VGND VGND VPWR VPWR _0555_ sky130_fd_sc_hd__inv_2
X_7492_ _4156_ VGND VGND VPWR VPWR _0493_ sky130_fd_sc_hd__inv_2
XFILLER_0_82_180 VGND VGND VPWR VPWR sky130_fd_sc_hd__decap_4
X_6512_ _3377_ _3451_ sh12\[4\] VGND VGND VPWR VPWR _3509_ sky130_fd_sc_hd__o21a_1
XFILLER_0_70_320 VPWR VGND VPWR VGND sky130_ef_sc_hd__decap_12
X_6443_ _3434_ _3439_ _3440_ VGND VGND VPWR VPWR _3441_ sky130_fd_sc_hd__a21o_1
XFILLER_0_15_247 VGND VGND VPWR VPWR sky130_fd_sc_hd__decap_6
XFILLER_0_3_653 VPWR VGND VPWR VGND sky130_ef_sc_hd__decap_12
XFILLER_0_31_729 VGND VGND VPWR VPWR sky130_fd_sc_hd__decap_6
XFILLER_0_101_628 VGND VGND VPWR VPWR sky130_fd_sc_hd__fill_1
X_6374_ _3311_ _3331_ _3343_ VGND VGND VPWR VPWR _3373_ sky130_fd_sc_hd__o21ai_2
XFILLER_0_3_697 VPWR VGND VPWR VGND sky130_ef_sc_hd__decap_12
XFILLER_0_2_141 VPWR VGND VPWR VGND sky130_ef_sc_hd__decap_12
X_8113_ _0725_ _0721_ _0863_ _0951_ _0727_ VGND VGND VPWR VPWR _0960_ sky130_fd_sc_hd__o221ai_4
X_5325_ _2347_ _2346_ VGND VGND VPWR VPWR _2351_ sky130_fd_sc_hd__nand2_1
X_8044_ sh9\[3\] VGND VGND VPWR VPWR _0892_ sky130_fd_sc_hd__buf_4
XFILLER_0_54_3 VGND VGND VPWR VPWR sky130_fd_sc_hd__decap_8
XFILLER_0_11_497 VGND VGND VPWR VPWR sky130_fd_sc_hd__decap_6
X_5256_ _2282_ _2271_ _2273_ VGND VGND VPWR VPWR _2283_ sky130_fd_sc_hd__a21oi_1
X_5187_ _2202_ _2205_ _2212_ _2214_ VGND VGND VPWR VPWR _2215_ sky130_fd_sc_hd__o22ai_4
XFILLER_0_64_91 VGND VGND VPWR VPWR sky130_fd_sc_hd__decap_6
XFILLER_0_78_464 VPWR VGND VPWR VGND sky130_ef_sc_hd__decap_12
XFILLER_0_93_401 VGND VGND VPWR VPWR sky130_fd_sc_hd__decap_8
X_7828_ sum3\[5\] net381 _0699_ VGND VGND VPWR VPWR _0035_ sky130_fd_sc_hd__o21a_1
XFILLER_0_108_227 VGND VGND VPWR VPWR sky130_fd_sc_hd__decap_8
XFILLER_0_81_607 VGND VGND VPWR VPWR sky130_fd_sc_hd__decap_8
X_7759_ carry4\[11\] sum4\[12\] VGND VGND VPWR VPWR _0661_ sky130_fd_sc_hd__nor2_1
XFILLER_0_80_139 VGND VGND VPWR VPWR sky130_fd_sc_hd__fill_1
XFILLER_0_104_433 VGND VGND VPWR VPWR sky130_fd_sc_hd__fill_1
XFILLER_0_61_386 VGND VGND VPWR VPWR sky130_fd_sc_hd__decap_6
XFILLER_0_21_217 VGND VGND VPWR VPWR sky130_fd_sc_hd__fill_2
XFILLER_0_34_589 VGND VGND VPWR VPWR sky130_fd_sc_hd__decap_6
XFILLER_0_28_29 VPWR VGND VPWR VGND sky130_ef_sc_hd__decap_12
XFILLER_0_89_729 VGND VGND VPWR VPWR sky130_fd_sc_hd__decap_6
XFILLER_0_96_250 VGND VGND VPWR VPWR sky130_fd_sc_hd__fill_2
XTAP_1140 VGND VPWR sky130_fd_sc_hd__tapvpwrvgnd_1
XTAP_1173 VGND VPWR sky130_fd_sc_hd__tapvpwrvgnd_1
XTAP_1162 VGND VPWR sky130_fd_sc_hd__tapvpwrvgnd_1
XTAP_1151 VGND VPWR sky130_fd_sc_hd__tapvpwrvgnd_1
XFILLER_0_56_136 VGND VGND VPWR VPWR sky130_fd_sc_hd__decap_4
XTAP_1195 VGND VPWR sky130_fd_sc_hd__tapvpwrvgnd_1
XTAP_1184 VGND VPWR sky130_fd_sc_hd__tapvpwrvgnd_1
XFILLER_0_115_709 VPWR VGND VPWR VGND sky130_ef_sc_hd__decap_12
XFILLER_0_71_128 VGND VGND VPWR VPWR sky130_fd_sc_hd__decap_3
XFILLER_0_4_417 VGND VGND VPWR VPWR sky130_fd_sc_hd__decap_3
XFILLER_0_25_545 VPWR VGND VPWR VGND sky130_ef_sc_hd__decap_12
XFILLER_0_13_729 VGND VGND VPWR VPWR sky130_fd_sc_hd__decap_6
XFILLER_0_0_601 VPWR VGND VPWR VGND sky130_ef_sc_hd__decap_12
XFILLER_0_110_425 VGND VGND VPWR VPWR sky130_fd_sc_hd__fill_1
XFILLER_0_0_645 VPWR VGND VPWR VGND sky130_ef_sc_hd__decap_12
X_6090_ _2870_ _2907_ _3096_ _2871_ VGND VGND VPWR VPWR _3097_ sky130_fd_sc_hd__o211ai_2
XTAP_935 VGND VPWR sky130_fd_sc_hd__tapvpwrvgnd_1
X_5110_ sh0\[2\] sh3\[2\] VGND VGND VPWR VPWR _2139_ sky130_fd_sc_hd__and2_2
XFILLER_0_20_294 VGND VGND VPWR VPWR sky130_fd_sc_hd__fill_1
XTAP_902 VGND VPWR sky130_fd_sc_hd__tapvpwrvgnd_1
XTAP_913 VGND VPWR sky130_fd_sc_hd__tapvpwrvgnd_1
XTAP_924 VGND VPWR sky130_fd_sc_hd__tapvpwrvgnd_1
XFILLER_0_85_57 VPWR VGND VPWR VGND sky130_ef_sc_hd__decap_12
XTAP_968 VGND VPWR sky130_fd_sc_hd__tapvpwrvgnd_1
XTAP_946 VGND VPWR sky130_fd_sc_hd__tapvpwrvgnd_1
XTAP_957 VGND VPWR sky130_fd_sc_hd__tapvpwrvgnd_1
X_5041_ net38 VGND VGND VPWR VPWR _2071_ sky130_fd_sc_hd__clkbuf_4
XTAP_979 VGND VPWR sky130_fd_sc_hd__tapvpwrvgnd_1
X_8800_ clknet_leaf_3_clk net343 _0551_ VGND VGND VPWR VPWR sh6\[4\] sky130_fd_sc_hd__dfrtp_4
X_8731_ clknet_leaf_15_clk _0137_ _0482_ VGND VGND VPWR VPWR bit_sum6\[2\] sky130_fd_sc_hd__dfrtp_1
X_6992_ _3787_ _3752_ VGND VGND VPWR VPWR _3978_ sky130_fd_sc_hd__nand2_1
X_5943_ _2950_ _2951_ _2886_ VGND VGND VPWR VPWR _2952_ sky130_fd_sc_hd__o21bai_2
XFILLER_0_118_503 VGND VGND VPWR VPWR sky130_fd_sc_hd__fill_2
X_5874_ _2878_ sh0\[6\] VGND VGND VPWR VPWR _2884_ sky130_fd_sc_hd__nor2_2
X_8662_ clknet_leaf_22_clk net75 _0413_ VGND VGND VPWR VPWR s7\[9\] sky130_fd_sc_hd__dfrtp_1
XFILLER_0_87_294 VPWR VGND VPWR VGND sky130_ef_sc_hd__decap_12
XFILLER_0_75_456 VGND VGND VPWR VPWR sky130_fd_sc_hd__decap_4
XFILLER_0_8_701 VPWR VGND VPWR VGND sky130_ef_sc_hd__decap_12
XFILLER_0_34_83 VGND VGND VPWR VPWR sky130_fd_sc_hd__fill_1
X_4825_ _1722_ _1791_ VGND VGND VPWR VPWR _1861_ sky130_fd_sc_hd__nand2_1
X_7613_ _4168_ VGND VGND VPWR VPWR _0602_ sky130_fd_sc_hd__inv_2
XFILLER_0_63_629 VGND VGND VPWR VPWR sky130_fd_sc_hd__decap_4
XFILLER_0_35_309 VGND VGND VPWR VPWR sky130_fd_sc_hd__fill_1
X_8593_ clknet_leaf_35_clk _0055_ _0344_ VGND VGND VPWR VPWR sum1\[5\] sky130_fd_sc_hd__dfrtp_1
XFILLER_0_118_569 VGND VGND VPWR VPWR sky130_fd_sc_hd__decap_4
X_7544_ _4162_ VGND VGND VPWR VPWR _0539_ sky130_fd_sc_hd__inv_2
XFILLER_0_16_512 VGND VGND VPWR VPWR sky130_fd_sc_hd__fill_1
X_4756_ _1722_ _1791_ _1792_ VGND VGND VPWR VPWR _1793_ sky130_fd_sc_hd__a21o_1
XFILLER_0_16_567 VGND VGND VPWR VPWR sky130_fd_sc_hd__fill_1
X_4687_ _1639_ _1722_ _1674_ VGND VGND VPWR VPWR _1725_ sky130_fd_sc_hd__o21a_1
X_7475_ _4154_ VGND VGND VPWR VPWR _0478_ sky130_fd_sc_hd__inv_2
XFILLER_0_71_673 VGND VGND VPWR VPWR sky130_fd_sc_hd__decap_4
XFILLER_0_70_161 VGND VGND VPWR VPWR sky130_fd_sc_hd__decap_3
XFILLER_0_16_589 VPWR VGND VPWR VGND sky130_ef_sc_hd__decap_12
XFILLER_0_31_526 VGND VGND VPWR VPWR sky130_fd_sc_hd__decap_4
X_6426_ _3302_ _3306_ _3423_ VGND VGND VPWR VPWR _3424_ sky130_fd_sc_hd__a21oi_2
XFILLER_0_3_472 VPWR VGND VPWR VGND sky130_ef_sc_hd__decap_12
XFILLER_0_31_559 VGND VGND VPWR VPWR sky130_fd_sc_hd__fill_1
X_6357_ _3306_ sh6\[4\] sh14\[4\] _3355_ VGND VGND VPWR VPWR _3356_ sky130_fd_sc_hd__a211o_1
X_5308_ _2323_ _2326_ _2329_ _2333_ VGND VGND VPWR VPWR _2334_ sky130_fd_sc_hd__o211ai_1
X_6288_ sh10\[4\] _3286_ _3287_ VGND VGND VPWR VPWR _3288_ sky130_fd_sc_hd__a21o_2
X_8027_ _0874_ _0867_ _0814_ _0868_ VGND VGND VPWR VPWR _0875_ sky130_fd_sc_hd__o211a_1
X_5239_ _2263_ _2260_ _2264_ _2265_ VGND VGND VPWR VPWR _2266_ sky130_fd_sc_hd__o2bb2ai_2
XFILLER_0_98_548 VGND VGND VPWR VPWR sky130_fd_sc_hd__decap_8
XPHY_201 VGND VGND VPWR VPWR sky130_fd_sc_hd__decap_3
XFILLER_0_78_272 VGND VGND VPWR VPWR sky130_fd_sc_hd__decap_4
XPHY_234 VGND VGND VPWR VPWR sky130_fd_sc_hd__decap_3
XPHY_223 VGND VGND VPWR VPWR sky130_fd_sc_hd__decap_3
XPHY_212 VGND VGND VPWR VPWR sky130_fd_sc_hd__decap_3
XPHY_245 VGND VGND VPWR VPWR sky130_fd_sc_hd__decap_3
XFILLER_0_26_309 VPWR VGND VPWR VGND sky130_ef_sc_hd__decap_12
XFILLER_0_117_580 VGND VGND VPWR VPWR sky130_fd_sc_hd__decap_6
XFILLER_0_62_640 VGND VGND VPWR VPWR sky130_fd_sc_hd__decap_4
XFILLER_0_62_684 VPWR VGND VPWR VGND sky130_ef_sc_hd__decap_12
XFILLER_0_120_701 VPWR VGND VPWR VGND sky130_ef_sc_hd__decap_12
XFILLER_0_39_39 VPWR VGND VPWR VGND sky130_ef_sc_hd__decap_12
Xhold5 bit_sum3\[7\] VGND VGND VPWR VPWR net47 sky130_fd_sc_hd__dlygate4sd3_1
XFILLER_0_85_721 VGND VGND VPWR VPWR sky130_fd_sc_hd__decap_6
XFILLER_0_71_15 VPWR VGND VPWR VGND sky130_ef_sc_hd__decap_12
XFILLER_0_69_250 VGND VGND VPWR VPWR sky130_fd_sc_hd__fill_2
XFILLER_0_29_169 VPWR VGND VPWR VGND sky130_ef_sc_hd__decap_12
X_4610_ sh4\[7\] VGND VGND VPWR VPWR _1649_ sky130_fd_sc_hd__clkbuf_4
XFILLER_0_115_517 VGND VGND VPWR VPWR sky130_fd_sc_hd__fill_2
XFILLER_0_112_3 VPWR VGND VPWR VGND sky130_ef_sc_hd__decap_12
X_5590_ sh8\[0\] sh9\[0\] VGND VGND VPWR VPWR _2608_ sky130_fd_sc_hd__nor2_1
X_4541_ _1579_ _1584_ VGND VGND VPWR VPWR _1585_ sky130_fd_sc_hd__nand2_1
XFILLER_0_13_526 VPWR VGND VPWR VGND sky130_ef_sc_hd__decap_12
XFILLER_0_20_52 VGND VGND VPWR VPWR sky130_fd_sc_hd__decap_8
XFILLER_0_123_561 VPWR VGND VPWR VGND sky130_ef_sc_hd__decap_12
X_4472_ _1511_ _1505_ _1509_ VGND VGND VPWR VPWR _1517_ sky130_fd_sc_hd__a21oi_1
XFILLER_0_80_492 VGND VGND VPWR VPWR sky130_fd_sc_hd__decap_6
X_7260_ _4133_ VGND VGND VPWR VPWR _0284_ sky130_fd_sc_hd__inv_2
XFILLER_0_4_269 VPWR VGND VPWR VGND sky130_ef_sc_hd__decap_12
XFILLER_0_20_85 VPWR VGND VPWR VGND sky130_ef_sc_hd__decap_12
Xhold405 s0\[6\] VGND VGND VPWR VPWR net447 sky130_fd_sc_hd__dlygate4sd3_1
X_6211_ _3191_ _3211_ _3215_ VGND VGND VPWR VPWR _3216_ sky130_fd_sc_hd__o21ai_4
XFILLER_0_110_211 VPWR VGND VPWR VGND sky130_ef_sc_hd__decap_12
X_7191_ _4127_ VGND VGND VPWR VPWR _0221_ sky130_fd_sc_hd__inv_2
X_6142_ _3146_ _3147_ VGND VGND VPWR VPWR _3148_ sky130_fd_sc_hd__or2_2
XFILLER_0_21_592 VGND VGND VPWR VPWR sky130_fd_sc_hd__decap_6
XTAP_710 VGND VPWR sky130_fd_sc_hd__tapvpwrvgnd_1
XTAP_721 VGND VPWR sky130_fd_sc_hd__tapvpwrvgnd_1
XTAP_732 VGND VPWR sky130_fd_sc_hd__tapvpwrvgnd_1
XTAP_743 VGND VPWR sky130_fd_sc_hd__tapvpwrvgnd_1
X_6073_ _2889_ _2890_ _2875_ VGND VGND VPWR VPWR _3080_ sky130_fd_sc_hd__o21ai_2
XTAP_754 VGND VPWR sky130_fd_sc_hd__tapvpwrvgnd_1
XTAP_765 VGND VPWR sky130_fd_sc_hd__tapvpwrvgnd_1
XTAP_776 VGND VPWR sky130_fd_sc_hd__tapvpwrvgnd_1
X_5024_ sh1\[2\] sh0\[2\] VGND VGND VPWR VPWR _2054_ sky130_fd_sc_hd__and2_1
XTAP_787 VGND VPWR sky130_fd_sc_hd__tapvpwrvgnd_1
XTAP_798 VGND VPWR sky130_fd_sc_hd__tapvpwrvgnd_1
XFILLER_0_17_3 VPWR VGND VPWR VGND sky130_ef_sc_hd__decap_12
XFILLER_0_76_710 VGND VGND VPWR VPWR sky130_fd_sc_hd__decap_4
X_6975_ _3960_ _3956_ _3961_ VGND VGND VPWR VPWR _3962_ sky130_fd_sc_hd__o21ai_1
X_5926_ _2933_ _2930_ _2931_ VGND VGND VPWR VPWR _2935_ sky130_fd_sc_hd__nand3_2
X_8714_ clknet_leaf_32_clk _0122_ _0465_ VGND VGND VPWR VPWR bit_sum4\[5\] sky130_fd_sc_hd__dfrtp_1
XFILLER_0_118_300 VGND VGND VPWR VPWR sky130_fd_sc_hd__decap_3
X_8645_ clknet_leaf_15_clk net76 _0396_ VGND VGND VPWR VPWR s5\[10\] sky130_fd_sc_hd__dfrtp_1
XFILLER_0_63_404 VGND VGND VPWR VPWR sky130_fd_sc_hd__decap_4
XFILLER_0_61_81 VGND VGND VPWR VPWR sky130_fd_sc_hd__fill_2
X_5857_ _2866_ _2546_ _2867_ VGND VGND VPWR VPWR _0172_ sky130_fd_sc_hd__o21a_1
XFILLER_0_35_106 VGND VGND VPWR VPWR sky130_fd_sc_hd__decap_6
X_4808_ _1840_ _1842_ _1843_ VGND VGND VPWR VPWR _1844_ sky130_fd_sc_hd__nand3_4
X_8576_ clknet_leaf_32_clk _0061_ _0327_ VGND VGND VPWR VPWR sum2\[11\] sky130_fd_sc_hd__dfrtp_1
X_5788_ _2798_ _2801_ _2802_ VGND VGND VPWR VPWR _2803_ sky130_fd_sc_hd__o21ai_2
X_4739_ _1774_ _1775_ net40 VGND VGND VPWR VPWR _1776_ sky130_fd_sc_hd__o21bai_4
X_7527_ _4160_ VGND VGND VPWR VPWR _0524_ sky130_fd_sc_hd__inv_2
XFILLER_0_114_561 VGND VGND VPWR VPWR sky130_fd_sc_hd__fill_1
XFILLER_0_102_701 VPWR VGND VPWR VGND sky130_ef_sc_hd__decap_12
X_7458_ _4153_ VGND VGND VPWR VPWR _0462_ sky130_fd_sc_hd__inv_2
XFILLER_0_9_93 VPWR VGND VPWR VGND sky130_ef_sc_hd__decap_12
XFILLER_0_101_222 VGND VGND VPWR VPWR sky130_fd_sc_hd__fill_2
X_6409_ _3354_ _3407_ _3364_ VGND VGND VPWR VPWR _3408_ sky130_fd_sc_hd__a21bo_1
X_7389_ _4146_ VGND VGND VPWR VPWR _0400_ sky130_fd_sc_hd__inv_2
XFILLER_0_12_592 VGND VGND VPWR VPWR sky130_fd_sc_hd__decap_6
XFILLER_0_58_209 VGND VGND VPWR VPWR sky130_fd_sc_hd__decap_6
XFILLER_0_67_732 VGND VGND VPWR VPWR sky130_fd_sc_hd__decap_3
XFILLER_0_66_253 VPWR VGND VPWR VGND sky130_ef_sc_hd__decap_12
XFILLER_0_66_297 VGND VGND VPWR VPWR sky130_fd_sc_hd__decap_6
XFILLER_0_54_437 VGND VGND VPWR VPWR sky130_fd_sc_hd__fill_1
XFILLER_0_19_191 VPWR VGND VPWR VGND sky130_ef_sc_hd__decap_12
XFILLER_0_26_139 VGND VGND VPWR VPWR sky130_fd_sc_hd__fill_1
XFILLER_0_81_267 VGND VGND VPWR VPWR sky130_fd_sc_hd__decap_8
XFILLER_0_35_673 VPWR VGND VPWR VGND sky130_ef_sc_hd__decap_12
XFILLER_0_105_561 VPWR VGND VPWR VGND sky130_ef_sc_hd__decap_12
XFILLER_0_50_643 VGND VGND VPWR VPWR sky130_fd_sc_hd__fill_1
XFILLER_0_1_217 VGND VGND VPWR VPWR sky130_fd_sc_hd__decap_6
XFILLER_0_66_15 VPWR VGND VPWR VGND sky130_ef_sc_hd__decap_12
XFILLER_0_89_323 VPWR VGND VPWR VGND sky130_ef_sc_hd__decap_12
XFILLER_0_106_32 VGND VGND VPWR VPWR sky130_fd_sc_hd__decap_4
XFILLER_0_106_76 VGND VGND VPWR VPWR sky130_fd_sc_hd__decap_8
XFILLER_0_58_721 VPWR VGND VPWR VGND sky130_ef_sc_hd__decap_12
X_6760_ _3745_ _3746_ _3734_ _3733_ _3748_ VGND VGND VPWR VPWR _3749_ sky130_fd_sc_hd__o221ai_4
XFILLER_0_119_119 VGND VGND VPWR VPWR sky130_fd_sc_hd__fill_1
XFILLER_0_15_96 VGND VGND VPWR VPWR sky130_fd_sc_hd__decap_4
X_5711_ _2726_ _2671_ _2674_ VGND VGND VPWR VPWR _2727_ sky130_fd_sc_hd__a21oi_1
XFILLER_0_85_595 VGND VGND VPWR VPWR sky130_fd_sc_hd__fill_1
X_6691_ _3638_ _3641_ _3683_ _3650_ VGND VGND VPWR VPWR _3685_ sky130_fd_sc_hd__o211ai_1
XFILLER_0_72_201 VGND VGND VPWR VPWR sky130_fd_sc_hd__decap_8
XFILLER_0_57_275 VGND VGND VPWR VPWR sky130_fd_sc_hd__decap_4
XFILLER_0_122_53 VPWR VGND VPWR VGND sky130_ef_sc_hd__decap_12
X_8430_ _1229_ _1223_ _1226_ VGND VGND VPWR VPWR _1260_ sky130_fd_sc_hd__and3_1
X_5642_ _2653_ _2659_ _2521_ VGND VGND VPWR VPWR _2660_ sky130_fd_sc_hd__a21o_1
XFILLER_0_122_97 VPWR VGND VPWR VGND sky130_ef_sc_hd__decap_12
X_8361_ _1184_ _1187_ _1194_ VGND VGND VPWR VPWR _1196_ sky130_fd_sc_hd__nor3_1
XFILLER_0_60_418 VGND VGND VPWR VPWR sky130_fd_sc_hd__fill_2
X_5573_ _2558_ _2570_ _2571_ _2575_ _2580_ VGND VGND VPWR VPWR _2592_ sky130_fd_sc_hd__o221ai_2
XFILLER_0_5_545 VPWR VGND VPWR VGND sky130_ef_sc_hd__decap_12
XFILLER_0_26_684 VPWR VGND VPWR VGND sky130_ef_sc_hd__decap_12
X_4524_ _1558_ _1562_ _1564_ VGND VGND VPWR VPWR _1568_ sky130_fd_sc_hd__a21oi_2
Xhold202 _0021_ VGND VGND VPWR VPWR net244 sky130_fd_sc_hd__dlygate4sd3_1
XFILLER_0_13_334 VGND VGND VPWR VPWR sky130_fd_sc_hd__fill_2
XFILLER_0_25_172 VGND VGND VPWR VPWR sky130_fd_sc_hd__decap_6
X_7312_ _4139_ VGND VGND VPWR VPWR _0330_ sky130_fd_sc_hd__inv_2
Xhold213 sh10\[7\] VGND VGND VPWR VPWR net255 sky130_fd_sc_hd__dlygate4sd3_1
Xhold235 carry4\[8\] VGND VGND VPWR VPWR net277 sky130_fd_sc_hd__dlygate4sd3_1
X_8292_ _1124_ _1131_ _1129_ VGND VGND VPWR VPWR _1134_ sky130_fd_sc_hd__a21o_1
Xhold224 s2\[2\] VGND VGND VPWR VPWR net266 sky130_fd_sc_hd__buf_1
X_4455_ _1498_ _1491_ _1492_ VGND VGND VPWR VPWR _1500_ sky130_fd_sc_hd__a21o_1
Xhold257 carry4\[5\] VGND VGND VPWR VPWR net299 sky130_fd_sc_hd__dlygate4sd3_1
Xhold246 _0028_ VGND VGND VPWR VPWR net288 sky130_fd_sc_hd__dlygate4sd3_1
X_7243_ _4125_ VGND VGND VPWR VPWR _4132_ sky130_fd_sc_hd__buf_4
Xhold268 sum2\[6\] VGND VGND VPWR VPWR net310 sky130_fd_sc_hd__dlygate4sd3_1
X_4386_ _1430_ _1431_ _1422_ _1425_ VGND VGND VPWR VPWR _1432_ sky130_fd_sc_hd__o211a_1
X_7174_ _4124_ VGND VGND VPWR VPWR _0207_ sky130_fd_sc_hd__inv_2
Xhold279 sh13\[1\] VGND VGND VPWR VPWR net321 sky130_fd_sc_hd__dlygate4sd3_1
X_6125_ _2923_ _3066_ _3063_ VGND VGND VPWR VPWR _3132_ sky130_fd_sc_hd__a21o_1
XTAP_540 VGND VPWR sky130_fd_sc_hd__tapvpwrvgnd_1
XTAP_551 VGND VPWR sky130_fd_sc_hd__tapvpwrvgnd_1
XTAP_562 VGND VPWR sky130_fd_sc_hd__tapvpwrvgnd_1
XTAP_573 VGND VPWR sky130_fd_sc_hd__tapvpwrvgnd_1
XTAP_584 VGND VPWR sky130_fd_sc_hd__tapvpwrvgnd_1
X_6056_ _3061_ _3062_ _3059_ VGND VGND VPWR VPWR _3064_ sky130_fd_sc_hd__and3_1
XTAP_595 VGND VPWR sky130_fd_sc_hd__tapvpwrvgnd_1
X_5007_ sh2\[2\] VGND VGND VPWR VPWR _2037_ sky130_fd_sc_hd__clkbuf_4
XTAP_1706 VGND VPWR sky130_fd_sc_hd__tapvpwrvgnd_1
XFILLER_0_49_710 VPWR VGND VPWR VGND sky130_ef_sc_hd__decap_12
XTAP_1728 VGND VPWR sky130_fd_sc_hd__tapvpwrvgnd_1
XTAP_1739 VGND VPWR sky130_fd_sc_hd__tapvpwrvgnd_1
XTAP_1717 VGND VPWR sky130_fd_sc_hd__tapvpwrvgnd_1
XFILLER_0_95_348 VGND VGND VPWR VPWR sky130_fd_sc_hd__decap_4
XFILLER_0_95_337 VGND VGND VPWR VPWR sky130_fd_sc_hd__decap_8
X_6958_ _3939_ _3940_ _3936_ VGND VGND VPWR VPWR _3945_ sky130_fd_sc_hd__nand3_2
XFILLER_0_48_242 VGND VGND VPWR VPWR sky130_fd_sc_hd__decap_3
XFILLER_0_48_253 VGND VGND VPWR VPWR sky130_fd_sc_hd__decap_8
XFILLER_0_119_642 VPWR VGND VPWR VGND sky130_ef_sc_hd__decap_12
X_5909_ _2916_ _2917_ net37 VGND VGND VPWR VPWR _2918_ sky130_fd_sc_hd__o21ai_1
XFILLER_0_64_713 VPWR VGND VPWR VGND sky130_ef_sc_hd__decap_12
X_6889_ _3742_ _3735_ _3738_ _3754_ VGND VGND VPWR VPWR _3877_ sky130_fd_sc_hd__a31oi_2
XFILLER_0_36_404 VPWR VGND VPWR VGND sky130_ef_sc_hd__decap_12
XFILLER_0_36_437 VGND VGND VPWR VPWR sky130_fd_sc_hd__fill_1
XFILLER_0_119_697 VPWR VGND VPWR VGND sky130_ef_sc_hd__decap_12
XFILLER_0_91_554 VGND VGND VPWR VPWR sky130_fd_sc_hd__decap_3
X_8628_ clknet_leaf_54_clk net63 _0379_ VGND VGND VPWR VPWR s3\[11\] sky130_fd_sc_hd__dfrtp_1
X_8559_ clknet_leaf_27_clk _0089_ _0310_ VGND VGND VPWR VPWR sum4\[9\] sky130_fd_sc_hd__dfrtp_1
XFILLER_0_17_673 VPWR VGND VPWR VGND sky130_ef_sc_hd__decap_12
XFILLER_0_23_109 VGND VGND VPWR VPWR sky130_fd_sc_hd__decap_3
XFILLER_0_16_194 VGND VGND VPWR VPWR sky130_fd_sc_hd__fill_2
XFILLER_0_121_328 VGND VGND VPWR VPWR sky130_fd_sc_hd__fill_1
XFILLER_0_102_531 VGND VGND VPWR VPWR sky130_fd_sc_hd__fill_1
XFILLER_0_102_586 VGND VGND VPWR VPWR sky130_fd_sc_hd__fill_2
XFILLER_0_6_3 VPWR VGND VPWR VGND sky130_ef_sc_hd__decap_12
XFILLER_0_31_197 VGND VGND VPWR VPWR sky130_fd_sc_hd__fill_1
XFILLER_0_36_29 VPWR VGND VPWR VGND sky130_ef_sc_hd__decap_12
XFILLER_0_99_665 VGND VGND VPWR VPWR sky130_fd_sc_hd__decap_6
XFILLER_0_109_130 VPWR VGND VPWR VGND sky130_ef_sc_hd__decap_12
XFILLER_0_55_713 VPWR VGND VPWR VGND sky130_ef_sc_hd__decap_12
XFILLER_0_39_297 VGND VGND VPWR VPWR sky130_fd_sc_hd__fill_1
XFILLER_0_109_185 VGND VGND VPWR VPWR sky130_fd_sc_hd__decap_8
XFILLER_0_112_306 VGND VGND VPWR VPWR sky130_fd_sc_hd__fill_2
X_4240_ sh0\[5\] sh3\[5\] VGND VGND VPWR VPWR _1288_ sky130_fd_sc_hd__and2_2
XFILLER_0_77_69 VPWR VGND VPWR VGND sky130_ef_sc_hd__decap_12
XFILLER_0_10_348 VGND VGND VPWR VPWR sky130_fd_sc_hd__decap_3
XFILLER_0_93_57 VPWR VGND VPWR VGND sky130_ef_sc_hd__decap_12
X_7930_ sh0\[3\] _0772_ VGND VGND VPWR VPWR _0779_ sky130_fd_sc_hd__nand2_1
X_7861_ carry4\[12\] net379 net264 VGND VGND VPWR VPWR _0716_ sky130_fd_sc_hd__o21a_1
XFILLER_0_77_337 VPWR VGND VPWR VGND sky130_ef_sc_hd__decap_12
X_6812_ _3750_ _3724_ _3768_ VGND VGND VPWR VPWR _3801_ sky130_fd_sc_hd__o21a_1
XFILLER_0_92_307 VGND VGND VPWR VPWR sky130_fd_sc_hd__fill_1
X_7792_ net444 VGND VGND VPWR VPWR _0045_ sky130_fd_sc_hd__clkbuf_1
XFILLER_0_9_125 VPWR VGND VPWR VGND sky130_ef_sc_hd__decap_12
XFILLER_0_92_329 VGND VGND VPWR VPWR sky130_fd_sc_hd__decap_6
XFILLER_0_85_370 VGND VGND VPWR VPWR sky130_fd_sc_hd__decap_8
XFILLER_0_58_573 VPWR VGND VPWR VGND sky130_ef_sc_hd__decap_12
X_6743_ net433 _3732_ VGND VGND VPWR VPWR _0104_ sky130_fd_sc_hd__xor2_1
X_6674_ _3603_ _3654_ _3659_ _3660_ _3661_ VGND VGND VPWR VPWR _3668_ sky130_fd_sc_hd__o311a_1
XFILLER_0_73_554 VGND VGND VPWR VPWR sky130_fd_sc_hd__decap_6
XFILLER_0_9_169 VPWR VGND VPWR VGND sky130_ef_sc_hd__decap_12
XFILLER_0_42_83 VGND VGND VPWR VPWR sky130_fd_sc_hd__fill_1
X_8413_ _1242_ VGND VGND VPWR VPWR _1243_ sky130_fd_sc_hd__buf_4
XFILLER_0_115_111 VGND VGND VPWR VPWR sky130_fd_sc_hd__fill_1
X_5625_ _2641_ _2642_ _2615_ VGND VGND VPWR VPWR _2643_ sky130_fd_sc_hd__o21ai_2
XFILLER_0_116_689 VGND VGND VPWR VPWR sky130_fd_sc_hd__decap_8
XFILLER_0_84_3 VPWR VGND VPWR VGND sky130_ef_sc_hd__decap_12
XFILLER_0_45_289 VGND VGND VPWR VPWR sky130_fd_sc_hd__decap_3
X_8344_ _1178_ _1179_ carry5\[10\] VGND VGND VPWR VPWR _1180_ sky130_fd_sc_hd__nor3b_2
X_5556_ _2512_ _2514_ _2573_ _2574_ VGND VGND VPWR VPWR _2575_ sky130_fd_sc_hd__a31oi_2
X_4507_ _1494_ _1488_ VGND VGND VPWR VPWR _1551_ sky130_fd_sc_hd__nand2_2
X_8275_ _1087_ _1118_ VGND VGND VPWR VPWR _1119_ sky130_fd_sc_hd__xor2_2
XFILLER_0_13_186 VGND VGND VPWR VPWR sky130_fd_sc_hd__fill_2
X_5487_ sh2\[0\] VGND VGND VPWR VPWR _2506_ sky130_fd_sc_hd__clkbuf_4
XFILLER_0_41_462 VPWR VGND VPWR VGND sky130_ef_sc_hd__decap_12
X_4438_ _1417_ _1483_ VGND VGND VPWR VPWR _0130_ sky130_fd_sc_hd__xnor2_1
X_7226_ _4130_ VGND VGND VPWR VPWR _0253_ sky130_fd_sc_hd__inv_2
XFILLER_0_6_83 VGND VGND VPWR VPWR sky130_fd_sc_hd__fill_1
X_4369_ _1413_ _1415_ VGND VGND VPWR VPWR _1416_ sky130_fd_sc_hd__nand2_1
X_7157_ _4123_ VGND VGND VPWR VPWR _0191_ sky130_fd_sc_hd__inv_2
X_6108_ _3094_ _3114_ _3105_ _3112_ VGND VGND VPWR VPWR _3115_ sky130_fd_sc_hd__o211ai_4
XTAP_392 VGND VPWR sky130_fd_sc_hd__tapvpwrvgnd_1
XTAP_381 VGND VPWR sky130_fd_sc_hd__tapvpwrvgnd_1
XTAP_370 VGND VPWR sky130_fd_sc_hd__tapvpwrvgnd_1
X_7088_ _4039_ _4023_ _4032_ VGND VGND VPWR VPWR _4072_ sky130_fd_sc_hd__o21ai_1
X_6039_ _2967_ _3046_ VGND VGND VPWR VPWR _3047_ sky130_fd_sc_hd__nand2_1
XFILLER_0_96_657 VPWR VGND VPWR VGND sky130_ef_sc_hd__decap_12
XTAP_1514 VGND VPWR sky130_fd_sc_hd__tapvpwrvgnd_1
XTAP_1503 VGND VPWR sky130_fd_sc_hd__tapvpwrvgnd_1
XFILLER_0_95_101 VGND VGND VPWR VPWR sky130_fd_sc_hd__decap_8
XPHY_21 VGND VGND VPWR VPWR sky130_fd_sc_hd__decap_3
XPHY_10 VGND VGND VPWR VPWR sky130_fd_sc_hd__decap_3
XTAP_1547 VGND VPWR sky130_fd_sc_hd__tapvpwrvgnd_1
XTAP_1536 VGND VPWR sky130_fd_sc_hd__tapvpwrvgnd_1
XTAP_1525 VGND VPWR sky130_fd_sc_hd__tapvpwrvgnd_1
XFILLER_0_68_359 VGND VGND VPWR VPWR sky130_fd_sc_hd__decap_4
XPHY_32 VGND VGND VPWR VPWR sky130_fd_sc_hd__decap_3
XPHY_43 VGND VGND VPWR VPWR sky130_fd_sc_hd__decap_3
XPHY_54 VGND VGND VPWR VPWR sky130_fd_sc_hd__decap_3
XPHY_65 VGND VGND VPWR VPWR sky130_fd_sc_hd__decap_3
XTAP_1558 VGND VPWR sky130_fd_sc_hd__tapvpwrvgnd_1
XTAP_1569 VGND VPWR sky130_fd_sc_hd__tapvpwrvgnd_1
XFILLER_0_95_178 VGND VGND VPWR VPWR sky130_fd_sc_hd__fill_1
XFILLER_0_83_318 VGND VGND VPWR VPWR sky130_fd_sc_hd__decap_3
XPHY_76 VGND VGND VPWR VPWR sky130_fd_sc_hd__decap_3
XPHY_87 VGND VGND VPWR VPWR sky130_fd_sc_hd__decap_3
XPHY_98 VGND VGND VPWR VPWR sky130_fd_sc_hd__decap_3
XFILLER_0_121_125 VPWR VGND VPWR VGND sky130_ef_sc_hd__decap_12
XFILLER_0_121_169 VPWR VGND VPWR VGND sky130_ef_sc_hd__decap_12
XFILLER_0_2_19 VGND VGND VPWR VPWR sky130_fd_sc_hd__decap_8
XFILLER_0_99_473 VGND VGND VPWR VPWR sky130_fd_sc_hd__decap_6
XFILLER_0_59_337 VPWR VGND VPWR VGND sky130_ef_sc_hd__decap_12
XFILLER_0_28_713 VPWR VGND VPWR VGND sky130_ef_sc_hd__decap_12
XFILLER_0_7_629 VPWR VGND VPWR VGND sky130_ef_sc_hd__decap_12
XFILLER_0_103_44 VGND VGND VPWR VPWR sky130_fd_sc_hd__decap_4
XFILLER_0_6_139 VGND VGND VPWR VPWR sky130_fd_sc_hd__fill_1
XFILLER_0_27_267 VPWR VGND VPWR VGND sky130_ef_sc_hd__decap_12
XFILLER_0_43_727 VGND VGND VPWR VPWR sky130_fd_sc_hd__fill_1
XFILLER_0_27_289 VGND VGND VPWR VPWR sky130_fd_sc_hd__fill_1
X_6390_ _3286_ sh12\[4\] VGND VGND VPWR VPWR _3389_ sky130_fd_sc_hd__and2_1
X_5410_ _2106_ _2189_ _2374_ VGND VGND VPWR VPWR _2434_ sky130_fd_sc_hd__a21o_1
X_5341_ _2246_ _2312_ _2313_ VGND VGND VPWR VPWR _2367_ sky130_fd_sc_hd__o21a_1
XFILLER_0_50_270 VGND VGND VPWR VPWR sky130_fd_sc_hd__decap_8
XFILLER_0_2_389 VGND VGND VPWR VPWR sky130_fd_sc_hd__fill_2
X_8060_ _0845_ _0835_ _0848_ VGND VGND VPWR VPWR _0908_ sky130_fd_sc_hd__o21a_1
X_7011_ _3995_ _3996_ _3941_ VGND VGND VPWR VPWR _3997_ sky130_fd_sc_hd__a21oi_1
X_5272_ _2294_ _2296_ _2298_ VGND VGND VPWR VPWR _2299_ sky130_fd_sc_hd__a21oi_1
X_4223_ _1239_ sh2\[5\] VGND VGND VPWR VPWR _1271_ sky130_fd_sc_hd__and2_2
X_7913_ sh8\[3\] VGND VGND VPWR VPWR _0762_ sky130_fd_sc_hd__clkbuf_4
X_7844_ sum3\[13\] net418 _0707_ VGND VGND VPWR VPWR _0033_ sky130_fd_sc_hd__o21a_1
XFILLER_0_78_657 VGND VGND VPWR VPWR sky130_fd_sc_hd__fill_1
XFILLER_0_77_167 VGND VGND VPWR VPWR sky130_fd_sc_hd__fill_1
X_7775_ carry2\[4\] sum2\[5\] net227 VGND VGND VPWR VPWR _0673_ sky130_fd_sc_hd__a21o_1
XFILLER_0_53_93 VPWR VGND VPWR VGND sky130_ef_sc_hd__decap_12
X_4987_ _2014_ _2012_ VGND VGND VPWR VPWR _2020_ sky130_fd_sc_hd__nand2_1
XFILLER_0_58_381 VGND VGND VPWR VPWR sky130_fd_sc_hd__fill_1
X_6726_ _3711_ _3714_ _3715_ VGND VGND VPWR VPWR _3716_ sky130_fd_sc_hd__nand3_1
XFILLER_0_18_234 VPWR VGND VPWR VGND sky130_ef_sc_hd__decap_12
XFILLER_0_46_576 VGND VGND VPWR VPWR sky130_fd_sc_hd__decap_8
XFILLER_0_116_464 VGND VGND VPWR VPWR sky130_fd_sc_hd__decap_4
XFILLER_0_116_442 VGND VGND VPWR VPWR sky130_fd_sc_hd__decap_4
X_6657_ _3645_ _3651_ VGND VGND VPWR VPWR _0123_ sky130_fd_sc_hd__nor2_1
XFILLER_0_116_497 VGND VGND VPWR VPWR sky130_fd_sc_hd__fill_1
X_6588_ _3511_ _3547_ _3581_ _3583_ VGND VGND VPWR VPWR _3584_ sky130_fd_sc_hd__o22ai_2
XFILLER_0_5_161 VGND VGND VPWR VPWR sky130_fd_sc_hd__decap_6
X_5608_ _2624_ _2625_ VGND VGND VPWR VPWR _2626_ sky130_fd_sc_hd__nand2_1
X_8327_ _1163_ _1162_ VGND VGND VPWR VPWR _1165_ sky130_fd_sc_hd__nand2_1
X_5539_ _2513_ _2553_ _2554_ _2555_ _2557_ VGND VGND VPWR VPWR _2558_ sky130_fd_sc_hd__o221a_2
XFILLER_0_112_670 VGND VGND VPWR VPWR sky130_fd_sc_hd__decap_8
XFILLER_0_103_169 VGND VGND VPWR VPWR sky130_fd_sc_hd__decap_6
XFILLER_0_103_158 VGND VGND VPWR VPWR sky130_fd_sc_hd__decap_8
XFILLER_0_41_281 VGND VGND VPWR VPWR sky130_fd_sc_hd__decap_4
XFILLER_0_112_681 VGND VGND VPWR VPWR sky130_fd_sc_hd__fill_2
X_8258_ _0742_ _0870_ _1058_ VGND VGND VPWR VPWR _1102_ sky130_fd_sc_hd__o21ai_1
X_7209_ _4128_ VGND VGND VPWR VPWR _0238_ sky130_fd_sc_hd__inv_2
X_8189_ _1032_ _1033_ _1034_ VGND VGND VPWR VPWR _1035_ sky130_fd_sc_hd__nand3_2
XFILLER_0_96_421 VGND VGND VPWR VPWR sky130_fd_sc_hd__decap_8
XTAP_1322 VGND VPWR sky130_fd_sc_hd__tapvpwrvgnd_1
XTAP_1300 VGND VPWR sky130_fd_sc_hd__tapvpwrvgnd_1
XTAP_1311 VGND VPWR sky130_fd_sc_hd__tapvpwrvgnd_1
XFILLER_0_69_668 VGND VGND VPWR VPWR sky130_fd_sc_hd__decap_4
XTAP_1366 VGND VPWR sky130_fd_sc_hd__tapvpwrvgnd_1
XTAP_1355 VGND VPWR sky130_fd_sc_hd__tapvpwrvgnd_1
XTAP_1344 VGND VPWR sky130_fd_sc_hd__tapvpwrvgnd_1
XTAP_1333 VGND VPWR sky130_fd_sc_hd__tapvpwrvgnd_1
XFILLER_0_56_318 VGND VGND VPWR VPWR sky130_fd_sc_hd__decap_6
XFILLER_0_56_307 VGND VGND VPWR VPWR sky130_fd_sc_hd__fill_1
XTAP_1399 VGND VPWR sky130_fd_sc_hd__tapvpwrvgnd_1
XTAP_1377 VGND VPWR sky130_fd_sc_hd__tapvpwrvgnd_1
XTAP_1388 VGND VPWR sky130_fd_sc_hd__tapvpwrvgnd_1
XFILLER_0_83_137 VPWR VGND VPWR VGND sky130_ef_sc_hd__decap_12
XFILLER_0_77_690 VGND VGND VPWR VPWR sky130_fd_sc_hd__decap_8
XFILLER_0_92_660 VGND VGND VPWR VPWR sky130_fd_sc_hd__fill_1
XFILLER_0_52_502 VGND VGND VPWR VPWR sky130_fd_sc_hd__fill_1
XFILLER_0_25_705 VGND VGND VPWR VPWR sky130_fd_sc_hd__decap_3
XFILLER_0_107_453 VGND VGND VPWR VPWR sky130_fd_sc_hd__decap_8
XFILLER_0_92_693 VGND VGND VPWR VPWR sky130_fd_sc_hd__decap_6
XFILLER_0_24_204 VPWR VGND VPWR VGND sky130_ef_sc_hd__decap_12
XFILLER_0_52_579 VGND VGND VPWR VPWR sky130_fd_sc_hd__decap_8
XFILLER_0_24_248 VGND VGND VPWR VPWR sky130_fd_sc_hd__fill_1
XFILLER_0_20_410 VGND VGND VPWR VPWR sky130_fd_sc_hd__fill_1
XFILLER_0_20_421 VGND VGND VPWR VPWR sky130_fd_sc_hd__decap_3
XFILLER_0_87_421 VGND VGND VPWR VPWR sky130_fd_sc_hd__decap_3
X_4910_ _1941_ _1943_ _1944_ VGND VGND VPWR VPWR _1945_ sky130_fd_sc_hd__a21oi_1
X_5890_ _2887_ _2892_ _2899_ VGND VGND VPWR VPWR _2900_ sky130_fd_sc_hd__o21a_1
X_4841_ _1851_ _1850_ VGND VGND VPWR VPWR _1877_ sky130_fd_sc_hd__nand2_1
XFILLER_0_59_167 VGND VGND VPWR VPWR sky130_fd_sc_hd__fill_1
XFILLER_0_23_41 VGND VGND VPWR VPWR sky130_fd_sc_hd__fill_2
X_4772_ _1717_ _1693_ _1727_ VGND VGND VPWR VPWR _1809_ sky130_fd_sc_hd__a21boi_1
X_7560_ _4163_ VGND VGND VPWR VPWR _0554_ sky130_fd_sc_hd__inv_2
XFILLER_0_99_45 VGND VGND VPWR VPWR sky130_fd_sc_hd__fill_2
X_7491_ _4156_ VGND VGND VPWR VPWR _0492_ sky130_fd_sc_hd__inv_2
X_6511_ _3292_ _3288_ _3507_ VGND VGND VPWR VPWR _3508_ sky130_fd_sc_hd__a21oi_4
XFILLER_0_15_204 VGND VGND VPWR VPWR sky130_fd_sc_hd__decap_4
X_6442_ _3378_ _3375_ _3372_ VGND VGND VPWR VPWR _3440_ sky130_fd_sc_hd__a21boi_2
XFILLER_0_70_332 VGND VGND VPWR VPWR sky130_fd_sc_hd__decap_4
XFILLER_0_70_365 VPWR VGND VPWR VGND sky130_ef_sc_hd__decap_12
XFILLER_0_30_207 VGND VGND VPWR VPWR sky130_fd_sc_hd__decap_8
XFILLER_0_30_229 VPWR VGND VPWR VGND sky130_ef_sc_hd__decap_12
X_6373_ _3365_ _3368_ _3369_ _3371_ VGND VGND VPWR VPWR _3372_ sky130_fd_sc_hd__o211ai_4
XFILLER_0_70_398 VPWR VGND VPWR VGND sky130_ef_sc_hd__decap_12
X_8112_ _0826_ _0892_ _0955_ VGND VGND VPWR VPWR _0959_ sky130_fd_sc_hd__a21oi_4
XFILLER_0_3_665 VGND VGND VPWR VPWR sky130_fd_sc_hd__decap_6
XFILLER_0_2_153 VPWR VGND VPWR VGND sky130_ef_sc_hd__decap_12
XFILLER_0_23_281 VPWR VGND VPWR VGND sky130_ef_sc_hd__decap_12
XFILLER_0_51_590 VGND VGND VPWR VPWR sky130_fd_sc_hd__fill_1
XFILLER_0_2_197 VPWR VGND VPWR VGND sky130_ef_sc_hd__decap_12
X_5324_ _2249_ _2267_ _2276_ VGND VGND VPWR VPWR _2350_ sky130_fd_sc_hd__o21a_1
XFILLER_0_11_487 VGND VGND VPWR VPWR sky130_fd_sc_hd__fill_1
X_5255_ _2272_ _2271_ _2274_ VGND VGND VPWR VPWR _2282_ sky130_fd_sc_hd__a21oi_2
XFILLER_0_48_60 VGND VGND VPWR VPWR sky130_fd_sc_hd__fill_1
X_8043_ _0887_ _0888_ _0830_ _0726_ _0797_ VGND VGND VPWR VPWR _0891_ sky130_fd_sc_hd__o311a_4
XFILLER_0_47_3 VPWR VGND VPWR VGND sky130_ef_sc_hd__decap_12
X_5186_ _2213_ _2207_ _2211_ _2208_ VGND VGND VPWR VPWR _2214_ sky130_fd_sc_hd__o211a_1
XFILLER_0_3_51 VGND VGND VPWR VPWR sky130_fd_sc_hd__decap_4
X_7827_ sum3\[5\] carry3\[4\] s5\[5\] VGND VGND VPWR VPWR _0699_ sky130_fd_sc_hd__a21o_1
XFILLER_0_109_729 VGND VGND VPWR VPWR sky130_fd_sc_hd__decap_6
X_7758_ carry4\[11\] sum4\[12\] VGND VGND VPWR VPWR _0660_ sky130_fd_sc_hd__and2_1
XFILLER_0_19_565 VGND VGND VPWR VPWR sky130_fd_sc_hd__fill_1
XFILLER_0_123_209 VPWR VGND VPWR VGND sky130_ef_sc_hd__decap_12
XFILLER_0_19_598 VGND VGND VPWR VPWR sky130_fd_sc_hd__decap_3
X_6709_ sh10\[1\] sh11\[1\] VGND VGND VPWR VPWR _3699_ sky130_fd_sc_hd__and2_1
XFILLER_0_46_373 VGND VGND VPWR VPWR sky130_fd_sc_hd__fill_2
X_7689_ carry1\[2\] net334 _4208_ VGND VGND VPWR VPWR _0013_ sky130_fd_sc_hd__o21a_1
XFILLER_0_116_272 VGND VGND VPWR VPWR sky130_fd_sc_hd__fill_1
XFILLER_0_116_250 VGND VGND VPWR VPWR sky130_fd_sc_hd__fill_2
XFILLER_0_61_354 VGND VGND VPWR VPWR sky130_fd_sc_hd__decap_8
XFILLER_0_116_294 VGND VGND VPWR VPWR sky130_fd_sc_hd__decap_4
XFILLER_0_14_292 VPWR VGND VPWR VGND sky130_ef_sc_hd__decap_12
XFILLER_0_100_662 VPWR VGND VPWR VGND sky130_ef_sc_hd__decap_12
XFILLER_0_44_29 VPWR VGND VPWR VGND sky130_ef_sc_hd__decap_12
XFILLER_0_69_432 VPWR VGND VPWR VGND sky130_ef_sc_hd__decap_12
XTAP_1130 VGND VPWR sky130_fd_sc_hd__tapvpwrvgnd_1
XTAP_1141 VGND VPWR sky130_fd_sc_hd__tapvpwrvgnd_1
XFILLER_0_84_435 VGND VGND VPWR VPWR sky130_fd_sc_hd__decap_4
XFILLER_0_84_424 VGND VGND VPWR VPWR sky130_fd_sc_hd__decap_3
XTAP_1174 VGND VPWR sky130_fd_sc_hd__tapvpwrvgnd_1
XTAP_1163 VGND VPWR sky130_fd_sc_hd__tapvpwrvgnd_1
XTAP_1152 VGND VPWR sky130_fd_sc_hd__tapvpwrvgnd_1
XTAP_1196 VGND VPWR sky130_fd_sc_hd__tapvpwrvgnd_1
XTAP_1185 VGND VPWR sky130_fd_sc_hd__tapvpwrvgnd_1
XFILLER_0_25_535 VGND VGND VPWR VPWR sky130_fd_sc_hd__decap_6
XFILLER_0_123_721 VGND VGND VPWR VPWR sky130_fd_sc_hd__fill_1
XFILLER_0_8_29 VPWR VGND VPWR VGND sky130_ef_sc_hd__decap_12
XFILLER_0_25_557 VGND VGND VPWR VPWR sky130_fd_sc_hd__decap_3
XFILLER_0_40_505 VGND VGND VPWR VPWR sky130_fd_sc_hd__decap_6
XFILLER_0_122_253 VGND VGND VPWR VPWR sky130_fd_sc_hd__decap_4
XFILLER_0_100_45 VGND VGND VPWR VPWR sky130_fd_sc_hd__decap_4
XFILLER_0_0_613 VGND VGND VPWR VPWR sky130_fd_sc_hd__decap_3
XFILLER_0_100_67 VGND VGND VPWR VPWR sky130_fd_sc_hd__decap_3
XFILLER_0_0_657 VPWR VGND VPWR VGND sky130_ef_sc_hd__decap_12
XFILLER_0_20_273 VGND VGND VPWR VPWR sky130_fd_sc_hd__decap_3
XTAP_903 VGND VPWR sky130_fd_sc_hd__tapvpwrvgnd_1
XTAP_914 VGND VPWR sky130_fd_sc_hd__tapvpwrvgnd_1
XTAP_925 VGND VPWR sky130_fd_sc_hd__tapvpwrvgnd_1
XTAP_947 VGND VPWR sky130_fd_sc_hd__tapvpwrvgnd_1
XTAP_958 VGND VPWR sky130_fd_sc_hd__tapvpwrvgnd_1
XTAP_936 VGND VPWR sky130_fd_sc_hd__tapvpwrvgnd_1
X_5040_ _2066_ _2068_ _2069_ VGND VGND VPWR VPWR _2070_ sky130_fd_sc_hd__o21ai_1
XFILLER_0_109_65 VGND VGND VPWR VPWR sky130_fd_sc_hd__decap_4
XFILLER_0_109_54 VGND VGND VPWR VPWR sky130_fd_sc_hd__fill_2
XFILLER_0_85_69 VPWR VGND VPWR VGND sky130_ef_sc_hd__decap_12
XTAP_969 VGND VPWR sky130_fd_sc_hd__tapvpwrvgnd_1
XFILLER_0_18_52 VGND VGND VPWR VPWR sky130_fd_sc_hd__decap_6
XFILLER_0_109_76 VGND VGND VPWR VPWR sky130_fd_sc_hd__decap_8
XFILLER_0_79_207 VGND VGND VPWR VPWR sky130_fd_sc_hd__decap_3
X_6991_ _3787_ _3752_ VGND VGND VPWR VPWR _3977_ sky130_fd_sc_hd__nor2_1
X_5942_ _2879_ sh3\[6\] VGND VGND VPWR VPWR _2951_ sky130_fd_sc_hd__nor2_2
X_8730_ clknet_leaf_15_clk _0136_ _0481_ VGND VGND VPWR VPWR bit_sum6\[1\] sky130_fd_sc_hd__dfrtp_1
X_5873_ sh3\[6\] VGND VGND VPWR VPWR _2883_ sky130_fd_sc_hd__buf_2
X_8661_ clknet_leaf_22_clk net134 _0412_ VGND VGND VPWR VPWR s7\[8\] sky130_fd_sc_hd__dfrtp_4
XFILLER_0_8_713 VPWR VGND VPWR VGND sky130_ef_sc_hd__decap_12
XFILLER_0_118_537 VGND VGND VPWR VPWR sky130_fd_sc_hd__decap_6
X_4824_ _1664_ _1667_ _1859_ VGND VGND VPWR VPWR _1860_ sky130_fd_sc_hd__and3_2
X_7612_ _4168_ VGND VGND VPWR VPWR _0601_ sky130_fd_sc_hd__inv_2
XFILLER_0_7_223 VGND VGND VPWR VPWR sky130_fd_sc_hd__fill_1
X_8592_ clknet_leaf_35_clk _0054_ _0343_ VGND VGND VPWR VPWR sum1\[4\] sky130_fd_sc_hd__dfrtp_1
X_4755_ net31 sh9\[7\] sh12\[7\] VGND VGND VPWR VPWR _1792_ sky130_fd_sc_hd__o21ai_2
X_7543_ _4158_ VGND VGND VPWR VPWR _4162_ sky130_fd_sc_hd__clkbuf_16
XFILLER_0_43_332 VGND VGND VPWR VPWR sky130_fd_sc_hd__decap_4
XFILLER_0_50_83 VGND VGND VPWR VPWR sky130_fd_sc_hd__fill_1
XFILLER_0_113_231 VGND VGND VPWR VPWR sky130_fd_sc_hd__fill_2
X_4686_ _1721_ _1675_ _1723_ VGND VGND VPWR VPWR _1724_ sky130_fd_sc_hd__and3_1
X_7474_ _4154_ VGND VGND VPWR VPWR _0477_ sky130_fd_sc_hd__inv_2
XFILLER_0_31_505 VGND VGND VPWR VPWR sky130_fd_sc_hd__fill_1
XFILLER_0_113_253 VGND VGND VPWR VPWR sky130_fd_sc_hd__decap_4
X_6425_ sh4\[4\] sh5\[4\] sh7\[4\] VGND VGND VPWR VPWR _3423_ sky130_fd_sc_hd__o21ai_2
XFILLER_0_31_538 VGND VGND VPWR VPWR sky130_fd_sc_hd__fill_2
XFILLER_0_101_426 VPWR VGND VPWR VGND sky130_ef_sc_hd__decap_12
X_6356_ _3306_ sh6\[4\] _3307_ VGND VGND VPWR VPWR _3355_ sky130_fd_sc_hd__o21a_1
XFILLER_0_3_484 VPWR VGND VPWR VGND sky130_ef_sc_hd__decap_12
XFILLER_0_101_459 VGND VGND VPWR VPWR sky130_fd_sc_hd__fill_1
X_5307_ _2330_ _2331_ _2332_ VGND VGND VPWR VPWR _2333_ sky130_fd_sc_hd__nand3_2
X_6287_ sh10\[4\] sh11\[4\] sh12\[4\] VGND VGND VPWR VPWR _3287_ sky130_fd_sc_hd__o21ai_2
X_8026_ _0730_ _0772_ _0734_ VGND VGND VPWR VPWR _0874_ sky130_fd_sc_hd__o21ai_4
X_5238_ _2109_ _2189_ _2110_ VGND VGND VPWR VPWR _2265_ sky130_fd_sc_hd__and3_1
XFILLER_0_75_91 VPWR VGND VPWR VGND sky130_ef_sc_hd__decap_12
X_5169_ _2104_ _2189_ _2190_ VGND VGND VPWR VPWR _2197_ sky130_fd_sc_hd__a21o_1
XFILLER_0_78_251 VGND VGND VPWR VPWR sky130_fd_sc_hd__fill_1
XPHY_224 VGND VGND VPWR VPWR sky130_fd_sc_hd__decap_3
XPHY_213 VGND VGND VPWR VPWR sky130_fd_sc_hd__decap_3
XPHY_202 VGND VGND VPWR VPWR sky130_fd_sc_hd__decap_3
X_8859_ clknet_leaf_16_clk net363 _0610_ VGND VGND VPWR VPWR sh13\[7\] sky130_fd_sc_hd__dfrtp_1
XFILLER_0_94_733 VGND VGND VPWR VPWR sky130_fd_sc_hd__fill_2
XFILLER_0_78_284 VPWR VGND VPWR VGND sky130_ef_sc_hd__decap_12
XFILLER_0_66_424 VGND VGND VPWR VPWR sky130_fd_sc_hd__decap_4
XFILLER_0_38_126 VPWR VGND VPWR VGND sky130_ef_sc_hd__decap_12
XPHY_246 VGND VGND VPWR VPWR sky130_fd_sc_hd__decap_3
XPHY_235 VGND VGND VPWR VPWR sky130_fd_sc_hd__decap_3
XFILLER_0_109_526 VPWR VGND VPWR VGND sky130_ef_sc_hd__decap_12
XFILLER_0_81_405 VGND VGND VPWR VPWR sky130_fd_sc_hd__decap_6
XFILLER_0_66_457 VGND VGND VPWR VPWR sky130_fd_sc_hd__decap_4
XFILLER_0_54_608 VGND VGND VPWR VPWR sky130_fd_sc_hd__decap_6
XFILLER_0_81_449 VGND VGND VPWR VPWR sky130_fd_sc_hd__fill_2
XFILLER_0_34_332 VGND VGND VPWR VPWR sky130_fd_sc_hd__decap_4
XFILLER_0_105_732 VGND VGND VPWR VPWR sky130_fd_sc_hd__decap_3
XFILLER_0_120_713 VGND VGND VPWR VPWR sky130_fd_sc_hd__fill_2
XFILLER_0_62_696 VGND VGND VPWR VPWR sky130_fd_sc_hd__decap_4
Xhold6 bit_sum4\[3\] VGND VGND VPWR VPWR net48 sky130_fd_sc_hd__dlygate4sd3_1
XFILLER_0_71_27 VGND VGND VPWR VPWR sky130_fd_sc_hd__decap_3
XFILLER_0_57_435 VPWR VGND VPWR VGND sky130_ef_sc_hd__decap_12
XFILLER_0_57_413 VGND VGND VPWR VPWR sky130_fd_sc_hd__fill_2
XFILLER_0_84_265 VGND VGND VPWR VPWR sky130_fd_sc_hd__decap_6
XFILLER_0_72_405 VGND VGND VPWR VPWR sky130_fd_sc_hd__decap_6
XFILLER_0_5_705 VGND VGND VPWR VPWR sky130_fd_sc_hd__decap_3
XFILLER_0_38_660 VPWR VGND VPWR VGND sky130_ef_sc_hd__decap_12
XFILLER_0_111_11 VGND VGND VPWR VPWR sky130_fd_sc_hd__decap_3
XFILLER_0_37_181 VPWR VGND VPWR VGND sky130_ef_sc_hd__decap_12
Xclkbuf_leaf_10_clk clknet_3_3__leaf_clk VGND VGND VPWR VPWR clknet_leaf_10_clk sky130_fd_sc_hd__clkbuf_16
X_4540_ _1581_ _1582_ _1583_ VGND VGND VPWR VPWR _1584_ sky130_fd_sc_hd__nand3_2
XFILLER_0_105_3 VGND VGND VPWR VPWR sky130_fd_sc_hd__decap_8
XFILLER_0_80_460 VGND VGND VPWR VPWR sky130_fd_sc_hd__fill_2
XFILLER_0_13_505 VGND VGND VPWR VPWR sky130_fd_sc_hd__decap_6
X_4471_ _1502_ _1515_ _1509_ _1505_ VGND VGND VPWR VPWR _1516_ sky130_fd_sc_hd__o211a_1
XFILLER_0_52_195 VGND VGND VPWR VPWR sky130_fd_sc_hd__fill_1
XFILLER_0_13_538 VPWR VGND VPWR VGND sky130_ef_sc_hd__decap_12
Xhold406 s0\[4\] VGND VGND VPWR VPWR net448 sky130_fd_sc_hd__dlygate4sd3_1
X_6210_ _3211_ _3191_ _3214_ VGND VGND VPWR VPWR _3215_ sky130_fd_sc_hd__a21oi_2
XFILLER_0_110_223 VGND VGND VPWR VPWR sky130_fd_sc_hd__decap_6
XFILLER_0_110_201 VGND VGND VPWR VPWR sky130_fd_sc_hd__fill_2
XFILLER_0_0_421 VPWR VGND VPWR VGND sky130_ef_sc_hd__decap_12
XFILLER_0_20_97 VGND VGND VPWR VPWR sky130_fd_sc_hd__fill_2
X_7190_ _4127_ VGND VGND VPWR VPWR _0220_ sky130_fd_sc_hd__inv_2
X_6141_ _2922_ sh11\[6\] VGND VGND VPWR VPWR _3147_ sky130_fd_sc_hd__and2b_1
XTAP_700 VGND VPWR sky130_fd_sc_hd__tapvpwrvgnd_1
XTAP_711 VGND VPWR sky130_fd_sc_hd__tapvpwrvgnd_1
XTAP_722 VGND VPWR sky130_fd_sc_hd__tapvpwrvgnd_1
XTAP_733 VGND VPWR sky130_fd_sc_hd__tapvpwrvgnd_1
X_6072_ _3074_ _3075_ _3078_ VGND VGND VPWR VPWR _3079_ sky130_fd_sc_hd__nand3_4
XFILLER_0_29_95 VPWR VGND VPWR VGND sky130_ef_sc_hd__decap_12
XTAP_744 VGND VPWR sky130_fd_sc_hd__tapvpwrvgnd_1
XTAP_755 VGND VPWR sky130_fd_sc_hd__tapvpwrvgnd_1
XTAP_766 VGND VPWR sky130_fd_sc_hd__tapvpwrvgnd_1
XTAP_777 VGND VPWR sky130_fd_sc_hd__tapvpwrvgnd_1
X_5023_ _2052_ sh0\[2\] VGND VGND VPWR VPWR _2053_ sky130_fd_sc_hd__nor2_2
XTAP_788 VGND VPWR sky130_fd_sc_hd__tapvpwrvgnd_1
XTAP_799 VGND VPWR sky130_fd_sc_hd__tapvpwrvgnd_1
XFILLER_0_95_508 VGND VGND VPWR VPWR sky130_fd_sc_hd__decap_6
X_6974_ sh15\[1\] VGND VGND VPWR VPWR _3961_ sky130_fd_sc_hd__inv_2
X_5925_ _2930_ _2931_ _2933_ VGND VGND VPWR VPWR _2934_ sky130_fd_sc_hd__a21oi_2
XFILLER_0_88_582 VGND VGND VPWR VPWR sky130_fd_sc_hd__decap_3
X_8713_ clknet_leaf_32_clk _0121_ _0464_ VGND VGND VPWR VPWR bit_sum4\[4\] sky130_fd_sc_hd__dfrtp_1
XFILLER_0_0_41 VPWR VGND VPWR VGND sky130_ef_sc_hd__decap_12
XFILLER_0_48_413 VGND VGND VPWR VPWR sky130_fd_sc_hd__decap_6
XFILLER_0_48_435 VGND VGND VPWR VPWR sky130_fd_sc_hd__fill_1
X_8644_ clknet_leaf_15_clk net79 _0395_ VGND VGND VPWR VPWR s5\[9\] sky130_fd_sc_hd__dfrtp_1
XFILLER_0_8_510 VGND VGND VPWR VPWR sky130_fd_sc_hd__fill_2
XFILLER_0_0_85 VPWR VGND VPWR VGND sky130_ef_sc_hd__decap_12
X_5856_ _2466_ _2502_ _2544_ _2545_ VGND VGND VPWR VPWR _2867_ sky130_fd_sc_hd__a2bb2o_1
X_4807_ _1650_ _1682_ _1781_ VGND VGND VPWR VPWR _1843_ sky130_fd_sc_hd__o21a_1
XFILLER_0_63_438 VGND VGND VPWR VPWR sky130_fd_sc_hd__fill_1
XFILLER_0_29_671 VGND VGND VPWR VPWR sky130_fd_sc_hd__fill_1
XFILLER_0_118_378 VPWR VGND VPWR VGND sky130_ef_sc_hd__decap_12
XFILLER_0_63_449 VGND VGND VPWR VPWR sky130_fd_sc_hd__fill_1
X_8575_ clknet_leaf_32_clk _0060_ _0326_ VGND VGND VPWR VPWR sum2\[10\] sky130_fd_sc_hd__dfrtp_1
X_5787_ _2524_ _2748_ _2533_ VGND VGND VPWR VPWR _2802_ sky130_fd_sc_hd__a21o_1
X_4738_ net41 sh2\[7\] VGND VGND VPWR VPWR _1775_ sky130_fd_sc_hd__and2_2
X_7526_ _4160_ VGND VGND VPWR VPWR _0523_ sky130_fd_sc_hd__inv_2
XFILLER_0_16_365 VPWR VGND VPWR VGND sky130_ef_sc_hd__decap_12
X_4669_ _1651_ _1647_ VGND VGND VPWR VPWR _1707_ sky130_fd_sc_hd__nand2_1
X_7457_ _4153_ VGND VGND VPWR VPWR _0461_ sky130_fd_sc_hd__inv_2
XFILLER_0_16_387 VGND VGND VPWR VPWR sky130_fd_sc_hd__decap_8
XFILLER_0_102_713 VGND VGND VPWR VPWR sky130_fd_sc_hd__decap_6
X_6408_ _3352_ _3314_ _3396_ _3397_ VGND VGND VPWR VPWR _3407_ sky130_fd_sc_hd__o211ai_1
XFILLER_0_3_281 VGND VGND VPWR VPWR sky130_fd_sc_hd__decap_8
X_7388_ _4146_ VGND VGND VPWR VPWR _0399_ sky130_fd_sc_hd__inv_2
X_6339_ _3307_ net33 VGND VGND VPWR VPWR _3338_ sky130_fd_sc_hd__or2_1
X_8009_ _0807_ _0810_ _0856_ _0857_ VGND VGND VPWR VPWR _0858_ sky130_fd_sc_hd__a22oi_4
XFILLER_0_94_541 VPWR VGND VPWR VGND sky130_ef_sc_hd__decap_12
XFILLER_0_27_608 VGND VGND VPWR VPWR sky130_fd_sc_hd__decap_8
XFILLER_0_109_334 VGND VGND VPWR VPWR sky130_fd_sc_hd__fill_2
XFILLER_0_19_181 VGND VGND VPWR VPWR sky130_fd_sc_hd__decap_4
XFILLER_0_35_685 VPWR VGND VPWR VGND sky130_ef_sc_hd__decap_12
XFILLER_0_62_471 VGND VGND VPWR VPWR sky130_fd_sc_hd__decap_4
XFILLER_0_22_324 VPWR VGND VPWR VGND sky130_ef_sc_hd__decap_12
XFILLER_0_105_573 VGND VGND VPWR VPWR sky130_fd_sc_hd__decap_8
XFILLER_0_50_699 VGND VGND VPWR VPWR sky130_fd_sc_hd__fill_1
XFILLER_0_120_587 VGND VGND VPWR VPWR sky130_fd_sc_hd__fill_1
XFILLER_0_66_27 VGND VGND VPWR VPWR sky130_fd_sc_hd__fill_1
Xclkbuf_leaf_59_clk clknet_3_0__leaf_clk VGND VGND VPWR VPWR clknet_leaf_59_clk sky130_fd_sc_hd__clkbuf_16
XFILLER_0_89_335 VGND VGND VPWR VPWR sky130_fd_sc_hd__fill_1
XFILLER_0_82_15 VPWR VGND VPWR VGND sky130_ef_sc_hd__decap_12
XFILLER_0_58_733 VGND VGND VPWR VPWR sky130_fd_sc_hd__fill_2
X_5710_ _2470_ _2668_ _2671_ _2673_ VGND VGND VPWR VPWR _2726_ sky130_fd_sc_hd__a22oi_4
X_6690_ _3652_ _3650_ _3683_ VGND VGND VPWR VPWR _3684_ sky130_fd_sc_hd__a21o_1
XFILLER_0_17_107 VGND VGND VPWR VPWR sky130_fd_sc_hd__decap_4
XFILLER_0_122_65 VPWR VGND VPWR VGND sky130_ef_sc_hd__decap_12
XFILLER_0_115_304 VPWR VGND VPWR VGND sky130_ef_sc_hd__decap_12
XFILLER_0_26_630 VGND VGND VPWR VPWR sky130_fd_sc_hd__decap_3
XFILLER_0_26_641 VGND VGND VPWR VPWR sky130_fd_sc_hd__decap_3
X_5641_ _2654_ _2655_ _2658_ VGND VGND VPWR VPWR _2659_ sky130_fd_sc_hd__nand3_1
XFILLER_0_45_449 VGND VGND VPWR VPWR sky130_fd_sc_hd__fill_2
XFILLER_0_115_337 VGND VGND VPWR VPWR sky130_fd_sc_hd__decap_8
X_8360_ _1184_ _1187_ _1194_ VGND VGND VPWR VPWR _1195_ sky130_fd_sc_hd__o21a_1
X_5572_ _2551_ _2552_ VGND VGND VPWR VPWR _2591_ sky130_fd_sc_hd__nor2_1
X_4523_ _1543_ _1565_ _1566_ VGND VGND VPWR VPWR _1567_ sky130_fd_sc_hd__nand3b_4
X_8291_ _1124_ _1132_ _1133_ VGND VGND VPWR VPWR _0116_ sky130_fd_sc_hd__a21oi_1
XFILLER_0_5_557 VGND VGND VPWR VPWR sky130_fd_sc_hd__decap_3
XFILLER_0_26_696 VGND VGND VPWR VPWR sky130_fd_sc_hd__decap_4
X_7311_ _4139_ VGND VGND VPWR VPWR _0329_ sky130_fd_sc_hd__inv_2
Xhold225 sh0\[7\] VGND VGND VPWR VPWR net267 sky130_fd_sc_hd__buf_1
Xhold214 sh14\[7\] VGND VGND VPWR VPWR net256 sky130_fd_sc_hd__dlygate4sd3_1
X_7242_ _4131_ VGND VGND VPWR VPWR _0268_ sky130_fd_sc_hd__inv_2
Xhold203 sum1\[2\] VGND VGND VPWR VPWR net245 sky130_fd_sc_hd__dlygate4sd3_1
X_4454_ _1491_ _1492_ _1498_ VGND VGND VPWR VPWR _1499_ sky130_fd_sc_hd__nand3_1
XFILLER_0_111_532 VGND VGND VPWR VPWR sky130_fd_sc_hd__decap_4
Xhold247 sh9\[6\] VGND VGND VPWR VPWR net289 sky130_fd_sc_hd__dlygate4sd3_1
Xhold236 _0049_ VGND VGND VPWR VPWR net278 sky130_fd_sc_hd__dlygate4sd3_1
Xhold258 _0046_ VGND VGND VPWR VPWR net300 sky130_fd_sc_hd__dlygate4sd3_1
Xhold269 _0026_ VGND VGND VPWR VPWR net311 sky130_fd_sc_hd__dlygate4sd3_1
XFILLER_0_13_379 VGND VGND VPWR VPWR sky130_fd_sc_hd__fill_1
X_4385_ _1245_ _1299_ _1426_ VGND VGND VPWR VPWR _1431_ sky130_fd_sc_hd__a21oi_2
X_7173_ _4124_ VGND VGND VPWR VPWR _0206_ sky130_fd_sc_hd__inv_2
X_6124_ _3130_ sh15\[6\] _3125_ VGND VGND VPWR VPWR _3131_ sky130_fd_sc_hd__nand3_1
XTAP_530 VGND VPWR sky130_fd_sc_hd__tapvpwrvgnd_1
XTAP_541 VGND VPWR sky130_fd_sc_hd__tapvpwrvgnd_1
XTAP_552 VGND VPWR sky130_fd_sc_hd__tapvpwrvgnd_1
X_6055_ _3059_ _3061_ _3062_ VGND VGND VPWR VPWR _3063_ sky130_fd_sc_hd__a21oi_1
XTAP_563 VGND VPWR sky130_fd_sc_hd__tapvpwrvgnd_1
XTAP_574 VGND VPWR sky130_fd_sc_hd__tapvpwrvgnd_1
XTAP_585 VGND VPWR sky130_fd_sc_hd__tapvpwrvgnd_1
X_5006_ _1758_ _2036_ VGND VGND VPWR VPWR _0181_ sky130_fd_sc_hd__xor2_1
XTAP_596 VGND VPWR sky130_fd_sc_hd__tapvpwrvgnd_1
XTAP_1729 VGND VPWR sky130_fd_sc_hd__tapvpwrvgnd_1
XTAP_1718 VGND VPWR sky130_fd_sc_hd__tapvpwrvgnd_1
XTAP_1707 VGND VPWR sky130_fd_sc_hd__tapvpwrvgnd_1
X_6957_ _3883_ _3876_ VGND VGND VPWR VPWR _3944_ sky130_fd_sc_hd__nor2_1
XFILLER_0_49_722 VGND VGND VPWR VPWR sky130_fd_sc_hd__decap_6
XFILLER_0_119_654 VPWR VGND VPWR VGND sky130_ef_sc_hd__decap_12
X_5908_ _2879_ _2911_ VGND VGND VPWR VPWR _2917_ sky130_fd_sc_hd__and2_1
XFILLER_0_64_725 VGND VGND VPWR VPWR sky130_fd_sc_hd__decap_8
XFILLER_0_63_213 VGND VGND VPWR VPWR sky130_fd_sc_hd__fill_1
X_6888_ _3847_ _3852_ _3875_ VGND VGND VPWR VPWR _3876_ sky130_fd_sc_hd__a21oi_2
XFILLER_0_36_416 VGND VGND VPWR VPWR sky130_fd_sc_hd__decap_4
X_8627_ clknet_leaf_55_clk net47 _0378_ VGND VGND VPWR VPWR s3\[10\] sky130_fd_sc_hd__dfrtp_1
X_5839_ _2833_ _2829_ _2832_ VGND VGND VPWR VPWR _2852_ sky130_fd_sc_hd__o21a_1
X_8558_ clknet_leaf_27_clk _0088_ _0309_ VGND VGND VPWR VPWR sum4\[8\] sky130_fd_sc_hd__dfrtp_1
X_7509_ _4121_ VGND VGND VPWR VPWR _4158_ sky130_fd_sc_hd__buf_6
XFILLER_0_17_685 VPWR VGND VPWR VGND sky130_ef_sc_hd__decap_12
X_8489_ clknet_leaf_21_clk net158 _0240_ VGND VGND VPWR VPWR net12 sky130_fd_sc_hd__dfrtp_1
XFILLER_0_99_611 VGND VGND VPWR VPWR sky130_fd_sc_hd__decap_4
XFILLER_0_98_121 VPWR VGND VPWR VGND sky130_ef_sc_hd__decap_12
XFILLER_0_55_725 VGND VGND VPWR VPWR sky130_fd_sc_hd__decap_3
XFILLER_0_109_142 VGND VGND VPWR VPWR sky130_fd_sc_hd__decap_6
XFILLER_0_94_393 VGND VGND VPWR VPWR sky130_fd_sc_hd__decap_3
XFILLER_0_42_419 VGND VGND VPWR VPWR sky130_fd_sc_hd__fill_1
XFILLER_0_35_482 VGND VGND VPWR VPWR sky130_fd_sc_hd__decap_3
XFILLER_0_35_493 VGND VGND VPWR VPWR sky130_fd_sc_hd__decap_8
XFILLER_0_22_121 VGND VGND VPWR VPWR sky130_fd_sc_hd__decap_3
XFILLER_0_105_381 VGND VGND VPWR VPWR sky130_fd_sc_hd__decap_8
XFILLER_0_77_15 VPWR VGND VPWR VGND sky130_ef_sc_hd__decap_12
XFILLER_0_50_474 VGND VGND VPWR VPWR sky130_fd_sc_hd__fill_2
XFILLER_0_89_165 VGND VGND VPWR VPWR sky130_fd_sc_hd__decap_3
X_7860_ net360 net346 _0715_ VGND VGND VPWR VPWR _0042_ sky130_fd_sc_hd__o21a_1
X_6811_ _3795_ _3796_ _3799_ VGND VGND VPWR VPWR _3800_ sky130_fd_sc_hd__o21bai_1
XFILLER_0_77_349 VGND VGND VPWR VPWR sky130_fd_sc_hd__fill_1
X_7791_ carry4\[4\] net443 VGND VGND VPWR VPWR _0681_ sky130_fd_sc_hd__and2_1
XFILLER_0_58_585 VGND VGND VPWR VPWR sky130_fd_sc_hd__decap_3
XFILLER_0_9_137 VPWR VGND VPWR VGND sky130_ef_sc_hd__decap_12
X_6742_ _3705_ _3730_ _3731_ VGND VGND VPWR VPWR _3732_ sky130_fd_sc_hd__o21a_1
X_6673_ _3660_ _3657_ _3661_ VGND VGND VPWR VPWR _3667_ sky130_fd_sc_hd__a21oi_1
XFILLER_0_85_393 VPWR VGND VPWR VGND sky130_ef_sc_hd__decap_12
XFILLER_0_73_544 VGND VGND VPWR VPWR sky130_fd_sc_hd__fill_1
XFILLER_0_116_635 VGND VGND VPWR VPWR sky130_fd_sc_hd__fill_1
X_8412_ sh4\[5\] VGND VGND VPWR VPWR _1242_ sky130_fd_sc_hd__buf_4
XFILLER_0_61_706 VGND VGND VPWR VPWR sky130_fd_sc_hd__fill_2
XFILLER_0_60_205 VPWR VGND VPWR VGND sky130_ef_sc_hd__decap_12
X_5624_ _2558_ _2583_ _2631_ _2636_ VGND VGND VPWR VPWR _2642_ sky130_fd_sc_hd__o211a_1
XFILLER_0_115_134 VGND VGND VPWR VPWR sky130_fd_sc_hd__decap_6
X_8343_ sum5\[11\] s7\[11\] VGND VGND VPWR VPWR _1179_ sky130_fd_sc_hd__nor2_1
XFILLER_0_115_189 VGND VGND VPWR VPWR sky130_fd_sc_hd__fill_2
XFILLER_0_103_318 VPWR VGND VPWR VGND sky130_ef_sc_hd__decap_12
X_5555_ _2522_ _2525_ VGND VGND VPWR VPWR _2574_ sky130_fd_sc_hd__nand2_1
X_4506_ _1242_ sh2\[5\] VGND VGND VPWR VPWR _1550_ sky130_fd_sc_hd__and2_2
XFILLER_0_77_3 VPWR VGND VPWR VGND sky130_ef_sc_hd__decap_12
X_8274_ _1116_ _1117_ VGND VGND VPWR VPWR _1118_ sky130_fd_sc_hd__nand2_1
XFILLER_0_14_699 VGND VGND VPWR VPWR sky130_fd_sc_hd__fill_1
X_5486_ _2505_ VGND VGND VPWR VPWR _0107_ sky130_fd_sc_hd__clkbuf_1
XFILLER_0_41_474 VGND VGND VPWR VPWR sky130_fd_sc_hd__decap_8
X_4437_ _1475_ _1480_ _1482_ VGND VGND VPWR VPWR _1483_ sky130_fd_sc_hd__a21oi_1
X_7225_ _4130_ VGND VGND VPWR VPWR _0252_ sky130_fd_sc_hd__inv_2
XFILLER_0_13_198 VPWR VGND VPWR VGND sky130_ef_sc_hd__decap_12
X_7156_ _4123_ VGND VGND VPWR VPWR _0190_ sky130_fd_sc_hd__inv_2
X_6107_ _3106_ _3104_ VGND VGND VPWR VPWR _3114_ sky130_fd_sc_hd__nand2_1
X_4368_ _1411_ _1414_ _1274_ VGND VGND VPWR VPWR _1415_ sky130_fd_sc_hd__nand3b_1
XFILLER_0_67_70 VPWR VGND VPWR VGND sky130_ef_sc_hd__decap_12
XTAP_360 VGND VPWR sky130_fd_sc_hd__tapvpwrvgnd_1
X_4299_ _1335_ _1327_ VGND VGND VPWR VPWR _1347_ sky130_fd_sc_hd__and2b_1
XTAP_393 VGND VPWR sky130_fd_sc_hd__tapvpwrvgnd_1
XTAP_382 VGND VPWR sky130_fd_sc_hd__tapvpwrvgnd_1
XTAP_371 VGND VPWR sky130_fd_sc_hd__tapvpwrvgnd_1
X_7087_ _3715_ _3704_ _4017_ VGND VGND VPWR VPWR _4071_ sky130_fd_sc_hd__a21oi_1
X_6038_ _2977_ _2979_ VGND VGND VPWR VPWR _3046_ sky130_fd_sc_hd__nor2_1
XTAP_1515 VGND VPWR sky130_fd_sc_hd__tapvpwrvgnd_1
XTAP_1504 VGND VPWR sky130_fd_sc_hd__tapvpwrvgnd_1
XFILLER_0_95_113 VGND VGND VPWR VPWR sky130_fd_sc_hd__decap_4
XPHY_22 VGND VGND VPWR VPWR sky130_fd_sc_hd__decap_3
XPHY_11 VGND VGND VPWR VPWR sky130_fd_sc_hd__decap_3
XTAP_1548 VGND VPWR sky130_fd_sc_hd__tapvpwrvgnd_1
XTAP_1537 VGND VPWR sky130_fd_sc_hd__tapvpwrvgnd_1
XTAP_1526 VGND VPWR sky130_fd_sc_hd__tapvpwrvgnd_1
XPHY_33 VGND VGND VPWR VPWR sky130_fd_sc_hd__decap_3
XPHY_44 VGND VGND VPWR VPWR sky130_fd_sc_hd__decap_3
XPHY_55 VGND VGND VPWR VPWR sky130_fd_sc_hd__decap_3
X_7989_ _0836_ _0837_ _0828_ _0834_ VGND VGND VPWR VPWR _0838_ sky130_fd_sc_hd__o211a_2
XTAP_1559 VGND VPWR sky130_fd_sc_hd__tapvpwrvgnd_1
XFILLER_0_76_360 VGND VGND VPWR VPWR sky130_fd_sc_hd__decap_4
XPHY_66 VGND VGND VPWR VPWR sky130_fd_sc_hd__decap_3
XPHY_77 VGND VGND VPWR VPWR sky130_fd_sc_hd__decap_3
XPHY_88 VGND VGND VPWR VPWR sky130_fd_sc_hd__decap_3
XFILLER_0_9_671 VGND VGND VPWR VPWR sky130_fd_sc_hd__fill_1
XPHY_99 VGND VGND VPWR VPWR sky130_fd_sc_hd__decap_3
XFILLER_0_121_137 VPWR VGND VPWR VGND sky130_ef_sc_hd__decap_12
XFILLER_0_32_463 VPWR VGND VPWR VGND sky130_ef_sc_hd__decap_12
XFILLER_0_102_351 VPWR VGND VPWR VGND sky130_ef_sc_hd__decap_12
XFILLER_0_32_496 VPWR VGND VPWR VGND sky130_ef_sc_hd__decap_12
XFILLER_0_59_349 VGND VGND VPWR VPWR sky130_fd_sc_hd__decap_8
XFILLER_0_95_680 VGND VGND VPWR VPWR sky130_fd_sc_hd__decap_8
XFILLER_0_28_725 VGND VGND VPWR VPWR sky130_fd_sc_hd__decap_8
XFILLER_0_67_393 VPWR VGND VPWR VGND sky130_ef_sc_hd__decap_12
XFILLER_0_55_577 VGND VGND VPWR VPWR sky130_fd_sc_hd__fill_1
XFILLER_0_70_536 VGND VGND VPWR VPWR sky130_fd_sc_hd__decap_8
XFILLER_0_27_279 VGND VGND VPWR VPWR sky130_fd_sc_hd__fill_1
XFILLER_0_112_104 VGND VGND VPWR VPWR sky130_fd_sc_hd__decap_3
XFILLER_0_112_126 VGND VGND VPWR VPWR sky130_fd_sc_hd__decap_8
XFILLER_0_106_690 VGND VGND VPWR VPWR sky130_fd_sc_hd__decap_8
X_5340_ _2363_ _2365_ VGND VGND VPWR VPWR _2366_ sky130_fd_sc_hd__nand2_1
X_5271_ _2229_ _2297_ VGND VGND VPWR VPWR _2298_ sky130_fd_sc_hd__nand2_1
X_4222_ _1238_ _1223_ _1269_ VGND VGND VPWR VPWR _1270_ sky130_fd_sc_hd__a21o_1
XFILLER_0_11_669 VGND VGND VPWR VPWR sky130_fd_sc_hd__decap_3
X_7010_ _3834_ _3836_ _3844_ _3849_ VGND VGND VPWR VPWR _3996_ sky130_fd_sc_hd__o31a_1
XFILLER_0_37_51 VGND VGND VPWR VPWR sky130_fd_sc_hd__decap_4
X_7912_ _0740_ _0735_ _0739_ _0745_ _0754_ VGND VGND VPWR VPWR _0761_ sky130_fd_sc_hd__a32oi_2
XFILLER_0_77_113 VPWR VGND VPWR VGND sky130_ef_sc_hd__decap_12
X_7843_ sum3\[13\] carry3\[12\] net275 VGND VGND VPWR VPWR _0707_ sky130_fd_sc_hd__a21o_1
X_4986_ _1990_ _2016_ _1946_ VGND VGND VPWR VPWR _2019_ sky130_fd_sc_hd__a21bo_1
XFILLER_0_93_628 VGND VGND VPWR VPWR sky130_fd_sc_hd__fill_2
XFILLER_0_93_617 VGND VGND VPWR VPWR sky130_fd_sc_hd__decap_6
X_7774_ carry2\[3\] net317 _0672_ VGND VGND VPWR VPWR _0024_ sky130_fd_sc_hd__o21a_1
X_6725_ sh4\[1\] VGND VGND VPWR VPWR _3715_ sky130_fd_sc_hd__clkbuf_4
XFILLER_0_46_533 VGND VGND VPWR VPWR sky130_fd_sc_hd__decap_3
XFILLER_0_18_246 VGND VGND VPWR VPWR sky130_fd_sc_hd__decap_6
XFILLER_0_18_257 VGND VGND VPWR VPWR sky130_fd_sc_hd__fill_2
X_6656_ _3650_ VGND VGND VPWR VPWR _3651_ sky130_fd_sc_hd__inv_2
X_6587_ _3579_ _3580_ _3582_ VGND VGND VPWR VPWR _3583_ sky130_fd_sc_hd__a21oi_1
X_5607_ _2484_ _2473_ VGND VGND VPWR VPWR _2625_ sky130_fd_sc_hd__nand2_1
XFILLER_0_103_148 VGND VGND VPWR VPWR sky130_fd_sc_hd__decap_3
XFILLER_0_103_126 VGND VGND VPWR VPWR sky130_fd_sc_hd__fill_1
X_8326_ _1162_ _1163_ VGND VGND VPWR VPWR _1164_ sky130_fd_sc_hd__or2_1
X_5538_ _2554_ _2556_ sh4\[0\] VGND VGND VPWR VPWR _2557_ sky130_fd_sc_hd__o21bai_2
X_8257_ _1068_ _1061_ VGND VGND VPWR VPWR _1101_ sky130_fd_sc_hd__nand2_1
X_7208_ _4128_ VGND VGND VPWR VPWR _0237_ sky130_fd_sc_hd__inv_2
X_5469_ sh6\[0\] VGND VGND VPWR VPWR _2489_ sky130_fd_sc_hd__clkbuf_4
X_8188_ _0950_ _0962_ _0946_ VGND VGND VPWR VPWR _1034_ sky130_fd_sc_hd__a21boi_1
X_7139_ net237 _4114_ VGND VGND VPWR VPWR _0054_ sky130_fd_sc_hd__xnor2_1
XFILLER_0_68_102 VGND VGND VPWR VPWR sky130_fd_sc_hd__decap_4
XTAP_1323 VGND VPWR sky130_fd_sc_hd__tapvpwrvgnd_1
XTAP_1312 VGND VPWR sky130_fd_sc_hd__tapvpwrvgnd_1
XTAP_1301 VGND VPWR sky130_fd_sc_hd__tapvpwrvgnd_1
XTAP_1356 VGND VPWR sky130_fd_sc_hd__tapvpwrvgnd_1
XTAP_1345 VGND VPWR sky130_fd_sc_hd__tapvpwrvgnd_1
XFILLER_0_83_105 VGND VGND VPWR VPWR sky130_fd_sc_hd__decap_6
XTAP_1334 VGND VPWR sky130_fd_sc_hd__tapvpwrvgnd_1
XTAP_1378 VGND VPWR sky130_fd_sc_hd__tapvpwrvgnd_1
XTAP_1389 VGND VPWR sky130_fd_sc_hd__tapvpwrvgnd_1
XTAP_1367 VGND VPWR sky130_fd_sc_hd__tapvpwrvgnd_1
XFILLER_0_83_149 VPWR VGND VPWR VGND sky130_ef_sc_hd__decap_12
XFILLER_0_49_393 VGND VGND VPWR VPWR sky130_fd_sc_hd__fill_2
XFILLER_0_119_281 VPWR VGND VPWR VGND sky130_ef_sc_hd__decap_12
XFILLER_0_37_555 VGND VGND VPWR VPWR sky130_fd_sc_hd__fill_2
XFILLER_0_9_490 VPWR VGND VPWR VGND sky130_ef_sc_hd__decap_12
XFILLER_0_24_216 VGND VGND VPWR VPWR sky130_fd_sc_hd__decap_6
XFILLER_0_107_465 VGND VGND VPWR VPWR sky130_fd_sc_hd__decap_4
XFILLER_0_91_182 VPWR VGND VPWR VGND sky130_ef_sc_hd__decap_12
XFILLER_0_122_435 VGND VGND VPWR VPWR sky130_fd_sc_hd__decap_3
XFILLER_0_103_660 VPWR VGND VPWR VGND sky130_ef_sc_hd__decap_12
XFILLER_0_102_170 VPWR VGND VPWR VGND sky130_ef_sc_hd__decap_12
XFILLER_0_20_477 VGND VGND VPWR VPWR sky130_fd_sc_hd__decap_4
XFILLER_0_20_499 VPWR VGND VPWR VGND sky130_ef_sc_hd__decap_12
XFILLER_0_99_271 VGND VGND VPWR VPWR sky130_fd_sc_hd__decap_8
XFILLER_0_59_113 VPWR VGND VPWR VGND sky130_ef_sc_hd__decap_12
XFILLER_0_90_15 VPWR VGND VPWR VGND sky130_ef_sc_hd__decap_12
X_4840_ _1875_ _1844_ _1847_ VGND VGND VPWR VPWR _1876_ sky130_fd_sc_hd__and3_1
XFILLER_0_75_617 VPWR VGND VPWR VGND sky130_ef_sc_hd__decap_12
XFILLER_0_114_66 VGND VGND VPWR VPWR sky130_fd_sc_hd__fill_2
X_4771_ _1802_ _1804_ _1807_ VGND VGND VPWR VPWR _1808_ sky130_fd_sc_hd__nand3_2
X_6510_ _3506_ _3423_ VGND VGND VPWR VPWR _3507_ sky130_fd_sc_hd__nand2_2
XFILLER_0_74_149 VPWR VGND VPWR VGND sky130_ef_sc_hd__decap_12
XFILLER_0_7_438 VGND VGND VPWR VPWR sky130_fd_sc_hd__fill_2
X_7490_ _4156_ VGND VGND VPWR VPWR _0491_ sky130_fd_sc_hd__inv_2
XFILLER_0_43_503 VGND VGND VPWR VPWR sky130_fd_sc_hd__fill_1
XFILLER_0_43_525 VGND VGND VPWR VPWR sky130_fd_sc_hd__decap_8
X_6441_ _3435_ _3436_ _3438_ VGND VGND VPWR VPWR _3439_ sky130_fd_sc_hd__nand3_4
XFILLER_0_15_238 VGND VGND VPWR VPWR sky130_fd_sc_hd__fill_1
XFILLER_0_31_709 VPWR VGND VPWR VGND sky130_ef_sc_hd__decap_12
X_6372_ _3367_ _3370_ _3302_ VGND VGND VPWR VPWR _3371_ sky130_fd_sc_hd__o21ai_2
XFILLER_0_70_377 VGND VGND VPWR VPWR sky130_fd_sc_hd__decap_8
XFILLER_0_2_121 VPWR VGND VPWR VGND sky130_ef_sc_hd__decap_12
XFILLER_0_113_457 VGND VGND VPWR VPWR sky130_fd_sc_hd__decap_8
X_8111_ _0727_ _0722_ _0953_ VGND VGND VPWR VPWR _0958_ sky130_fd_sc_hd__a21o_1
XFILLER_0_2_165 VPWR VGND VPWR VGND sky130_ef_sc_hd__decap_12
XFILLER_0_23_293 VGND VGND VPWR VPWR sky130_fd_sc_hd__fill_2
X_5323_ _2317_ _2347_ _2348_ VGND VGND VPWR VPWR _2349_ sky130_fd_sc_hd__nand3_1
XFILLER_0_11_455 VGND VGND VPWR VPWR sky130_fd_sc_hd__fill_1
XFILLER_0_121_490 VGND VGND VPWR VPWR sky130_fd_sc_hd__fill_1
X_5254_ _2280_ _2266_ _2277_ VGND VGND VPWR VPWR _2281_ sky130_fd_sc_hd__a21oi_1
X_8042_ _0886_ _0887_ _0830_ _0889_ VGND VGND VPWR VPWR _0890_ sky130_fd_sc_hd__o211ai_4
X_5185_ _2052_ sh2\[2\] sh3\[2\] VGND VGND VPWR VPWR _2213_ sky130_fd_sc_hd__o21ai_2
XFILLER_0_48_72 VPWR VGND VPWR VGND sky130_ef_sc_hd__decap_12
X_8875_ clknet_leaf_22_clk net256 _0626_ VGND VGND VPWR VPWR sh15\[7\] sky130_fd_sc_hd__dfrtp_4
XFILLER_0_78_477 VGND VGND VPWR VPWR sky130_fd_sc_hd__fill_2
X_7826_ net214 _0698_ VGND VGND VPWR VPWR _0072_ sky130_fd_sc_hd__xnor2_1
X_4969_ _1674_ _1791_ sh14\[7\] VGND VGND VPWR VPWR _2002_ sky130_fd_sc_hd__o21a_1
X_7757_ _0658_ _0659_ VGND VGND VPWR VPWR _0091_ sky130_fd_sc_hd__nand2_1
XFILLER_0_74_672 VGND VGND VPWR VPWR sky130_fd_sc_hd__fill_2
X_6708_ sh10\[1\] sh11\[1\] VGND VGND VPWR VPWR _3698_ sky130_fd_sc_hd__nor2_1
X_7688_ carry1\[2\] sum1\[3\] net284 VGND VGND VPWR VPWR _4208_ sky130_fd_sc_hd__a21o_1
X_6639_ _3629_ _3631_ _3633_ VGND VGND VPWR VPWR _3634_ sky130_fd_sc_hd__a21o_1
XFILLER_0_61_333 VGND VGND VPWR VPWR sky130_fd_sc_hd__decap_3
X_8309_ _1140_ _1143_ _1147_ VGND VGND VPWR VPWR _1148_ sky130_fd_sc_hd__a21o_1
XFILLER_0_100_674 VPWR VGND VPWR VGND sky130_ef_sc_hd__decap_12
XFILLER_0_69_444 VGND VGND VPWR VPWR sky130_fd_sc_hd__decap_4
XTAP_1131 VGND VPWR sky130_fd_sc_hd__tapvpwrvgnd_1
XTAP_1120 VGND VPWR sky130_fd_sc_hd__tapvpwrvgnd_1
XFILLER_0_57_617 VPWR VGND VPWR VGND sky130_ef_sc_hd__decap_12
XTAP_1164 VGND VPWR sky130_fd_sc_hd__tapvpwrvgnd_1
XTAP_1153 VGND VPWR sky130_fd_sc_hd__tapvpwrvgnd_1
XTAP_1142 VGND VPWR sky130_fd_sc_hd__tapvpwrvgnd_1
XFILLER_0_56_127 VGND VGND VPWR VPWR sky130_fd_sc_hd__fill_2
XTAP_1197 VGND VPWR sky130_fd_sc_hd__tapvpwrvgnd_1
XTAP_1186 VGND VPWR sky130_fd_sc_hd__tapvpwrvgnd_1
XTAP_1175 VGND VPWR sky130_fd_sc_hd__tapvpwrvgnd_1
XFILLER_0_60_29 VGND VGND VPWR VPWR sky130_fd_sc_hd__decap_8
XFILLER_0_80_653 VGND VGND VPWR VPWR sky130_fd_sc_hd__fill_2
XFILLER_0_13_709 VPWR VGND VPWR VGND sky130_ef_sc_hd__decap_12
XFILLER_0_122_221 VGND VGND VPWR VPWR sky130_fd_sc_hd__decap_8
XFILLER_0_85_15 VPWR VGND VPWR VGND sky130_ef_sc_hd__decap_12
XFILLER_0_0_669 VGND VGND VPWR VPWR sky130_fd_sc_hd__decap_3
XTAP_904 VGND VPWR sky130_fd_sc_hd__tapvpwrvgnd_1
XTAP_915 VGND VPWR sky130_fd_sc_hd__tapvpwrvgnd_1
XTAP_926 VGND VPWR sky130_fd_sc_hd__tapvpwrvgnd_1
XTAP_948 VGND VPWR sky130_fd_sc_hd__tapvpwrvgnd_1
XTAP_959 VGND VPWR sky130_fd_sc_hd__tapvpwrvgnd_1
XTAP_937 VGND VPWR sky130_fd_sc_hd__tapvpwrvgnd_1
XFILLER_0_109_33 VGND VGND VPWR VPWR sky130_fd_sc_hd__fill_1
X_6990_ _3969_ _3973_ _3974_ _3975_ VGND VGND VPWR VPWR _3976_ sky130_fd_sc_hd__o211ai_4
X_5941_ sh0\[6\] sh3\[6\] VGND VGND VPWR VPWR _2950_ sky130_fd_sc_hd__and2_2
XFILLER_0_34_41 VPWR VGND VPWR VGND sky130_ef_sc_hd__decap_12
X_5872_ _2881_ VGND VGND VPWR VPWR _2882_ sky130_fd_sc_hd__buf_4
X_8660_ clknet_leaf_23_clk net85 _0411_ VGND VGND VPWR VPWR s7\[7\] sky130_fd_sc_hd__dfrtp_1
XFILLER_0_87_285 VGND VGND VPWR VPWR sky130_fd_sc_hd__fill_1
XFILLER_0_34_85 VPWR VGND VPWR VGND sky130_ef_sc_hd__decap_12
XFILLER_0_47_127 VGND VGND VPWR VPWR sky130_fd_sc_hd__fill_1
XFILLER_0_48_639 VGND VGND VPWR VPWR sky130_fd_sc_hd__decap_4
X_4823_ _1768_ _1858_ VGND VGND VPWR VPWR _1859_ sky130_fd_sc_hd__nand2_1
X_7611_ _4168_ VGND VGND VPWR VPWR _0600_ sky130_fd_sc_hd__inv_2
XFILLER_0_8_725 VGND VGND VPWR VPWR sky130_fd_sc_hd__decap_8
X_8591_ clknet_leaf_35_clk _0053_ _0342_ VGND VGND VPWR VPWR sum1\[3\] sky130_fd_sc_hd__dfrtp_1
X_7542_ _4161_ VGND VGND VPWR VPWR _0538_ sky130_fd_sc_hd__inv_2
X_4754_ sh9\[7\] VGND VGND VPWR VPWR _1791_ sky130_fd_sc_hd__clkbuf_4
XFILLER_0_90_428 VPWR VGND VPWR VGND sky130_ef_sc_hd__decap_12
XFILLER_0_16_525 VGND VGND VPWR VPWR sky130_fd_sc_hd__decap_6
XFILLER_0_28_363 VGND VGND VPWR VPWR sky130_fd_sc_hd__fill_1
XFILLER_0_50_40 VGND VGND VPWR VPWR sky130_fd_sc_hd__fill_1
XFILLER_0_50_51 VGND VGND VPWR VPWR sky130_fd_sc_hd__fill_1
X_7473_ _4154_ VGND VGND VPWR VPWR _0476_ sky130_fd_sc_hd__inv_2
X_4685_ _1639_ _1722_ VGND VGND VPWR VPWR _1723_ sky130_fd_sc_hd__nand2_1
XFILLER_0_70_141 VPWR VGND VPWR VGND sky130_ef_sc_hd__decap_12
XFILLER_0_101_405 VPWR VGND VPWR VGND sky130_ef_sc_hd__decap_12
X_6424_ _3420_ _3421_ _3307_ VGND VGND VPWR VPWR _3422_ sky130_fd_sc_hd__o21ba_1
XFILLER_0_101_438 VGND VGND VPWR VPWR sky130_fd_sc_hd__fill_2
X_6355_ _3348_ _3351_ _3353_ VGND VGND VPWR VPWR _3354_ sky130_fd_sc_hd__o21ai_2
XFILLER_0_3_496 VGND VGND VPWR VPWR sky130_fd_sc_hd__decap_8
X_6286_ sh11\[4\] VGND VGND VPWR VPWR _3286_ sky130_fd_sc_hd__buf_2
X_5306_ _2094_ _2090_ _2250_ VGND VGND VPWR VPWR _2332_ sky130_fd_sc_hd__o21a_1
X_8025_ _0868_ _0872_ _0814_ VGND VGND VPWR VPWR _0873_ sky130_fd_sc_hd__a21oi_2
XFILLER_0_11_296 VGND VGND VPWR VPWR sky130_fd_sc_hd__fill_1
X_5237_ _2103_ _2105_ _2255_ VGND VGND VPWR VPWR _2264_ sky130_fd_sc_hd__o21a_1
XFILLER_0_75_81 VGND VGND VPWR VPWR sky130_fd_sc_hd__fill_2
X_5168_ _2191_ _2193_ _2192_ _2162_ VGND VGND VPWR VPWR _2196_ sky130_fd_sc_hd__o31ai_2
X_5099_ _2126_ _2127_ VGND VGND VPWR VPWR _2128_ sky130_fd_sc_hd__nor2_1
XFILLER_0_94_701 VPWR VGND VPWR VGND sky130_ef_sc_hd__decap_12
XFILLER_0_39_617 VGND VGND VPWR VPWR sky130_fd_sc_hd__fill_2
XPHY_225 VGND VGND VPWR VPWR sky130_fd_sc_hd__decap_3
XPHY_214 VGND VGND VPWR VPWR sky130_fd_sc_hd__decap_3
XPHY_203 VGND VGND VPWR VPWR sky130_fd_sc_hd__decap_3
X_8858_ clknet_leaf_6_clk net28 _0609_ VGND VGND VPWR VPWR sh13\[6\] sky130_fd_sc_hd__dfrtp_1
XFILLER_0_78_296 VPWR VGND VPWR VGND sky130_ef_sc_hd__decap_12
XFILLER_0_66_436 VGND VGND VPWR VPWR sky130_fd_sc_hd__decap_4
XPHY_247 VGND VGND VPWR VPWR sky130_fd_sc_hd__decap_3
XPHY_236 VGND VGND VPWR VPWR sky130_fd_sc_hd__decap_3
XFILLER_0_109_538 VGND VGND VPWR VPWR sky130_fd_sc_hd__decap_8
X_7809_ carry2\[3\] sum2\[4\] VGND VGND VPWR VPWR _0690_ sky130_fd_sc_hd__xnor2_1
X_8789_ clknet_leaf_61_clk net434 _0540_ VGND VGND VPWR VPWR sh5\[1\] sky130_fd_sc_hd__dfrtp_4
XFILLER_0_38_138 VGND VGND VPWR VPWR sky130_fd_sc_hd__fill_2
XFILLER_0_34_322 VGND VGND VPWR VPWR sky130_fd_sc_hd__decap_6
XFILLER_0_46_193 VGND VGND VPWR VPWR sky130_fd_sc_hd__decap_3
XFILLER_0_104_221 VPWR VGND VPWR VGND sky130_ef_sc_hd__decap_12
XFILLER_0_61_163 VGND VGND VPWR VPWR sky130_fd_sc_hd__decap_4
XFILLER_0_34_377 VGND VGND VPWR VPWR sky130_fd_sc_hd__decap_3
XFILLER_0_15_591 VGND VGND VPWR VPWR sky130_fd_sc_hd__decap_8
XFILLER_0_30_561 VGND VGND VPWR VPWR sky130_fd_sc_hd__decap_8
Xhold7 sum2\[2\] VGND VGND VPWR VPWR net49 sky130_fd_sc_hd__dlygate4sd3_1
XFILLER_0_97_572 VPWR VGND VPWR VGND sky130_ef_sc_hd__decap_12
XFILLER_0_84_200 VPWR VGND VPWR VGND sky130_ef_sc_hd__decap_12
XFILLER_0_57_447 VGND VGND VPWR VPWR sky130_fd_sc_hd__fill_1
XFILLER_0_84_288 VGND VGND VPWR VPWR sky130_fd_sc_hd__decap_4
XFILLER_0_38_672 VPWR VGND VPWR VGND sky130_ef_sc_hd__decap_12
XFILLER_0_53_620 VGND VGND VPWR VPWR sky130_fd_sc_hd__decap_3
XFILLER_0_37_193 VPWR VGND VPWR VGND sky130_ef_sc_hd__decap_12
XFILLER_0_52_141 VPWR VGND VPWR VGND sky130_ef_sc_hd__decap_12
XFILLER_0_4_238 VGND VGND VPWR VPWR sky130_fd_sc_hd__fill_2
XFILLER_0_25_366 VGND VGND VPWR VPWR sky130_fd_sc_hd__decap_4
X_4470_ _1485_ _1500_ VGND VGND VPWR VPWR _1515_ sky130_fd_sc_hd__nand2_1
Xhold407 carry3\[4\] VGND VGND VPWR VPWR net449 sky130_fd_sc_hd__dlygate4sd3_1
XFILLER_0_20_65 VPWR VGND VPWR VGND sky130_ef_sc_hd__decap_12
XFILLER_0_40_325 VGND VGND VPWR VPWR sky130_fd_sc_hd__decap_3
X_6140_ _2906_ sh8\[6\] VGND VGND VPWR VPWR _3146_ sky130_fd_sc_hd__and2b_1
XFILLER_0_96_58 VGND VGND VPWR VPWR sky130_fd_sc_hd__decap_3
XFILLER_0_0_433 VPWR VGND VPWR VGND sky130_ef_sc_hd__decap_12
XFILLER_0_21_561 VGND VGND VPWR VPWR sky130_fd_sc_hd__decap_6
XFILLER_0_21_583 VGND VGND VPWR VPWR sky130_fd_sc_hd__fill_2
XTAP_701 VGND VPWR sky130_fd_sc_hd__tapvpwrvgnd_1
XFILLER_0_0_477 VPWR VGND VPWR VGND sky130_ef_sc_hd__decap_12
XTAP_712 VGND VPWR sky130_fd_sc_hd__tapvpwrvgnd_1
XTAP_723 VGND VPWR sky130_fd_sc_hd__tapvpwrvgnd_1
XTAP_734 VGND VPWR sky130_fd_sc_hd__tapvpwrvgnd_1
X_6071_ _3076_ _3077_ VGND VGND VPWR VPWR _3078_ sky130_fd_sc_hd__nand2_1
XTAP_745 VGND VPWR sky130_fd_sc_hd__tapvpwrvgnd_1
XTAP_756 VGND VPWR sky130_fd_sc_hd__tapvpwrvgnd_1
XTAP_767 VGND VPWR sky130_fd_sc_hd__tapvpwrvgnd_1
X_5022_ sh1\[2\] VGND VGND VPWR VPWR _2052_ sky130_fd_sc_hd__clkbuf_4
XTAP_789 VGND VPWR sky130_fd_sc_hd__tapvpwrvgnd_1
XTAP_778 VGND VPWR sky130_fd_sc_hd__tapvpwrvgnd_1
XFILLER_0_76_701 VGND VGND VPWR VPWR sky130_fd_sc_hd__decap_6
X_6973_ _3949_ _3951_ _3952_ VGND VGND VPWR VPWR _3960_ sky130_fd_sc_hd__a21oi_2
X_5924_ _2899_ _2892_ _2932_ VGND VGND VPWR VPWR _2933_ sky130_fd_sc_hd__o21a_1
XFILLER_0_75_211 VGND VGND VPWR VPWR sky130_fd_sc_hd__decap_6
X_8712_ clknet_leaf_55_clk _0120_ _0463_ VGND VGND VPWR VPWR bit_sum4\[3\] sky130_fd_sc_hd__dfrtp_1
XFILLER_0_91_704 VGND VGND VPWR VPWR sky130_fd_sc_hd__decap_8
X_8643_ clknet_leaf_13_clk net153 _0394_ VGND VGND VPWR VPWR s5\[8\] sky130_fd_sc_hd__dfrtp_1
XFILLER_0_0_53 VGND VGND VPWR VPWR sky130_fd_sc_hd__decap_3
X_5855_ _2544_ VGND VGND VPWR VPWR _2866_ sky130_fd_sc_hd__inv_2
X_4806_ _1650_ _1651_ _1841_ VGND VGND VPWR VPWR _1842_ sky130_fd_sc_hd__o21ai_1
XFILLER_0_118_346 VGND VGND VPWR VPWR sky130_fd_sc_hd__fill_2
XFILLER_0_61_94 VGND VGND VPWR VPWR sky130_fd_sc_hd__decap_3
XFILLER_0_8_533 VPWR VGND VPWR VGND sky130_ef_sc_hd__decap_12
XFILLER_0_0_97 VPWR VGND VPWR VGND sky130_ef_sc_hd__decap_12
XFILLER_0_90_225 VGND VGND VPWR VPWR sky130_fd_sc_hd__fill_1
X_8574_ clknet_leaf_32_clk _0069_ _0325_ VGND VGND VPWR VPWR sum2\[9\] sky130_fd_sc_hd__dfrtp_1
X_5786_ _2800_ _2797_ _2795_ VGND VGND VPWR VPWR _2801_ sky130_fd_sc_hd__a21oi_2
X_4737_ net41 _1668_ VGND VGND VPWR VPWR _1774_ sky130_fd_sc_hd__nor2_1
X_7525_ _4160_ VGND VGND VPWR VPWR _0522_ sky130_fd_sc_hd__inv_2
XFILLER_0_9_51 VGND VGND VPWR VPWR sky130_fd_sc_hd__decap_4
X_4668_ _1643_ net40 VGND VGND VPWR VPWR _1706_ sky130_fd_sc_hd__nand2_1
XFILLER_0_71_483 VGND VGND VPWR VPWR sky130_fd_sc_hd__decap_4
X_7456_ _4153_ VGND VGND VPWR VPWR _0460_ sky130_fd_sc_hd__inv_2
XFILLER_0_16_377 VGND VGND VPWR VPWR sky130_fd_sc_hd__fill_1
XFILLER_0_31_325 VGND VGND VPWR VPWR sky130_fd_sc_hd__decap_8
X_6407_ _3364_ _3398_ _3354_ VGND VGND VPWR VPWR _3406_ sky130_fd_sc_hd__or3b_1
X_4599_ sh7\[7\] VGND VGND VPWR VPWR _1638_ sky130_fd_sc_hd__buf_4
X_7387_ _4136_ VGND VGND VPWR VPWR _4146_ sky130_fd_sc_hd__buf_4
XFILLER_0_12_583 VGND VGND VPWR VPWR sky130_fd_sc_hd__fill_1
XFILLER_0_101_279 VGND VGND VPWR VPWR sky130_fd_sc_hd__fill_1
X_6338_ sh13\[4\] VGND VGND VPWR VPWR _3337_ sky130_fd_sc_hd__inv_2
X_6269_ _3248_ _3256_ _3255_ VGND VGND VPWR VPWR _3272_ sky130_fd_sc_hd__o21a_1
X_8008_ _0855_ _0852_ _0853_ VGND VGND VPWR VPWR _0857_ sky130_fd_sc_hd__nand3_2
XFILLER_0_98_314 VGND VGND VPWR VPWR sky130_fd_sc_hd__decap_8
XFILLER_0_79_561 VGND VGND VPWR VPWR sky130_fd_sc_hd__decap_8
XFILLER_0_79_550 VGND VGND VPWR VPWR sky130_fd_sc_hd__decap_6
XFILLER_0_67_701 VPWR VGND VPWR VGND sky130_ef_sc_hd__decap_12
XFILLER_0_66_211 VGND VGND VPWR VPWR sky130_fd_sc_hd__fill_1
XFILLER_0_94_564 VPWR VGND VPWR VGND sky130_ef_sc_hd__decap_12
XFILLER_0_94_553 VGND VGND VPWR VPWR sky130_fd_sc_hd__fill_1
XFILLER_0_94_531 VGND VGND VPWR VPWR sky130_fd_sc_hd__fill_1
XFILLER_0_39_458 VGND VGND VPWR VPWR sky130_fd_sc_hd__decap_6
XFILLER_0_94_586 VGND VGND VPWR VPWR sky130_fd_sc_hd__fill_2
XFILLER_0_66_288 VGND VGND VPWR VPWR sky130_fd_sc_hd__decap_6
XFILLER_0_62_483 VGND VGND VPWR VPWR sky130_fd_sc_hd__fill_1
XFILLER_0_34_174 VPWR VGND VPWR VGND sky130_ef_sc_hd__decap_12
XFILLER_0_35_697 VPWR VGND VPWR VGND sky130_ef_sc_hd__decap_12
XFILLER_0_10_509 VPWR VGND VPWR VGND sky130_ef_sc_hd__decap_12
XFILLER_0_22_336 VPWR VGND VPWR VGND sky130_ef_sc_hd__decap_12
XFILLER_0_50_645 VGND VGND VPWR VPWR sky130_fd_sc_hd__decap_8
XFILLER_0_89_303 VGND VGND VPWR VPWR sky130_fd_sc_hd__fill_1
XFILLER_0_82_27 VGND VGND VPWR VPWR sky130_fd_sc_hd__fill_1
XFILLER_0_58_701 VGND VGND VPWR VPWR sky130_fd_sc_hd__decap_4
XFILLER_0_85_520 VPWR VGND VPWR VGND sky130_ef_sc_hd__decap_12
XFILLER_0_73_726 VGND VGND VPWR VPWR sky130_fd_sc_hd__fill_2
X_5640_ _2656_ _2657_ _2648_ net453 VGND VGND VPWR VPWR _2658_ sky130_fd_sc_hd__o211ai_1
XFILLER_0_122_77 VGND VGND VPWR VPWR sky130_fd_sc_hd__decap_6
XFILLER_0_115_316 VGND VGND VPWR VPWR sky130_fd_sc_hd__decap_6
X_5571_ _2517_ _2528_ _2588_ _2589_ VGND VGND VPWR VPWR _2590_ sky130_fd_sc_hd__nand4_1
X_4522_ _1564_ _1558_ _1562_ VGND VGND VPWR VPWR _1566_ sky130_fd_sc_hd__nand3_2
XFILLER_0_80_280 VPWR VGND VPWR VGND sky130_ef_sc_hd__decap_12
X_8290_ _1124_ _1131_ _1129_ VGND VGND VPWR VPWR _1133_ sky130_fd_sc_hd__a21oi_1
X_7310_ _4136_ VGND VGND VPWR VPWR _4139_ sky130_fd_sc_hd__buf_4
X_4453_ _1493_ _1496_ _1497_ VGND VGND VPWR VPWR _1498_ sky130_fd_sc_hd__nand3_2
X_7241_ _4131_ VGND VGND VPWR VPWR _0267_ sky130_fd_sc_hd__inv_2
Xhold226 s3\[9\] VGND VGND VPWR VPWR net268 sky130_fd_sc_hd__dlygate4sd3_1
XFILLER_0_40_122 VGND VGND VPWR VPWR sky130_fd_sc_hd__decap_8
Xhold215 s2\[3\] VGND VGND VPWR VPWR net257 sky130_fd_sc_hd__buf_1
Xhold204 _4217_ VGND VGND VPWR VPWR net246 sky130_fd_sc_hd__dlygate4sd3_1
XFILLER_0_123_393 VPWR VGND VPWR VGND sky130_ef_sc_hd__decap_12
Xhold259 s5\[12\] VGND VGND VPWR VPWR net301 sky130_fd_sc_hd__dlygate4sd3_1
Xhold237 sh9\[0\] VGND VGND VPWR VPWR net279 sky130_fd_sc_hd__dlygate4sd3_1
Xhold248 s1\[10\] VGND VGND VPWR VPWR net290 sky130_fd_sc_hd__dlygate4sd3_1
XFILLER_0_111_588 VGND VGND VPWR VPWR sky130_fd_sc_hd__decap_4
X_4384_ _1277_ _1278_ _1384_ VGND VGND VPWR VPWR _1430_ sky130_fd_sc_hd__o21a_1
X_7172_ _4124_ VGND VGND VPWR VPWR _0205_ sky130_fd_sc_hd__inv_2
XFILLER_0_21_391 VGND VGND VPWR VPWR sky130_fd_sc_hd__fill_1
X_6123_ _3116_ _3119_ _3121_ VGND VGND VPWR VPWR _3130_ sky130_fd_sc_hd__a21o_1
XTAP_531 VGND VPWR sky130_fd_sc_hd__tapvpwrvgnd_1
XTAP_520 VGND VPWR sky130_fd_sc_hd__tapvpwrvgnd_1
XTAP_542 VGND VPWR sky130_fd_sc_hd__tapvpwrvgnd_1
X_6054_ _2988_ _2991_ _2984_ VGND VGND VPWR VPWR _3062_ sky130_fd_sc_hd__a21oi_2
XTAP_553 VGND VPWR sky130_fd_sc_hd__tapvpwrvgnd_1
XTAP_564 VGND VPWR sky130_fd_sc_hd__tapvpwrvgnd_1
XTAP_575 VGND VPWR sky130_fd_sc_hd__tapvpwrvgnd_1
X_5005_ _1763_ _2035_ VGND VGND VPWR VPWR _2036_ sky130_fd_sc_hd__nand2_1
XTAP_586 VGND VPWR sky130_fd_sc_hd__tapvpwrvgnd_1
XTAP_597 VGND VPWR sky130_fd_sc_hd__tapvpwrvgnd_1
XFILLER_0_22_3 VPWR VGND VPWR VGND sky130_ef_sc_hd__decap_12
XTAP_1719 VGND VPWR sky130_fd_sc_hd__tapvpwrvgnd_1
XTAP_1708 VGND VPWR sky130_fd_sc_hd__tapvpwrvgnd_1
X_6956_ _3937_ _3938_ _3942_ VGND VGND VPWR VPWR _3943_ sky130_fd_sc_hd__nand3_4
XFILLER_0_48_200 VPWR VGND VPWR VGND sky130_ef_sc_hd__decap_12
XFILLER_0_119_611 VGND VGND VPWR VPWR sky130_fd_sc_hd__decap_4
X_5907_ _2879_ _2911_ net37 VGND VGND VPWR VPWR _2916_ sky130_fd_sc_hd__o21ai_2
XFILLER_0_76_531 VGND VGND VPWR VPWR sky130_fd_sc_hd__fill_1
X_6887_ _3749_ _3779_ VGND VGND VPWR VPWR _3875_ sky130_fd_sc_hd__nand2_1
XFILLER_0_119_666 VGND VGND VPWR VPWR sky130_fd_sc_hd__decap_6
XFILLER_0_63_225 VGND VGND VPWR VPWR sky130_fd_sc_hd__decap_3
X_8626_ clknet_leaf_55_clk net55 _0377_ VGND VGND VPWR VPWR s3\[9\] sky130_fd_sc_hd__dfrtp_1
XFILLER_0_8_363 VGND VGND VPWR VPWR sky130_fd_sc_hd__fill_1
XFILLER_0_8_341 VGND VGND VPWR VPWR sky130_fd_sc_hd__decap_4
X_5838_ _2816_ _2847_ _2768_ VGND VGND VPWR VPWR _2851_ sky130_fd_sc_hd__and3_1
XFILLER_0_118_176 VGND VGND VPWR VPWR sky130_fd_sc_hd__decap_4
X_8557_ clknet_leaf_26_clk _0087_ _0308_ VGND VGND VPWR VPWR sum4\[7\] sky130_fd_sc_hd__dfrtp_1
X_5769_ _2777_ _2782_ _2783_ VGND VGND VPWR VPWR _2784_ sky130_fd_sc_hd__nand3b_2
XFILLER_0_16_141 VPWR VGND VPWR VGND sky130_ef_sc_hd__decap_12
XFILLER_0_106_349 VPWR VGND VPWR VGND sky130_ef_sc_hd__decap_12
X_7508_ _4157_ VGND VGND VPWR VPWR _0508_ sky130_fd_sc_hd__inv_2
XFILLER_0_17_697 VPWR VGND VPWR VGND sky130_ef_sc_hd__decap_12
XFILLER_0_114_360 VGND VGND VPWR VPWR sky130_fd_sc_hd__decap_4
X_8488_ clknet_leaf_24_clk net128 _0239_ VGND VGND VPWR VPWR net11 sky130_fd_sc_hd__dfrtp_1
XFILLER_0_31_111 VGND VGND VPWR VPWR sky130_fd_sc_hd__fill_1
XFILLER_0_32_645 VGND VGND VPWR VPWR sky130_fd_sc_hd__fill_1
XFILLER_0_102_533 VPWR VGND VPWR VGND sky130_ef_sc_hd__decap_12
X_7439_ _4151_ VGND VGND VPWR VPWR _0445_ sky130_fd_sc_hd__inv_2
XFILLER_0_98_133 VGND VGND VPWR VPWR sky130_fd_sc_hd__decap_6
XFILLER_0_79_391 VGND VGND VPWR VPWR sky130_fd_sc_hd__fill_1
XFILLER_0_67_575 VGND VGND VPWR VPWR sky130_fd_sc_hd__decap_8
XFILLER_0_77_27 VPWR VGND VPWR VGND sky130_ef_sc_hd__decap_12
XFILLER_0_50_464 VGND VGND VPWR VPWR sky130_fd_sc_hd__decap_4
XFILLER_0_120_363 VGND VGND VPWR VPWR sky130_fd_sc_hd__fill_1
XFILLER_0_93_15 VPWR VGND VPWR VGND sky130_ef_sc_hd__decap_12
XFILLER_0_117_55 VGND VGND VPWR VPWR sky130_fd_sc_hd__fill_1
XFILLER_0_89_177 VGND VGND VPWR VPWR sky130_fd_sc_hd__decap_3
X_6810_ _3797_ _3798_ _3728_ VGND VGND VPWR VPWR _3799_ sky130_fd_sc_hd__o21ai_1
X_7790_ carry2\[11\] net430 _0680_ VGND VGND VPWR VPWR _0022_ sky130_fd_sc_hd__o21a_1
XFILLER_0_9_105 VGND VGND VPWR VPWR sky130_fd_sc_hd__decap_6
XFILLER_0_73_501 VGND VGND VPWR VPWR sky130_fd_sc_hd__decap_3
XFILLER_0_9_149 VPWR VGND VPWR VGND sky130_ef_sc_hd__decap_12
X_6741_ _3705_ _3706_ _3727_ _3729_ VGND VGND VPWR VPWR _3731_ sky130_fd_sc_hd__a2bb2o_1
XFILLER_0_42_41 VPWR VGND VPWR VGND sky130_ef_sc_hd__decap_12
X_6672_ _3656_ _3658_ _3662_ _3665_ VGND VGND VPWR VPWR _3666_ sky130_fd_sc_hd__o211ai_4
XFILLER_0_18_439 VGND VGND VPWR VPWR sky130_fd_sc_hd__fill_1
XFILLER_0_42_85 VPWR VGND VPWR VGND sky130_ef_sc_hd__decap_12
XFILLER_0_45_225 VPWR VGND VPWR VGND sky130_ef_sc_hd__decap_12
X_8411_ _1237_ _1238_ _1240_ VGND VGND VPWR VPWR _1241_ sky130_fd_sc_hd__a21o_1
XFILLER_0_115_113 VGND VGND VPWR VPWR sky130_fd_sc_hd__decap_4
X_5623_ _2631_ _2636_ _2637_ VGND VGND VPWR VPWR _2641_ sky130_fd_sc_hd__a21oi_2
XFILLER_0_45_269 VGND VGND VPWR VPWR sky130_fd_sc_hd__decap_8
X_8342_ sum5\[11\] s7\[11\] VGND VGND VPWR VPWR _1178_ sky130_fd_sc_hd__and2_1
XFILLER_0_60_217 VGND VGND VPWR VPWR sky130_fd_sc_hd__decap_8
XFILLER_0_14_601 VGND VGND VPWR VPWR sky130_fd_sc_hd__decap_4
X_5554_ _2508_ _2572_ _2509_ VGND VGND VPWR VPWR _2573_ sky130_fd_sc_hd__nand3_1
XFILLER_0_14_645 VPWR VGND VPWR VGND sky130_ef_sc_hd__decap_12
X_4505_ _1243_ _1223_ _1246_ VGND VGND VPWR VPWR _1549_ sky130_fd_sc_hd__o21ai_4
X_8273_ _1085_ _1082_ _1113_ _1114_ VGND VGND VPWR VPWR _1117_ sky130_fd_sc_hd__o211ai_4
X_5485_ _2503_ _2504_ VGND VGND VPWR VPWR _2505_ sky130_fd_sc_hd__and2b_1
X_4436_ _1475_ _1479_ _1481_ VGND VGND VPWR VPWR _1482_ sky130_fd_sc_hd__a21oi_1
X_7224_ _4130_ VGND VGND VPWR VPWR _0251_ sky130_fd_sc_hd__inv_2
XFILLER_0_6_41 VPWR VGND VPWR VGND sky130_ef_sc_hd__decap_12
XFILLER_0_1_561 VPWR VGND VPWR VGND sky130_ef_sc_hd__decap_12
X_4367_ _1409_ _1410_ _1407_ VGND VGND VPWR VPWR _1414_ sky130_fd_sc_hd__nand3_1
X_7155_ _4123_ VGND VGND VPWR VPWR _0189_ sky130_fd_sc_hd__inv_2
X_6106_ _3105_ _3108_ _3112_ VGND VGND VPWR VPWR _3113_ sky130_fd_sc_hd__a21o_1
XFILLER_0_67_82 VPWR VGND VPWR VGND sky130_ef_sc_hd__decap_12
XTAP_350 VGND VPWR sky130_fd_sc_hd__tapvpwrvgnd_1
XFILLER_0_6_85 VPWR VGND VPWR VGND sky130_ef_sc_hd__decap_12
X_4298_ _1327_ _1334_ VGND VGND VPWR VPWR _1346_ sky130_fd_sc_hd__nand2_1
XTAP_394 VGND VPWR sky130_fd_sc_hd__tapvpwrvgnd_1
XTAP_383 VGND VPWR sky130_fd_sc_hd__tapvpwrvgnd_1
XTAP_372 VGND VPWR sky130_fd_sc_hd__tapvpwrvgnd_1
XTAP_361 VGND VPWR sky130_fd_sc_hd__tapvpwrvgnd_1
X_7086_ _4032_ _4067_ _4068_ _4037_ _4025_ VGND VGND VPWR VPWR _4070_ sky130_fd_sc_hd__a32o_2
X_6037_ _3025_ _3029_ _3044_ VGND VGND VPWR VPWR _3045_ sky130_fd_sc_hd__a21oi_2
XTAP_1505 VGND VPWR sky130_fd_sc_hd__tapvpwrvgnd_1
XFILLER_0_83_81 VPWR VGND VPWR VGND sky130_ef_sc_hd__decap_12
XFILLER_0_68_317 VGND VGND VPWR VPWR sky130_fd_sc_hd__decap_3
XFILLER_0_68_306 VGND VGND VPWR VPWR sky130_fd_sc_hd__fill_2
XPHY_12 VGND VGND VPWR VPWR sky130_fd_sc_hd__decap_3
XTAP_1538 VGND VPWR sky130_fd_sc_hd__tapvpwrvgnd_1
XTAP_1527 VGND VPWR sky130_fd_sc_hd__tapvpwrvgnd_1
XTAP_1516 VGND VPWR sky130_fd_sc_hd__tapvpwrvgnd_1
XPHY_23 VGND VGND VPWR VPWR sky130_fd_sc_hd__decap_3
XPHY_34 VGND VGND VPWR VPWR sky130_fd_sc_hd__decap_3
XPHY_45 VGND VGND VPWR VPWR sky130_fd_sc_hd__decap_3
XPHY_56 VGND VGND VPWR VPWR sky130_fd_sc_hd__decap_3
X_7988_ _0818_ _0832_ VGND VGND VPWR VPWR _0837_ sky130_fd_sc_hd__nand2_1
XTAP_1549 VGND VPWR sky130_fd_sc_hd__tapvpwrvgnd_1
XFILLER_0_76_350 VGND VGND VPWR VPWR sky130_fd_sc_hd__fill_1
X_6939_ _3920_ _3923_ _3925_ VGND VGND VPWR VPWR _3926_ sky130_fd_sc_hd__a21oi_2
XPHY_67 VGND VGND VPWR VPWR sky130_fd_sc_hd__decap_3
XFILLER_0_37_726 VGND VGND VPWR VPWR sky130_fd_sc_hd__fill_2
XPHY_78 VGND VGND VPWR VPWR sky130_fd_sc_hd__decap_3
XPHY_89 VGND VGND VPWR VPWR sky130_fd_sc_hd__decap_3
XFILLER_0_119_496 VGND VGND VPWR VPWR sky130_fd_sc_hd__decap_8
X_8609_ clknet_leaf_56_clk net72 _0360_ VGND VGND VPWR VPWR s1\[10\] sky130_fd_sc_hd__dfrtp_1
XFILLER_0_107_658 VGND VGND VPWR VPWR sky130_fd_sc_hd__decap_8
XFILLER_0_91_386 VGND VGND VPWR VPWR sky130_fd_sc_hd__decap_6
XFILLER_0_64_589 VGND VGND VPWR VPWR sky130_fd_sc_hd__decap_6
XFILLER_0_17_461 VGND VGND VPWR VPWR sky130_fd_sc_hd__fill_2
XFILLER_0_121_105 VGND VGND VPWR VPWR sky130_fd_sc_hd__decap_6
XFILLER_0_121_149 VPWR VGND VPWR VGND sky130_ef_sc_hd__decap_12
XFILLER_0_20_615 VGND VGND VPWR VPWR sky130_fd_sc_hd__fill_2
XFILLER_0_32_475 VGND VGND VPWR VPWR sky130_fd_sc_hd__fill_1
XFILLER_0_102_363 VGND VGND VPWR VPWR sky130_fd_sc_hd__fill_1
XFILLER_0_20_637 VGND VGND VPWR VPWR sky130_fd_sc_hd__decap_6
XFILLER_0_63_29 VGND VGND VPWR VPWR sky130_fd_sc_hd__decap_6
XFILLER_0_27_214 VGND VGND VPWR VPWR sky130_fd_sc_hd__decap_8
XFILLER_0_27_225 VPWR VGND VPWR VGND sky130_ef_sc_hd__decap_12
XFILLER_0_103_57 VGND VGND VPWR VPWR sky130_fd_sc_hd__decap_4
XFILLER_0_70_504 VGND VGND VPWR VPWR sky130_fd_sc_hd__decap_8
XFILLER_0_82_397 VGND VGND VPWR VPWR sky130_fd_sc_hd__fill_2
XFILLER_0_82_375 VPWR VGND VPWR VGND sky130_ef_sc_hd__decap_12
XFILLER_0_12_66 VPWR VGND VPWR VGND sky130_ef_sc_hd__decap_12
XFILLER_0_113_617 VGND VGND VPWR VPWR sky130_fd_sc_hd__decap_8
XFILLER_0_88_15 VPWR VGND VPWR VGND sky130_ef_sc_hd__decap_12
XFILLER_0_23_431 VPWR VGND VPWR VGND sky130_ef_sc_hd__decap_12
XFILLER_0_42_239 VPWR VGND VPWR VGND sky130_ef_sc_hd__decap_12
XFILLER_0_11_615 VGND VGND VPWR VPWR sky130_fd_sc_hd__fill_1
XFILLER_0_50_261 VGND VGND VPWR VPWR sky130_fd_sc_hd__decap_3
XFILLER_0_11_637 VPWR VGND VPWR VGND sky130_ef_sc_hd__decap_12
X_5270_ _2233_ _2163_ VGND VGND VPWR VPWR _2297_ sky130_fd_sc_hd__nand2_1
X_4221_ _1239_ _1268_ _1246_ VGND VGND VPWR VPWR _1269_ sky130_fd_sc_hd__o21ai_4
X_7911_ net173 _0760_ VGND VGND VPWR VPWR _0100_ sky130_fd_sc_hd__xnor2_1
X_7842_ sum3\[12\] net422 _0706_ VGND VGND VPWR VPWR _0032_ sky130_fd_sc_hd__o21a_1
XFILLER_0_77_125 VPWR VGND VPWR VGND sky130_ef_sc_hd__decap_12
X_4985_ _1994_ _1997_ _2015_ _2017_ VGND VGND VPWR VPWR _2018_ sky130_fd_sc_hd__o2bb2ai_1
X_7773_ carry2\[3\] net317 net220 VGND VGND VPWR VPWR _0672_ sky130_fd_sc_hd__a21o_1
XFILLER_0_92_139 VGND VGND VPWR VPWR sky130_fd_sc_hd__fill_1
X_6724_ _3709_ _3710_ _3713_ VGND VGND VPWR VPWR _3714_ sky130_fd_sc_hd__nand3b_2
X_6655_ _3646_ _3649_ _3599_ _3644_ VGND VGND VPWR VPWR _3650_ sky130_fd_sc_hd__o211ai_2
XFILLER_0_46_589 VPWR VGND VPWR VGND sky130_ef_sc_hd__decap_12
X_6586_ _3519_ _3514_ _3503_ VGND VGND VPWR VPWR _3582_ sky130_fd_sc_hd__a21o_1
XFILLER_0_61_559 VGND VGND VPWR VPWR sky130_fd_sc_hd__fill_1
X_5606_ sh1\[0\] _2506_ _2482_ VGND VGND VPWR VPWR _2624_ sky130_fd_sc_hd__o21a_1
X_8325_ _1148_ _1152_ _1149_ VGND VGND VPWR VPWR _1163_ sky130_fd_sc_hd__a21bo_1
X_5537_ _2479_ _2482_ VGND VGND VPWR VPWR _2556_ sky130_fd_sc_hd__nor2_1
X_8256_ sh13\[3\] _0892_ _1053_ VGND VGND VPWR VPWR _1100_ sky130_fd_sc_hd__a21oi_2
XFILLER_0_41_261 VPWR VGND VPWR VGND sky130_ef_sc_hd__decap_12
X_7207_ _4128_ VGND VGND VPWR VPWR _0236_ sky130_fd_sc_hd__inv_2
X_5468_ _2483_ _2486_ _2487_ VGND VGND VPWR VPWR _2488_ sky130_fd_sc_hd__nand3_2
X_4419_ _1451_ _1453_ _1463_ _1464_ VGND VGND VPWR VPWR _1465_ sky130_fd_sc_hd__o211a_1
X_8187_ _1031_ _1022_ _1026_ VGND VGND VPWR VPWR _1033_ sky130_fd_sc_hd__nand3_1
XFILLER_0_10_681 VPWR VGND VPWR VGND sky130_ef_sc_hd__decap_12
X_5399_ _2418_ _2419_ VGND VGND VPWR VPWR _2424_ sky130_fd_sc_hd__and2_1
X_7138_ net448 s1\[4\] VGND VGND VPWR VPWR _4114_ sky130_fd_sc_hd__xnor2_1
X_7069_ _4050_ _4053_ _3986_ VGND VGND VPWR VPWR _4054_ sky130_fd_sc_hd__o21ai_4
XTAP_1313 VGND VPWR sky130_fd_sc_hd__tapvpwrvgnd_1
XTAP_1302 VGND VPWR sky130_fd_sc_hd__tapvpwrvgnd_1
XFILLER_0_68_136 VGND VGND VPWR VPWR sky130_fd_sc_hd__decap_4
XFILLER_0_96_467 VGND VGND VPWR VPWR sky130_fd_sc_hd__fill_1
XTAP_1357 VGND VPWR sky130_fd_sc_hd__tapvpwrvgnd_1
XTAP_1346 VGND VPWR sky130_fd_sc_hd__tapvpwrvgnd_1
XTAP_1335 VGND VPWR sky130_fd_sc_hd__tapvpwrvgnd_1
XTAP_1324 VGND VPWR sky130_fd_sc_hd__tapvpwrvgnd_1
XFILLER_0_56_309 VGND VGND VPWR VPWR sky130_fd_sc_hd__decap_6
XTAP_1368 VGND VPWR sky130_fd_sc_hd__tapvpwrvgnd_1
XTAP_1379 VGND VPWR sky130_fd_sc_hd__tapvpwrvgnd_1
XFILLER_0_119_293 VGND VGND VPWR VPWR sky130_fd_sc_hd__decap_3
XFILLER_0_52_526 VGND VGND VPWR VPWR sky130_fd_sc_hd__fill_2
XFILLER_0_122_414 VGND VGND VPWR VPWR sky130_fd_sc_hd__decap_6
XFILLER_0_107_477 VGND VGND VPWR VPWR sky130_fd_sc_hd__decap_8
XFILLER_0_91_194 VGND VGND VPWR VPWR sky130_fd_sc_hd__fill_1
XFILLER_0_102_182 VGND VGND VPWR VPWR sky130_fd_sc_hd__fill_1
XFILLER_0_90_27 VGND VGND VPWR VPWR sky130_fd_sc_hd__fill_1
XFILLER_0_59_125 VPWR VGND VPWR VGND sky130_ef_sc_hd__decap_12
XFILLER_0_75_629 VGND VGND VPWR VPWR sky130_fd_sc_hd__decap_4
XFILLER_0_75_607 VGND VGND VPWR VPWR sky130_fd_sc_hd__decap_8
XFILLER_0_59_169 VGND VGND VPWR VPWR sky130_fd_sc_hd__decap_3
XFILLER_0_74_139 VGND VGND VPWR VPWR sky130_fd_sc_hd__fill_1
XFILLER_0_68_670 VGND VGND VPWR VPWR sky130_fd_sc_hd__decap_8
XFILLER_0_28_501 VPWR VGND VPWR VGND sky130_ef_sc_hd__decap_12
XTAP_1880 VGND VPWR sky130_fd_sc_hd__tapvpwrvgnd_1
X_4770_ _1805_ _1806_ _1799_ _1800_ VGND VGND VPWR VPWR _1807_ sky130_fd_sc_hd__nand4_1
XFILLER_0_83_662 VGND VGND VPWR VPWR sky130_fd_sc_hd__decap_8
XFILLER_0_23_65 VGND VGND VPWR VPWR sky130_fd_sc_hd__fill_1
XFILLER_0_83_673 VGND VGND VPWR VPWR sky130_fd_sc_hd__decap_3
XFILLER_0_70_301 VGND VGND VPWR VPWR sky130_fd_sc_hd__decap_6
XFILLER_0_15_217 VGND VGND VPWR VPWR sky130_fd_sc_hd__decap_6
XFILLER_0_113_403 VGND VGND VPWR VPWR sky130_fd_sc_hd__fill_1
X_6440_ _3420_ _3423_ _3437_ VGND VGND VPWR VPWR _3438_ sky130_fd_sc_hd__o21a_1
XFILLER_0_43_559 VGND VGND VPWR VPWR sky130_fd_sc_hd__fill_1
X_6371_ _3296_ _3298_ VGND VGND VPWR VPWR _3370_ sky130_fd_sc_hd__and2_2
XFILLER_0_70_389 VGND VGND VPWR VPWR sky130_fd_sc_hd__decap_6
X_8110_ _0952_ _0954_ _0956_ VGND VGND VPWR VPWR _0957_ sky130_fd_sc_hd__o21ai_4
XFILLER_0_2_133 VGND VGND VPWR VPWR sky130_fd_sc_hd__decap_6
X_5322_ _2344_ _2345_ _2339_ _2342_ VGND VGND VPWR VPWR _2348_ sky130_fd_sc_hd__a2bb2o_1
XFILLER_0_100_108 VGND VGND VPWR VPWR sky130_fd_sc_hd__decap_6
XFILLER_0_11_434 VPWR VGND VPWR VGND sky130_ef_sc_hd__decap_12
XFILLER_0_2_177 VPWR VGND VPWR VGND sky130_ef_sc_hd__decap_12
X_5253_ _2256_ _2260_ _2263_ VGND VGND VPWR VPWR _2280_ sky130_fd_sc_hd__nand3_1
X_8041_ _0887_ _0888_ _0726_ VGND VGND VPWR VPWR _0889_ sky130_fd_sc_hd__o21bai_4
X_5184_ _2208_ _2210_ _2211_ VGND VGND VPWR VPWR _2212_ sky130_fd_sc_hd__a21oi_2
XFILLER_0_64_72 VPWR VGND VPWR VGND sky130_ef_sc_hd__decap_12
X_8874_ clknet_3_3__leaf_clk sh14\[6\] _0625_ VGND VGND VPWR VPWR sh15\[6\] sky130_fd_sc_hd__dfrtp_4
X_7825_ carry2\[11\] sum2\[12\] VGND VGND VPWR VPWR _0698_ sky130_fd_sc_hd__xnor2_1
XFILLER_0_38_309 VGND VGND VPWR VPWR sky130_fd_sc_hd__fill_1
XFILLER_0_109_709 VPWR VGND VPWR VGND sky130_ef_sc_hd__decap_12
XFILLER_0_19_523 VGND VGND VPWR VPWR sky130_fd_sc_hd__fill_2
X_4968_ _1690_ _1954_ _1955_ _1970_ _1971_ VGND VGND VPWR VPWR _2001_ sky130_fd_sc_hd__o2111ai_4
X_7756_ net309 _0656_ _0657_ VGND VGND VPWR VPWR _0659_ sky130_fd_sc_hd__or3_1
X_4899_ _1931_ _1932_ _1933_ VGND VGND VPWR VPWR _1934_ sky130_fd_sc_hd__nand3_1
XFILLER_0_80_109 VPWR VGND VPWR VGND sky130_ef_sc_hd__decap_12
X_6707_ _3697_ _3325_ net359 _3410_ _3412_ VGND VGND VPWR VPWR _0118_ sky130_fd_sc_hd__a32o_1
XFILLER_0_19_578 VPWR VGND VPWR VGND sky130_ef_sc_hd__decap_12
X_7687_ _4207_ VGND VGND VPWR VPWR _0012_ sky130_fd_sc_hd__clkbuf_1
XFILLER_0_104_403 VPWR VGND VPWR VGND sky130_ef_sc_hd__decap_12
X_6638_ _3570_ _3632_ VGND VGND VPWR VPWR _3633_ sky130_fd_sc_hd__nand2_1
XFILLER_0_73_172 VGND VGND VPWR VPWR sky130_fd_sc_hd__decap_4
XFILLER_0_61_378 VGND VGND VPWR VPWR sky130_fd_sc_hd__fill_1
XFILLER_0_21_209 VGND VGND VPWR VPWR sky130_fd_sc_hd__decap_8
X_6569_ _3286_ net33 VGND VGND VPWR VPWR _3565_ sky130_fd_sc_hd__or2_1
X_8308_ _1144_ _1146_ VGND VGND VPWR VPWR _1147_ sky130_fd_sc_hd__nand2_1
XFILLER_0_14_261 VGND VGND VPWR VPWR sky130_fd_sc_hd__fill_2
XFILLER_0_100_642 VGND VGND VPWR VPWR sky130_fd_sc_hd__fill_2
X_8239_ _1082_ _1083_ VGND VGND VPWR VPWR _1084_ sky130_fd_sc_hd__nand2_1
XFILLER_0_100_686 VPWR VGND VPWR VGND sky130_ef_sc_hd__decap_12
XFILLER_0_88_209 VGND VGND VPWR VPWR sky130_fd_sc_hd__decap_3
XFILLER_0_96_253 VPWR VGND VPWR VGND sky130_ef_sc_hd__decap_12
XFILLER_0_96_242 VGND VGND VPWR VPWR sky130_fd_sc_hd__decap_8
XFILLER_0_84_404 VPWR VGND VPWR VGND sky130_ef_sc_hd__decap_12
XTAP_1121 VGND VPWR sky130_fd_sc_hd__tapvpwrvgnd_1
XTAP_1132 VGND VPWR sky130_fd_sc_hd__tapvpwrvgnd_1
XTAP_1110 VGND VPWR sky130_fd_sc_hd__tapvpwrvgnd_1
XTAP_1165 VGND VPWR sky130_fd_sc_hd__tapvpwrvgnd_1
XTAP_1154 VGND VPWR sky130_fd_sc_hd__tapvpwrvgnd_1
XTAP_1143 VGND VPWR sky130_fd_sc_hd__tapvpwrvgnd_1
XFILLER_0_57_629 VGND VGND VPWR VPWR sky130_fd_sc_hd__decap_4
XTAP_1198 VGND VPWR sky130_fd_sc_hd__tapvpwrvgnd_1
XTAP_1187 VGND VPWR sky130_fd_sc_hd__tapvpwrvgnd_1
XTAP_1176 VGND VPWR sky130_fd_sc_hd__tapvpwrvgnd_1
XFILLER_0_65_651 VPWR VGND VPWR VGND sky130_ef_sc_hd__decap_12
XFILLER_0_65_673 VPWR VGND VPWR VGND sky130_ef_sc_hd__decap_12
XFILLER_0_37_364 VGND VGND VPWR VPWR sky130_fd_sc_hd__decap_3
XFILLER_0_123_701 VPWR VGND VPWR VGND sky130_ef_sc_hd__decap_12
XFILLER_0_80_643 VGND VGND VPWR VPWR sky130_fd_sc_hd__fill_1
XFILLER_0_52_345 VGND VGND VPWR VPWR sky130_fd_sc_hd__fill_1
XFILLER_0_4_409 VGND VGND VPWR VPWR sky130_fd_sc_hd__decap_8
XFILLER_0_80_687 VPWR VGND VPWR VGND sky130_ef_sc_hd__decap_12
XFILLER_0_122_299 VGND VGND VPWR VPWR sky130_fd_sc_hd__decap_3
XFILLER_0_110_439 VGND VGND VPWR VPWR sky130_fd_sc_hd__decap_8
XFILLER_0_110_417 VGND VGND VPWR VPWR sky130_fd_sc_hd__decap_3
XFILLER_0_20_253 VGND VGND VPWR VPWR sky130_fd_sc_hd__decap_4
XTAP_905 VGND VPWR sky130_fd_sc_hd__tapvpwrvgnd_1
XTAP_916 VGND VPWR sky130_fd_sc_hd__tapvpwrvgnd_1
XFILLER_0_85_27 VPWR VGND VPWR VGND sky130_ef_sc_hd__decap_12
XTAP_949 VGND VPWR sky130_fd_sc_hd__tapvpwrvgnd_1
XTAP_938 VGND VPWR sky130_fd_sc_hd__tapvpwrvgnd_1
XFILLER_0_20_286 VGND VGND VPWR VPWR sky130_fd_sc_hd__decap_8
XTAP_927 VGND VPWR sky130_fd_sc_hd__tapvpwrvgnd_1
X_5940_ _2879_ sh3\[6\] sh4\[6\] VGND VGND VPWR VPWR _2949_ sky130_fd_sc_hd__o21ai_2
XFILLER_0_34_53 VGND VGND VPWR VPWR sky130_fd_sc_hd__fill_2
X_5871_ sh1\[6\] sh0\[6\] VGND VGND VPWR VPWR _2881_ sky130_fd_sc_hd__and2_1
X_7610_ _4168_ VGND VGND VPWR VPWR _0599_ sky130_fd_sc_hd__inv_2
XFILLER_0_34_97 VGND VGND VPWR VPWR sky130_fd_sc_hd__decap_4
X_4822_ _1649_ _1641_ VGND VGND VPWR VPWR _1858_ sky130_fd_sc_hd__nand2_1
X_8590_ clknet_leaf_36_clk _0052_ _0341_ VGND VGND VPWR VPWR sum1\[2\] sky130_fd_sc_hd__dfrtp_1
X_4753_ _1714_ _1716_ _1710_ _1783_ _1787_ VGND VGND VPWR VPWR _1790_ sky130_fd_sc_hd__o2111a_2
X_7541_ _4161_ VGND VGND VPWR VPWR _0537_ sky130_fd_sc_hd__inv_2
XFILLER_0_7_236 VGND VGND VPWR VPWR sky130_fd_sc_hd__fill_2
XFILLER_0_28_353 VGND VGND VPWR VPWR sky130_fd_sc_hd__fill_1
XFILLER_0_114_701 VPWR VGND VPWR VGND sky130_ef_sc_hd__decap_12
X_7472_ _4154_ VGND VGND VPWR VPWR _0475_ sky130_fd_sc_hd__inv_2
XFILLER_0_50_85 VGND VGND VPWR VPWR sky130_fd_sc_hd__decap_3
X_4684_ net31 VGND VGND VPWR VPWR _1722_ sky130_fd_sc_hd__clkbuf_8
X_6423_ sh4\[4\] _3306_ VGND VGND VPWR VPWR _3421_ sky130_fd_sc_hd__nor2_1
XFILLER_0_70_153 VGND VGND VPWR VPWR sky130_fd_sc_hd__decap_8
XFILLER_0_24_581 VGND VGND VPWR VPWR sky130_fd_sc_hd__decap_6
XFILLER_0_113_266 VGND VGND VPWR VPWR sky130_fd_sc_hd__decap_8
XFILLER_0_101_417 VGND VGND VPWR VPWR sky130_fd_sc_hd__decap_3
X_6354_ _3320_ _3319_ _3352_ VGND VGND VPWR VPWR _3353_ sky130_fd_sc_hd__a21oi_1
X_6285_ _2948_ _3283_ _3285_ VGND VGND VPWR VPWR _0136_ sky130_fd_sc_hd__a21oi_2
XFILLER_0_59_83 VGND VGND VPWR VPWR sky130_fd_sc_hd__fill_1
X_5305_ _2324_ _2325_ _2319_ VGND VGND VPWR VPWR _2331_ sky130_fd_sc_hd__nand3_1
X_8024_ _0869_ _0870_ _0871_ VGND VGND VPWR VPWR _0872_ sky130_fd_sc_hd__o21ai_1
XFILLER_0_52_3 VPWR VGND VPWR VGND sky130_ef_sc_hd__decap_12
X_5236_ _2250_ _2055_ _2262_ _2251_ VGND VGND VPWR VPWR _2263_ sky130_fd_sc_hd__o211ai_2
X_5167_ _2190_ _2191_ _2192_ _2194_ VGND VGND VPWR VPWR _2195_ sky130_fd_sc_hd__o211a_2
X_5098_ _2125_ _2123_ _2124_ VGND VGND VPWR VPWR _2127_ sky130_fd_sc_hd__and3_1
XFILLER_0_94_713 VPWR VGND VPWR VGND sky130_ef_sc_hd__decap_12
XFILLER_0_78_253 VGND VGND VPWR VPWR sky130_fd_sc_hd__decap_4
X_8857_ clknet_leaf_17_clk net196 _0608_ VGND VGND VPWR VPWR sh13\[5\] sky130_fd_sc_hd__dfrtp_1
XPHY_215 VGND VGND VPWR VPWR sky130_fd_sc_hd__decap_3
XPHY_204 VGND VGND VPWR VPWR sky130_fd_sc_hd__decap_3
XPHY_237 VGND VGND VPWR VPWR sky130_fd_sc_hd__decap_3
XPHY_226 VGND VGND VPWR VPWR sky130_fd_sc_hd__decap_3
X_8788_ clknet_leaf_47_clk net417 _0539_ VGND VGND VPWR VPWR sh5\[0\] sky130_fd_sc_hd__dfrtp_1
XFILLER_0_19_331 VGND VGND VPWR VPWR sky130_fd_sc_hd__decap_4
X_7808_ s0\[9\] net377 _0689_ VGND VGND VPWR VPWR _0009_ sky130_fd_sc_hd__o21a_1
X_7739_ carry4\[7\] s6\[8\] VGND VGND VPWR VPWR _0645_ sky130_fd_sc_hd__nor2_1
XFILLER_0_46_150 VGND VGND VPWR VPWR sky130_fd_sc_hd__fill_1
XFILLER_0_117_561 VPWR VGND VPWR VGND sky130_ef_sc_hd__decap_12
XFILLER_0_34_345 VGND VGND VPWR VPWR sky130_fd_sc_hd__fill_2
XFILLER_0_104_233 VPWR VGND VPWR VGND sky130_ef_sc_hd__decap_12
XFILLER_0_61_175 VPWR VGND VPWR VGND sky130_ef_sc_hd__decap_12
XFILLER_0_100_483 VGND VGND VPWR VPWR sky130_fd_sc_hd__fill_1
Xhold8 bit_sum7\[4\] VGND VGND VPWR VPWR net50 sky130_fd_sc_hd__dlygate4sd3_1
XFILLER_0_97_584 VPWR VGND VPWR VGND sky130_ef_sc_hd__decap_12
XFILLER_0_84_212 VGND VGND VPWR VPWR sky130_fd_sc_hd__fill_2
XFILLER_0_72_418 VGND VGND VPWR VPWR sky130_fd_sc_hd__fill_2
XFILLER_0_38_684 VPWR VGND VPWR VGND sky130_ef_sc_hd__decap_12
XFILLER_0_44_109 VPWR VGND VPWR VGND sky130_ef_sc_hd__decap_12
XFILLER_0_53_643 VGND VGND VPWR VPWR sky130_fd_sc_hd__decap_4
XFILLER_0_25_312 VGND VGND VPWR VPWR sky130_fd_sc_hd__fill_1
XFILLER_0_123_520 VPWR VGND VPWR VGND sky130_ef_sc_hd__decap_12
XFILLER_0_80_451 VGND VGND VPWR VPWR sky130_fd_sc_hd__fill_1
XFILLER_0_52_153 VPWR VGND VPWR VGND sky130_ef_sc_hd__decap_12
XFILLER_0_4_217 VGND VGND VPWR VPWR sky130_fd_sc_hd__fill_1
XFILLER_0_111_57 VPWR VGND VPWR VGND sky130_ef_sc_hd__decap_12
XFILLER_0_80_473 VGND VGND VPWR VPWR sky130_fd_sc_hd__decap_3
Xhold408 sh15\[3\] VGND VGND VPWR VPWR net450 sky130_fd_sc_hd__dlygate4sd3_1
XFILLER_0_20_77 VGND VGND VPWR VPWR sky130_fd_sc_hd__decap_6
XFILLER_0_123_597 VGND VGND VPWR VPWR sky130_fd_sc_hd__fill_2
XFILLER_0_111_726 VGND VGND VPWR VPWR sky130_fd_sc_hd__fill_2
XFILLER_0_96_15 VPWR VGND VPWR VGND sky130_ef_sc_hd__decap_12
XFILLER_0_40_348 VPWR VGND VPWR VGND sky130_ef_sc_hd__decap_12
XFILLER_0_0_445 VGND VGND VPWR VPWR sky130_fd_sc_hd__decap_3
XFILLER_0_0_489 VPWR VGND VPWR VGND sky130_ef_sc_hd__decap_12
XTAP_713 VGND VPWR sky130_fd_sc_hd__tapvpwrvgnd_1
XTAP_702 VGND VPWR sky130_fd_sc_hd__tapvpwrvgnd_1
XTAP_724 VGND VPWR sky130_fd_sc_hd__tapvpwrvgnd_1
X_6070_ _2889_ _2890_ VGND VGND VPWR VPWR _3077_ sky130_fd_sc_hd__nand2_1
XTAP_735 VGND VPWR sky130_fd_sc_hd__tapvpwrvgnd_1
XTAP_746 VGND VPWR sky130_fd_sc_hd__tapvpwrvgnd_1
XTAP_757 VGND VPWR sky130_fd_sc_hd__tapvpwrvgnd_1
XTAP_768 VGND VPWR sky130_fd_sc_hd__tapvpwrvgnd_1
X_5021_ sh3\[2\] VGND VGND VPWR VPWR _2051_ sky130_fd_sc_hd__inv_2
XTAP_779 VGND VPWR sky130_fd_sc_hd__tapvpwrvgnd_1
X_8711_ clknet_leaf_55_clk _0119_ _0462_ VGND VGND VPWR VPWR bit_sum4\[2\] sky130_fd_sc_hd__dfrtp_1
X_6972_ _3956_ _3957_ _3958_ VGND VGND VPWR VPWR _3959_ sky130_fd_sc_hd__o21ai_1
X_5923_ _2880_ _2882_ _2883_ _2885_ _2886_ VGND VGND VPWR VPWR _2932_ sky130_fd_sc_hd__o221ai_1
X_8642_ clknet_leaf_13_clk net102 _0393_ VGND VGND VPWR VPWR s5\[7\] sky130_fd_sc_hd__dfrtp_1
XFILLER_0_75_223 VGND VGND VPWR VPWR sky130_fd_sc_hd__fill_1
XFILLER_0_29_640 VGND VGND VPWR VPWR sky130_fd_sc_hd__decap_6
X_5854_ _2856_ _2864_ _2865_ VGND VGND VPWR VPWR _0180_ sky130_fd_sc_hd__o21bai_1
X_4805_ sh1\[7\] _1643_ sh2\[7\] VGND VGND VPWR VPWR _1841_ sky130_fd_sc_hd__o21ba_1
XFILLER_0_91_727 VGND VGND VPWR VPWR sky130_fd_sc_hd__fill_1
XFILLER_0_61_62 VGND VGND VPWR VPWR sky130_fd_sc_hd__fill_1
X_8573_ clknet_leaf_33_clk net242 _0324_ VGND VGND VPWR VPWR sum2\[8\] sky130_fd_sc_hd__dfrtp_1
XFILLER_0_8_545 VPWR VGND VPWR VGND sky130_ef_sc_hd__decap_12
XFILLER_0_29_673 VPWR VGND VPWR VGND sky130_ef_sc_hd__decap_12
X_7524_ _4160_ VGND VGND VPWR VPWR _0521_ sky130_fd_sc_hd__inv_2
XFILLER_0_56_492 VPWR VGND VPWR VGND sky130_ef_sc_hd__decap_12
XFILLER_0_8_589 VGND VGND VPWR VPWR sky130_fd_sc_hd__decap_4
X_5785_ _2799_ _2789_ _2796_ VGND VGND VPWR VPWR _2800_ sky130_fd_sc_hd__nand3b_1
X_4736_ _1639_ _1772_ VGND VGND VPWR VPWR _1773_ sky130_fd_sc_hd__nor2_1
XFILLER_0_43_131 VPWR VGND VPWR VGND sky130_ef_sc_hd__decap_12
X_4667_ _1700_ _1701_ _1649_ VGND VGND VPWR VPWR _1705_ sky130_fd_sc_hd__o21ai_1
X_7455_ _4153_ VGND VGND VPWR VPWR _0459_ sky130_fd_sc_hd__inv_2
X_7386_ _4145_ VGND VGND VPWR VPWR _0398_ sky130_fd_sc_hd__inv_2
X_6406_ _3403_ _3399_ _3401_ VGND VGND VPWR VPWR _3405_ sky130_fd_sc_hd__nand3_1
XFILLER_0_31_348 VGND VGND VPWR VPWR sky130_fd_sc_hd__fill_1
X_4598_ sh5\[7\] VGND VGND VPWR VPWR _1637_ sky130_fd_sc_hd__clkbuf_4
XFILLER_0_101_214 VGND VGND VPWR VPWR sky130_fd_sc_hd__decap_8
X_6337_ _3333_ _3335_ sh13\[4\] VGND VGND VPWR VPWR _3336_ sky130_fd_sc_hd__o21ai_1
X_6268_ _3248_ _3256_ _3253_ _3261_ _3255_ VGND VGND VPWR VPWR _3271_ sky130_fd_sc_hd__o2111ai_2
X_6199_ _2889_ _2936_ _3197_ VGND VGND VPWR VPWR _3204_ sky130_fd_sc_hd__a21o_1
X_5219_ _2245_ _2246_ VGND VGND VPWR VPWR _2247_ sky130_fd_sc_hd__and2_1
X_8007_ _0852_ _0853_ _0855_ VGND VGND VPWR VPWR _0856_ sky130_fd_sc_hd__a21o_1
XFILLER_0_67_713 VPWR VGND VPWR VGND sky130_ef_sc_hd__decap_12
XFILLER_0_39_404 VGND VGND VPWR VPWR sky130_fd_sc_hd__fill_1
XFILLER_0_35_610 VGND VGND VPWR VPWR sky130_fd_sc_hd__fill_1
XFILLER_0_117_391 VGND VGND VPWR VPWR sky130_fd_sc_hd__fill_1
XFILLER_0_22_304 VGND VGND VPWR VPWR sky130_fd_sc_hd__decap_4
XFILLER_0_34_153 VGND VGND VPWR VPWR sky130_fd_sc_hd__fill_1
XFILLER_0_34_186 VGND VGND VPWR VPWR sky130_fd_sc_hd__fill_1
XFILLER_0_22_348 VPWR VGND VPWR VGND sky130_ef_sc_hd__decap_12
XFILLER_0_120_589 VGND VGND VPWR VPWR sky130_fd_sc_hd__decap_3
XFILLER_0_66_29 VGND VGND VPWR VPWR sky130_fd_sc_hd__decap_4
XFILLER_0_89_337 VGND VGND VPWR VPWR sky130_fd_sc_hd__decap_4
XFILLER_0_97_370 VPWR VGND VPWR VGND sky130_ef_sc_hd__decap_12
XFILLER_0_15_55 VGND VGND VPWR VPWR sky130_fd_sc_hd__fill_1
XFILLER_0_85_532 VGND VGND VPWR VPWR sky130_fd_sc_hd__decap_6
XFILLER_0_57_223 VGND VGND VPWR VPWR sky130_fd_sc_hd__fill_1
XFILLER_0_15_77 VGND VGND VPWR VPWR sky130_fd_sc_hd__fill_1
XFILLER_0_115_328 VGND VGND VPWR VPWR sky130_fd_sc_hd__fill_1
X_5570_ _2579_ _2563_ VGND VGND VPWR VPWR _2589_ sky130_fd_sc_hd__nand2_1
XFILLER_0_31_65 VGND VGND VPWR VPWR sky130_fd_sc_hd__decap_3
X_4521_ _1558_ _1562_ _1564_ VGND VGND VPWR VPWR _1565_ sky130_fd_sc_hd__a21o_1
XFILLER_0_53_473 VGND VGND VPWR VPWR sky130_fd_sc_hd__decap_3
XFILLER_0_25_153 VGND VGND VPWR VPWR sky130_fd_sc_hd__decap_4
XFILLER_0_40_101 VGND VGND VPWR VPWR sky130_fd_sc_hd__decap_6
XFILLER_0_123_361 VGND VGND VPWR VPWR sky130_fd_sc_hd__decap_3
X_4452_ _1237_ _1238_ _1486_ VGND VGND VPWR VPWR _1497_ sky130_fd_sc_hd__a21oi_1
XFILLER_0_80_292 VGND VGND VPWR VPWR sky130_fd_sc_hd__decap_4
Xhold216 sum4\[8\] VGND VGND VPWR VPWR net258 sky130_fd_sc_hd__dlygate4sd3_1
X_7240_ _4131_ VGND VGND VPWR VPWR _0266_ sky130_fd_sc_hd__inv_2
Xhold205 sh1\[0\] VGND VGND VPWR VPWR net247 sky130_fd_sc_hd__dlygate4sd3_1
XFILLER_0_13_337 VPWR VGND VPWR VGND sky130_ef_sc_hd__decap_12
XFILLER_0_41_657 VPWR VGND VPWR VGND sky130_ef_sc_hd__decap_12
Xhold227 s6\[14\] VGND VGND VPWR VPWR net269 sky130_fd_sc_hd__buf_1
Xhold238 s5\[11\] VGND VGND VPWR VPWR net280 sky130_fd_sc_hd__dlygate4sd3_1
XFILLER_0_1_721 VGND VGND VPWR VPWR sky130_fd_sc_hd__decap_6
Xhold249 _4120_ VGND VGND VPWR VPWR net291 sky130_fd_sc_hd__dlygate4sd3_1
X_4383_ _1422_ _1425_ _1428_ VGND VGND VPWR VPWR _1429_ sky130_fd_sc_hd__a21oi_1
X_7171_ _4124_ VGND VGND VPWR VPWR _0204_ sky130_fd_sc_hd__inv_2
XFILLER_0_0_253 VPWR VGND VPWR VGND sky130_ef_sc_hd__decap_12
X_6122_ _3063_ _3124_ _3125_ _3128_ VGND VGND VPWR VPWR _3129_ sky130_fd_sc_hd__a2bb2oi_1
XTAP_521 VGND VPWR sky130_fd_sc_hd__tapvpwrvgnd_1
XTAP_510 VGND VPWR sky130_fd_sc_hd__tapvpwrvgnd_1
XTAP_532 VGND VPWR sky130_fd_sc_hd__tapvpwrvgnd_1
XTAP_543 VGND VPWR sky130_fd_sc_hd__tapvpwrvgnd_1
X_6053_ _3060_ _2977_ VGND VGND VPWR VPWR _3061_ sky130_fd_sc_hd__nand2_1
XTAP_554 VGND VPWR sky130_fd_sc_hd__tapvpwrvgnd_1
XTAP_565 VGND VPWR sky130_fd_sc_hd__tapvpwrvgnd_1
XTAP_576 VGND VPWR sky130_fd_sc_hd__tapvpwrvgnd_1
X_5004_ _1760_ _1761_ _1669_ _1671_ VGND VGND VPWR VPWR _2035_ sky130_fd_sc_hd__a211o_1
XTAP_587 VGND VPWR sky130_fd_sc_hd__tapvpwrvgnd_1
XTAP_598 VGND VPWR sky130_fd_sc_hd__tapvpwrvgnd_1
XFILLER_0_15_3 VPWR VGND VPWR VGND sky130_ef_sc_hd__decap_12
XTAP_1709 VGND VPWR sky130_fd_sc_hd__tapvpwrvgnd_1
X_6955_ _3939_ _3940_ _3941_ VGND VGND VPWR VPWR _3942_ sky130_fd_sc_hd__nand3_1
X_5906_ _2889_ _2890_ _2914_ VGND VGND VPWR VPWR _2915_ sky130_fd_sc_hd__a21oi_1
XFILLER_0_72_83 VGND VGND VPWR VPWR sky130_fd_sc_hd__fill_1
XFILLER_0_48_212 VGND VGND VPWR VPWR sky130_fd_sc_hd__fill_2
XFILLER_0_48_223 VGND VGND VPWR VPWR sky130_fd_sc_hd__decap_3
XFILLER_0_76_587 VGND VGND VPWR VPWR sky130_fd_sc_hd__fill_1
X_8625_ clknet_leaf_56_clk net46 _0376_ VGND VGND VPWR VPWR s3\[8\] sky130_fd_sc_hd__dfrtp_1
X_6886_ _3787_ net29 _3872_ _3873_ VGND VGND VPWR VPWR _3874_ sky130_fd_sc_hd__o2bb2a_1
X_5837_ _2848_ _2850_ VGND VGND VPWR VPWR _0178_ sky130_fd_sc_hd__nand2_1
XFILLER_0_118_166 VGND VGND VPWR VPWR sky130_fd_sc_hd__fill_2
X_8556_ clknet_leaf_38_clk _0086_ _0307_ VGND VGND VPWR VPWR sum4\[6\] sky130_fd_sc_hd__dfrtp_1
X_5768_ _2772_ _2774_ _2736_ _2776_ VGND VGND VPWR VPWR _2783_ sky130_fd_sc_hd__o211ai_4
XFILLER_0_17_654 VPWR VGND VPWR VGND sky130_ef_sc_hd__decap_12
X_4719_ _1751_ _1755_ _1756_ VGND VGND VPWR VPWR _1757_ sky130_fd_sc_hd__a21o_1
X_8487_ clknet_leaf_25_clk net110 _0238_ VGND VGND VPWR VPWR net25 sky130_fd_sc_hd__dfrtp_1
X_7507_ _4157_ VGND VGND VPWR VPWR _0507_ sky130_fd_sc_hd__inv_2
XFILLER_0_16_153 VPWR VGND VPWR VGND sky130_ef_sc_hd__decap_12
XFILLER_0_32_613 VPWR VGND VPWR VGND sky130_ef_sc_hd__decap_12
XFILLER_0_44_473 VGND VGND VPWR VPWR sky130_fd_sc_hd__decap_3
XFILLER_0_71_292 VGND VGND VPWR VPWR sky130_fd_sc_hd__decap_3
XFILLER_0_71_281 VGND VGND VPWR VPWR sky130_fd_sc_hd__fill_1
XFILLER_0_4_570 VGND VGND VPWR VPWR sky130_fd_sc_hd__fill_1
XFILLER_0_16_197 VGND VGND VPWR VPWR sky130_fd_sc_hd__decap_8
X_5699_ _2712_ _2715_ _2466_ VGND VGND VPWR VPWR _2716_ sky130_fd_sc_hd__o21ai_2
X_7438_ _4151_ VGND VGND VPWR VPWR _0444_ sky130_fd_sc_hd__inv_2
XFILLER_0_102_545 VGND VGND VPWR VPWR sky130_fd_sc_hd__decap_4
XFILLER_0_102_523 VGND VGND VPWR VPWR sky130_fd_sc_hd__decap_8
X_7369_ _4144_ VGND VGND VPWR VPWR _0382_ sky130_fd_sc_hd__inv_2
XFILLER_0_31_189 VGND VGND VPWR VPWR sky130_fd_sc_hd__decap_8
XFILLER_0_98_156 VPWR VGND VPWR VGND sky130_ef_sc_hd__decap_12
XFILLER_0_86_307 VGND VGND VPWR VPWR sky130_fd_sc_hd__fill_1
XFILLER_0_39_212 VGND VGND VPWR VPWR sky130_fd_sc_hd__fill_1
XFILLER_0_39_223 VGND VGND VPWR VPWR sky130_fd_sc_hd__fill_1
XFILLER_0_35_473 VGND VGND VPWR VPWR sky130_fd_sc_hd__fill_1
XFILLER_0_112_309 VGND VGND VPWR VPWR sky130_fd_sc_hd__decap_6
XFILLER_0_50_421 VGND VGND VPWR VPWR sky130_fd_sc_hd__decap_8
XFILLER_0_50_454 VGND VGND VPWR VPWR sky130_fd_sc_hd__fill_2
XFILLER_0_77_39 VPWR VGND VPWR VGND sky130_ef_sc_hd__decap_12
XFILLER_0_120_386 VGND VGND VPWR VPWR sky130_fd_sc_hd__decap_6
XFILLER_0_93_27 VPWR VGND VPWR VGND sky130_ef_sc_hd__decap_12
XFILLER_0_77_307 VGND VGND VPWR VPWR sky130_fd_sc_hd__fill_2
XFILLER_0_26_98 VGND VGND VPWR VPWR sky130_fd_sc_hd__fill_1
X_6740_ _3706_ _3727_ _3729_ VGND VGND VPWR VPWR _3730_ sky130_fd_sc_hd__nand3b_1
XFILLER_0_18_418 VGND VGND VPWR VPWR sky130_fd_sc_hd__fill_2
XFILLER_0_42_53 VPWR VGND VPWR VGND sky130_ef_sc_hd__decap_12
X_6671_ _3616_ _3663_ _3664_ VGND VGND VPWR VPWR _3665_ sky130_fd_sc_hd__o21ai_2
XFILLER_0_45_204 VPWR VGND VPWR VGND sky130_ef_sc_hd__decap_12
XFILLER_0_45_237 VPWR VGND VPWR VGND sky130_ef_sc_hd__decap_12
X_8410_ _1237_ _1239_ _1235_ VGND VGND VPWR VPWR _1240_ sky130_fd_sc_hd__o21ai_2
X_5622_ _2615_ _2638_ _2639_ VGND VGND VPWR VPWR _2640_ sky130_fd_sc_hd__nand3b_1
XFILLER_0_42_97 VGND VGND VPWR VPWR sky130_fd_sc_hd__decap_6
X_8341_ _1176_ _1177_ VGND VGND VPWR VPWR _0164_ sky130_fd_sc_hd__nor2_1
X_5553_ _2477_ _2506_ VGND VGND VPWR VPWR _2572_ sky130_fd_sc_hd__or2_1
X_4504_ _1274_ _1384_ _1547_ VGND VGND VPWR VPWR _1548_ sky130_fd_sc_hd__a21oi_2
XFILLER_0_115_169 VPWR VGND VPWR VGND sky130_ef_sc_hd__decap_12
XFILLER_0_14_657 VPWR VGND VPWR VGND sky130_ef_sc_hd__decap_12
XFILLER_0_41_432 VGND VGND VPWR VPWR sky130_fd_sc_hd__decap_3
X_8272_ _1113_ _1114_ _1115_ VGND VGND VPWR VPWR _1116_ sky130_fd_sc_hd__a21o_1
XFILLER_0_13_167 VGND VGND VPWR VPWR sky130_fd_sc_hd__fill_1
X_5484_ _2466_ _2502_ VGND VGND VPWR VPWR _2504_ sky130_fd_sc_hd__nand2_1
X_4435_ _1274_ _1414_ _1411_ VGND VGND VPWR VPWR _1481_ sky130_fd_sc_hd__a21o_1
X_7223_ _4130_ VGND VGND VPWR VPWR _0250_ sky130_fd_sc_hd__inv_2
X_4366_ _1411_ _1412_ _1316_ VGND VGND VPWR VPWR _1413_ sky130_fd_sc_hd__o21ai_1
X_7154_ _4122_ VGND VGND VPWR VPWR _4123_ sky130_fd_sc_hd__buf_4
XFILLER_0_6_53 VPWR VGND VPWR VGND sky130_ef_sc_hd__decap_12
XFILLER_0_1_573 VPWR VGND VPWR VGND sky130_ef_sc_hd__decap_12
X_6105_ _3111_ _3050_ _3029_ VGND VGND VPWR VPWR _3112_ sky130_fd_sc_hd__o21ai_4
XTAP_351 VGND VPWR sky130_fd_sc_hd__tapvpwrvgnd_1
XFILLER_0_6_97 VPWR VGND VPWR VGND sky130_ef_sc_hd__decap_12
XTAP_340 VGND VPWR sky130_fd_sc_hd__tapvpwrvgnd_1
X_4297_ _1225_ _1228_ _1223_ _1226_ VGND VGND VPWR VPWR _1345_ sky130_fd_sc_hd__o211ai_1
XFILLER_0_67_94 VPWR VGND VPWR VGND sky130_ef_sc_hd__decap_12
XTAP_384 VGND VPWR sky130_fd_sc_hd__tapvpwrvgnd_1
XTAP_373 VGND VPWR sky130_fd_sc_hd__tapvpwrvgnd_1
XTAP_362 VGND VPWR sky130_fd_sc_hd__tapvpwrvgnd_1
X_7085_ _4032_ _4067_ _4068_ VGND VGND VPWR VPWR _4069_ sky130_fd_sc_hd__a21oi_2
X_6036_ _3042_ _3043_ VGND VGND VPWR VPWR _3044_ sky130_fd_sc_hd__nand2_1
XTAP_395 VGND VPWR sky130_fd_sc_hd__tapvpwrvgnd_1
XTAP_1506 VGND VPWR sky130_fd_sc_hd__tapvpwrvgnd_1
XFILLER_0_83_93 VPWR VGND VPWR VGND sky130_ef_sc_hd__decap_12
XPHY_13 VGND VGND VPWR VPWR sky130_fd_sc_hd__decap_3
XTAP_1539 VGND VPWR sky130_fd_sc_hd__tapvpwrvgnd_1
XTAP_1528 VGND VPWR sky130_fd_sc_hd__tapvpwrvgnd_1
XTAP_1517 VGND VPWR sky130_fd_sc_hd__tapvpwrvgnd_1
XFILLER_0_95_126 VGND VGND VPWR VPWR sky130_fd_sc_hd__fill_2
X_7987_ _0773_ _0819_ _0816_ _0813_ _0820_ VGND VGND VPWR VPWR _0836_ sky130_fd_sc_hd__o221a_2
XPHY_24 VGND VGND VPWR VPWR sky130_fd_sc_hd__decap_3
XPHY_35 VGND VGND VPWR VPWR sky130_fd_sc_hd__decap_3
XPHY_46 VGND VGND VPWR VPWR sky130_fd_sc_hd__decap_3
XFILLER_0_119_420 VPWR VGND VPWR VGND sky130_ef_sc_hd__decap_12
XFILLER_0_95_159 VGND VGND VPWR VPWR sky130_fd_sc_hd__fill_1
X_6938_ _3907_ _3844_ _3849_ VGND VGND VPWR VPWR _3925_ sky130_fd_sc_hd__o21ai_2
XPHY_57 VGND VGND VPWR VPWR sky130_fd_sc_hd__decap_3
XPHY_68 VGND VGND VPWR VPWR sky130_fd_sc_hd__decap_3
XPHY_79 VGND VGND VPWR VPWR sky130_fd_sc_hd__decap_3
X_6869_ _3787_ net29 VGND VGND VPWR VPWR _3857_ sky130_fd_sc_hd__nand2_1
XFILLER_0_36_226 VGND VGND VPWR VPWR sky130_fd_sc_hd__decap_3
XFILLER_0_9_673 VPWR VGND VPWR VGND sky130_ef_sc_hd__decap_12
XFILLER_0_36_237 VPWR VGND VPWR VGND sky130_ef_sc_hd__decap_12
X_8608_ clknet_leaf_53_clk net118 _0359_ VGND VGND VPWR VPWR s1\[9\] sky130_fd_sc_hd__dfrtp_1
XFILLER_0_106_147 VPWR VGND VPWR VGND sky130_ef_sc_hd__decap_12
X_8539_ clknet_leaf_14_clk net101 _0290_ VGND VGND VPWR VPWR sum3\[13\] sky130_fd_sc_hd__dfrtp_1
XFILLER_0_60_730 VGND VGND VPWR VPWR sky130_fd_sc_hd__decap_4
XFILLER_0_32_421 VPWR VGND VPWR VGND sky130_ef_sc_hd__decap_12
XFILLER_0_4_3 VPWR VGND VPWR VGND sky130_ef_sc_hd__decap_12
XFILLER_0_95_671 VGND VGND VPWR VPWR sky130_fd_sc_hd__fill_1
XFILLER_0_94_170 VPWR VGND VPWR VGND sky130_ef_sc_hd__decap_12
XFILLER_0_27_204 VGND VGND VPWR VPWR sky130_fd_sc_hd__decap_6
XFILLER_0_103_36 VGND VGND VPWR VPWR sky130_fd_sc_hd__fill_1
XFILLER_0_6_109 VPWR VGND VPWR VGND sky130_ef_sc_hd__decap_12
XFILLER_0_27_237 VGND VGND VPWR VPWR sky130_fd_sc_hd__fill_2
XFILLER_0_82_387 VGND VGND VPWR VPWR sky130_fd_sc_hd__decap_6
XFILLER_0_12_78 VGND VGND VPWR VPWR sky130_fd_sc_hd__decap_6
XFILLER_0_88_27 VGND VGND VPWR VPWR sky130_fd_sc_hd__fill_1
XFILLER_0_70_549 VGND VGND VPWR VPWR sky130_fd_sc_hd__decap_4
XFILLER_0_2_304 VGND VGND VPWR VPWR sky130_fd_sc_hd__fill_1
XFILLER_0_35_281 VGND VGND VPWR VPWR sky130_fd_sc_hd__decap_8
XFILLER_0_112_139 VGND VGND VPWR VPWR sky130_fd_sc_hd__fill_1
XFILLER_0_11_605 VGND VGND VPWR VPWR sky130_fd_sc_hd__fill_1
XFILLER_0_23_443 VGND VGND VPWR VPWR sky130_fd_sc_hd__decap_4
XFILLER_0_50_251 VGND VGND VPWR VPWR sky130_fd_sc_hd__fill_1
XFILLER_0_11_649 VPWR VGND VPWR VGND sky130_ef_sc_hd__decap_12
XFILLER_0_2_359 VGND VGND VPWR VPWR sky130_fd_sc_hd__fill_1
XFILLER_0_23_498 VGND VGND VPWR VPWR sky130_fd_sc_hd__decap_3
X_4220_ sh2\[5\] VGND VGND VPWR VPWR _1268_ sky130_fd_sc_hd__buf_4
XFILLER_0_121_673 VPWR VGND VPWR VGND sky130_ef_sc_hd__decap_12
XFILLER_0_37_86 VPWR VGND VPWR VGND sky130_ef_sc_hd__decap_12
X_7910_ _0728_ _0758_ _0759_ VGND VGND VPWR VPWR _0760_ sky130_fd_sc_hd__o21ai_1
X_7841_ sum3\[12\] carry3\[11\] net301 VGND VGND VPWR VPWR _0706_ sky130_fd_sc_hd__a21o_1
XFILLER_0_77_137 VPWR VGND VPWR VGND sky130_ef_sc_hd__decap_12
X_4984_ _2014_ _2012_ _1990_ _2016_ VGND VGND VPWR VPWR _2017_ sky130_fd_sc_hd__o2bb2a_1
X_7772_ net270 _0671_ VGND VGND VPWR VPWR _0094_ sky130_fd_sc_hd__nand2_1
XFILLER_0_58_340 VPWR VGND VPWR VGND sky130_ef_sc_hd__decap_12
X_6723_ sh1\[1\] _3712_ VGND VGND VPWR VPWR _3713_ sky130_fd_sc_hd__nand2_2
XFILLER_0_19_727 VGND VGND VPWR VPWR sky130_fd_sc_hd__fill_1
X_6654_ _3647_ _3648_ _3482_ VGND VGND VPWR VPWR _3649_ sky130_fd_sc_hd__a21oi_1
XFILLER_0_61_516 VGND VGND VPWR VPWR sky130_fd_sc_hd__decap_4
X_5605_ _2621_ _2622_ _2482_ VGND VGND VPWR VPWR _2623_ sky130_fd_sc_hd__o21bai_4
XFILLER_0_116_489 VGND VGND VPWR VPWR sky130_fd_sc_hd__fill_2
XFILLER_0_103_106 VGND VGND VPWR VPWR sky130_fd_sc_hd__decap_6
XFILLER_0_82_3 VPWR VGND VPWR VGND sky130_ef_sc_hd__decap_12
X_6585_ _3503_ _3551_ _3579_ _3580_ VGND VGND VPWR VPWR _3581_ sky130_fd_sc_hd__o211a_1
XFILLER_0_14_421 VGND VGND VPWR VPWR sky130_fd_sc_hd__decap_4
X_8324_ _1160_ _1161_ VGND VGND VPWR VPWR _1162_ sky130_fd_sc_hd__xnor2_1
X_5536_ _2479_ _2482_ sh4\[0\] VGND VGND VPWR VPWR _2555_ sky130_fd_sc_hd__o21ai_4
X_8255_ _1093_ VGND VGND VPWR VPWR _1099_ sky130_fd_sc_hd__inv_2
X_5467_ sh4\[0\] VGND VGND VPWR VPWR _2487_ sky130_fd_sc_hd__clkbuf_4
XFILLER_0_41_273 VGND VGND VPWR VPWR sky130_fd_sc_hd__decap_6
X_4418_ _1314_ _1392_ _1387_ VGND VGND VPWR VPWR _1464_ sky130_fd_sc_hd__a21bo_2
X_7206_ _4128_ VGND VGND VPWR VPWR _0235_ sky130_fd_sc_hd__inv_2
XFILLER_0_1_370 VGND VGND VPWR VPWR sky130_fd_sc_hd__fill_1
X_8186_ _1022_ _1026_ _1031_ VGND VGND VPWR VPWR _1032_ sky130_fd_sc_hd__a21o_1
X_5398_ _2246_ _2312_ VGND VGND VPWR VPWR _2423_ sky130_fd_sc_hd__nor2_1
X_4349_ _1377_ _1380_ _1395_ VGND VGND VPWR VPWR _1396_ sky130_fd_sc_hd__o21a_2
XFILLER_0_10_693 VGND VGND VPWR VPWR sky130_fd_sc_hd__decap_6
X_7137_ net257 _4113_ VGND VGND VPWR VPWR _0053_ sky130_fd_sc_hd__xnor2_1
X_7068_ _4049_ _4045_ _4047_ VGND VGND VPWR VPWR _4053_ sky130_fd_sc_hd__and3_1
X_6019_ _3008_ _3009_ _3011_ VGND VGND VPWR VPWR _3027_ sky130_fd_sc_hd__o21ai_2
XFILLER_0_96_402 VGND VGND VPWR VPWR sky130_fd_sc_hd__decap_3
XTAP_1314 VGND VPWR sky130_fd_sc_hd__tapvpwrvgnd_1
XTAP_1303 VGND VPWR sky130_fd_sc_hd__tapvpwrvgnd_1
XTAP_1347 VGND VPWR sky130_fd_sc_hd__tapvpwrvgnd_1
XTAP_1336 VGND VPWR sky130_fd_sc_hd__tapvpwrvgnd_1
XTAP_1325 VGND VPWR sky130_fd_sc_hd__tapvpwrvgnd_1
XTAP_1369 VGND VPWR sky130_fd_sc_hd__tapvpwrvgnd_1
XTAP_1358 VGND VPWR sky130_fd_sc_hd__tapvpwrvgnd_1
XFILLER_0_37_513 VGND VGND VPWR VPWR sky130_fd_sc_hd__fill_2
XFILLER_0_119_261 VPWR VGND VPWR VGND sky130_ef_sc_hd__decap_12
XFILLER_0_64_321 VPWR VGND VPWR VGND sky130_ef_sc_hd__decap_12
XFILLER_0_91_151 VGND VGND VPWR VPWR sky130_fd_sc_hd__decap_6
XFILLER_0_17_281 VGND VGND VPWR VPWR sky130_fd_sc_hd__fill_2
XFILLER_0_60_560 VGND VGND VPWR VPWR sky130_fd_sc_hd__decap_3
XFILLER_0_103_673 VPWR VGND VPWR VGND sky130_ef_sc_hd__decap_12
XFILLER_0_20_435 VPWR VGND VPWR VGND sky130_ef_sc_hd__decap_12
XFILLER_0_74_29 VPWR VGND VPWR VGND sky130_ef_sc_hd__decap_12
XFILLER_0_99_240 VGND VGND VPWR VPWR sky130_fd_sc_hd__decap_8
XFILLER_0_59_137 VPWR VGND VPWR VGND sky130_ef_sc_hd__decap_12
XTAP_1870 VGND VPWR sky130_fd_sc_hd__tapvpwrvgnd_1
XFILLER_0_28_513 VPWR VGND VPWR VGND sky130_ef_sc_hd__decap_12
XTAP_1881 VGND VPWR sky130_fd_sc_hd__tapvpwrvgnd_1
XFILLER_0_99_15 VPWR VGND VPWR VGND sky130_ef_sc_hd__decap_12
Xclkbuf_leaf_40_clk clknet_3_5__leaf_clk VGND VGND VPWR VPWR clknet_leaf_40_clk sky130_fd_sc_hd__clkbuf_16
XFILLER_0_24_730 VGND VGND VPWR VPWR sky130_fd_sc_hd__decap_4
X_6370_ _3311_ _3331_ _3343_ VGND VGND VPWR VPWR _3369_ sky130_fd_sc_hd__o21a_1
XFILLER_0_23_240 VGND VGND VPWR VPWR sky130_fd_sc_hd__decap_4
XFILLER_0_23_251 VGND VGND VPWR VPWR sky130_fd_sc_hd__decap_4
X_5321_ _2339_ _2342_ _2346_ VGND VGND VPWR VPWR _2347_ sky130_fd_sc_hd__nand3_1
XFILLER_0_51_582 VGND VGND VPWR VPWR sky130_fd_sc_hd__decap_8
XFILLER_0_11_446 VGND VGND VPWR VPWR sky130_fd_sc_hd__fill_2
XFILLER_0_2_189 VGND VGND VPWR VPWR sky130_fd_sc_hd__decap_6
X_8040_ _0762_ sh9\[3\] VGND VGND VPWR VPWR _0888_ sky130_fd_sc_hd__nor2_1
X_5252_ _2200_ _2226_ _2224_ VGND VGND VPWR VPWR _2279_ sky130_fd_sc_hd__o21ai_2
XFILLER_0_48_52 VGND VGND VPWR VPWR sky130_fd_sc_hd__decap_8
X_5183_ _2090_ _2051_ _2138_ VGND VGND VPWR VPWR _2211_ sky130_fd_sc_hd__o21ai_4
XFILLER_0_48_85 VPWR VGND VPWR VGND sky130_ef_sc_hd__decap_12
X_8873_ clknet_leaf_17_clk net236 _0624_ VGND VGND VPWR VPWR sh15\[5\] sky130_fd_sc_hd__dfrtp_4
X_7824_ net306 _0697_ VGND VGND VPWR VPWR _0071_ sky130_fd_sc_hd__xnor2_1
XFILLER_0_66_608 VGND VGND VPWR VPWR sky130_fd_sc_hd__fill_1
XFILLER_0_93_438 VGND VGND VPWR VPWR sky130_fd_sc_hd__decap_3
X_4967_ _1955_ _1956_ _1970_ _1974_ VGND VGND VPWR VPWR _2000_ sky130_fd_sc_hd__a22o_1
XFILLER_0_108_209 VGND VGND VPWR VPWR sky130_fd_sc_hd__decap_3
XFILLER_0_80_83 VGND VGND VPWR VPWR sky130_fd_sc_hd__fill_1
X_7755_ _0656_ _0657_ net309 VGND VGND VPWR VPWR _0658_ sky130_fd_sc_hd__o21ai_1
XFILLER_0_19_535 VGND VGND VPWR VPWR sky130_fd_sc_hd__fill_2
XFILLER_0_19_557 VGND VGND VPWR VPWR sky130_fd_sc_hd__decap_3
XFILLER_0_46_343 VGND VGND VPWR VPWR sky130_fd_sc_hd__fill_1
X_4898_ _1875_ _1844_ _1837_ VGND VGND VPWR VPWR _1933_ sky130_fd_sc_hd__a21oi_1
XFILLER_0_73_162 VGND VGND VPWR VPWR sky130_fd_sc_hd__decap_6
Xclkbuf_leaf_31_clk clknet_3_6__leaf_clk VGND VGND VPWR VPWR clknet_leaf_31_clk sky130_fd_sc_hd__clkbuf_16
X_6706_ _3411_ _3536_ _3410_ _3325_ VGND VGND VPWR VPWR _3697_ sky130_fd_sc_hd__or4bb_1
X_7686_ net442 net245 VGND VGND VPWR VPWR _4207_ sky130_fd_sc_hd__and2_1
XFILLER_0_116_242 VGND VGND VPWR VPWR sky130_fd_sc_hd__decap_8
X_6637_ _3574_ _3578_ VGND VGND VPWR VPWR _3632_ sky130_fd_sc_hd__nand2_1
XFILLER_0_104_415 VGND VGND VPWR VPWR sky130_fd_sc_hd__decap_4
X_6568_ _3557_ _3561_ _3562_ _3563_ VGND VGND VPWR VPWR _3564_ sky130_fd_sc_hd__o211ai_4
X_8307_ _1145_ net438 _1144_ VGND VGND VPWR VPWR _1146_ sky130_fd_sc_hd__nand3b_1
XFILLER_0_14_251 VGND VGND VPWR VPWR sky130_fd_sc_hd__fill_1
X_5519_ _2533_ _2537_ VGND VGND VPWR VPWR _2538_ sky130_fd_sc_hd__xnor2_1
XFILLER_0_30_733 VGND VGND VPWR VPWR sky130_fd_sc_hd__fill_2
X_6499_ _3307_ _3377_ sh9\[4\] VGND VGND VPWR VPWR _3496_ sky130_fd_sc_hd__o21bai_1
X_8238_ _1080_ _1075_ _1079_ VGND VGND VPWR VPWR _1083_ sky130_fd_sc_hd__nand3_2
X_8169_ _0733_ _1012_ _1004_ _1002_ _1014_ VGND VGND VPWR VPWR _1015_ sky130_fd_sc_hd__o221a_2
XFILLER_0_100_698 VGND VGND VPWR VPWR sky130_fd_sc_hd__fill_2
XTAP_1122 VGND VPWR sky130_fd_sc_hd__tapvpwrvgnd_1
XTAP_1111 VGND VPWR sky130_fd_sc_hd__tapvpwrvgnd_1
XTAP_1100 VGND VPWR sky130_fd_sc_hd__tapvpwrvgnd_1
XFILLER_0_96_265 VGND VGND VPWR VPWR sky130_fd_sc_hd__decap_6
XFILLER_0_84_416 VGND VGND VPWR VPWR sky130_fd_sc_hd__decap_4
XTAP_1155 VGND VPWR sky130_fd_sc_hd__tapvpwrvgnd_1
XTAP_1144 VGND VPWR sky130_fd_sc_hd__tapvpwrvgnd_1
XTAP_1133 VGND VPWR sky130_fd_sc_hd__tapvpwrvgnd_1
XFILLER_0_77_490 VGND VGND VPWR VPWR sky130_fd_sc_hd__decap_3
XTAP_1199 VGND VPWR sky130_fd_sc_hd__tapvpwrvgnd_1
XTAP_1188 VGND VPWR sky130_fd_sc_hd__tapvpwrvgnd_1
XTAP_1177 VGND VPWR sky130_fd_sc_hd__tapvpwrvgnd_1
XTAP_1166 VGND VPWR sky130_fd_sc_hd__tapvpwrvgnd_1
Xclkbuf_leaf_22_clk clknet_3_7__leaf_clk VGND VGND VPWR VPWR clknet_leaf_22_clk sky130_fd_sc_hd__clkbuf_16
XFILLER_0_65_685 VPWR VGND VPWR VGND sky130_ef_sc_hd__decap_12
XFILLER_0_65_663 VGND VGND VPWR VPWR sky130_fd_sc_hd__decap_3
XFILLER_0_25_505 VGND VGND VPWR VPWR sky130_fd_sc_hd__decap_4
XFILLER_0_123_713 VGND VGND VPWR VPWR sky130_fd_sc_hd__decap_8
XFILLER_0_64_195 VGND VGND VPWR VPWR sky130_fd_sc_hd__fill_1
XFILLER_0_64_173 VGND VGND VPWR VPWR sky130_fd_sc_hd__fill_1
XFILLER_0_52_313 VGND VGND VPWR VPWR sky130_fd_sc_hd__fill_1
XFILLER_0_107_297 VGND VGND VPWR VPWR sky130_fd_sc_hd__decap_3
XFILLER_0_52_357 VGND VGND VPWR VPWR sky130_fd_sc_hd__decap_6
XFILLER_0_100_15 VPWR VGND VPWR VGND sky130_ef_sc_hd__decap_12
XFILLER_0_80_699 VGND VGND VPWR VPWR sky130_fd_sc_hd__fill_1
XFILLER_0_20_265 VGND VGND VPWR VPWR sky130_fd_sc_hd__decap_8
XTAP_906 VGND VPWR sky130_fd_sc_hd__tapvpwrvgnd_1
XTAP_917 VGND VPWR sky130_fd_sc_hd__tapvpwrvgnd_1
XFILLER_0_85_39 VPWR VGND VPWR VGND sky130_ef_sc_hd__decap_12
XTAP_939 VGND VPWR sky130_fd_sc_hd__tapvpwrvgnd_1
XTAP_928 VGND VPWR sky130_fd_sc_hd__tapvpwrvgnd_1
X_5870_ _2878_ _2879_ sh3\[6\] VGND VGND VPWR VPWR _2880_ sky130_fd_sc_hd__o21ai_2
X_4821_ _1855_ _1856_ VGND VGND VPWR VPWR _1857_ sky130_fd_sc_hd__nand2_2
XFILLER_0_34_76 VGND VGND VPWR VPWR sky130_fd_sc_hd__fill_1
X_7540_ _4161_ VGND VGND VPWR VPWR _0536_ sky130_fd_sc_hd__inv_2
X_4752_ _1783_ _1787_ _1788_ VGND VGND VPWR VPWR _1789_ sky130_fd_sc_hd__a21oi_2
Xclkbuf_leaf_13_clk clknet_3_6__leaf_clk VGND VGND VPWR VPWR clknet_leaf_13_clk sky130_fd_sc_hd__clkbuf_16
XFILLER_0_28_343 VGND VGND VPWR VPWR sky130_fd_sc_hd__decap_4
XFILLER_0_28_365 VPWR VGND VPWR VGND sky130_ef_sc_hd__decap_12
X_4683_ _1718_ _1720_ VGND VGND VPWR VPWR _1721_ sky130_fd_sc_hd__nor2_1
X_7471_ _4154_ VGND VGND VPWR VPWR _0474_ sky130_fd_sc_hd__inv_2
XFILLER_0_83_482 VPWR VGND VPWR VGND sky130_ef_sc_hd__decap_12
XFILLER_0_16_549 VGND VGND VPWR VPWR sky130_fd_sc_hd__decap_4
XFILLER_0_114_713 VGND VGND VPWR VPWR sky130_fd_sc_hd__fill_2
XFILLER_0_113_212 VGND VGND VPWR VPWR sky130_fd_sc_hd__fill_1
X_6422_ sh4\[4\] sh5\[4\] VGND VGND VPWR VPWR _3420_ sky130_fd_sc_hd__and2_1
X_6353_ _3315_ _3305_ _3302_ VGND VGND VPWR VPWR _3352_ sky130_fd_sc_hd__a21boi_1
XFILLER_0_12_733 VGND VGND VPWR VPWR sky130_fd_sc_hd__fill_2
XFILLER_0_11_210 VPWR VGND VPWR VGND sky130_ef_sc_hd__decap_12
X_6284_ _2868_ _2905_ _3284_ _2947_ VGND VGND VPWR VPWR _3285_ sky130_fd_sc_hd__o22a_1
X_5304_ _2319_ _2321_ _2069_ VGND VGND VPWR VPWR _2330_ sky130_fd_sc_hd__o21ai_1
X_8023_ _0730_ _0772_ _0734_ VGND VGND VPWR VPWR _0871_ sky130_fd_sc_hd__o21a_1
X_5235_ _2094_ _2091_ _2213_ VGND VGND VPWR VPWR _2262_ sky130_fd_sc_hd__o21ai_1
XFILLER_0_45_3 VPWR VGND VPWR VGND sky130_ef_sc_hd__decap_12
X_5166_ _2191_ _2193_ _2043_ VGND VGND VPWR VPWR _2194_ sky130_fd_sc_hd__o21ai_1
X_5097_ _2123_ _2124_ _2125_ VGND VGND VPWR VPWR _2126_ sky130_fd_sc_hd__a21oi_1
XPHY_216 VGND VGND VPWR VPWR sky130_fd_sc_hd__decap_3
XPHY_205 VGND VGND VPWR VPWR sky130_fd_sc_hd__decap_3
XFILLER_0_94_725 VGND VGND VPWR VPWR sky130_fd_sc_hd__decap_8
XFILLER_0_78_276 VGND VGND VPWR VPWR sky130_fd_sc_hd__fill_1
X_8856_ clknet_leaf_0_clk net263 _0607_ VGND VGND VPWR VPWR sh13\[4\] sky130_fd_sc_hd__dfrtp_4
X_8787_ clknet_leaf_18_clk net156 _0538_ VGND VGND VPWR VPWR sh4\[7\] sky130_fd_sc_hd__dfrtp_4
XPHY_238 VGND VGND VPWR VPWR sky130_fd_sc_hd__decap_3
XPHY_227 VGND VGND VPWR VPWR sky130_fd_sc_hd__decap_3
X_5999_ _2951_ _3005_ _3006_ VGND VGND VPWR VPWR _3007_ sky130_fd_sc_hd__o21ai_1
X_7807_ s0\[9\] s1\[9\] net293 VGND VGND VPWR VPWR _0689_ sky130_fd_sc_hd__a21o_1
X_7738_ carry4\[7\] s6\[8\] VGND VGND VPWR VPWR _0644_ sky130_fd_sc_hd__and2_1
XFILLER_0_19_343 VPWR VGND VPWR VGND sky130_ef_sc_hd__decap_12
XFILLER_0_61_110 VGND VGND VPWR VPWR sky130_fd_sc_hd__fill_2
XFILLER_0_46_162 VGND VGND VPWR VPWR sky130_fd_sc_hd__fill_2
XFILLER_0_47_696 VGND VGND VPWR VPWR sky130_fd_sc_hd__decap_8
XFILLER_0_117_573 VGND VGND VPWR VPWR sky130_fd_sc_hd__fill_2
X_7669_ sum3\[11\] carry3\[10\] VGND VGND VPWR VPWR _4194_ sky130_fd_sc_hd__and2_1
XFILLER_0_61_154 VGND VGND VPWR VPWR sky130_fd_sc_hd__fill_2
XFILLER_0_61_132 VGND VGND VPWR VPWR sky130_fd_sc_hd__fill_1
XFILLER_0_104_245 VGND VGND VPWR VPWR sky130_fd_sc_hd__decap_6
XFILLER_0_61_187 VPWR VGND VPWR VGND sky130_ef_sc_hd__decap_12
XFILLER_0_104_256 VPWR VGND VPWR VGND sky130_ef_sc_hd__decap_12
XFILLER_0_30_530 VGND VGND VPWR VPWR sky130_fd_sc_hd__fill_2
XFILLER_0_42_390 VGND VGND VPWR VPWR sky130_fd_sc_hd__decap_3
XFILLER_0_100_462 VGND VGND VPWR VPWR sky130_fd_sc_hd__fill_1
Xhold9 bit_sum4\[2\] VGND VGND VPWR VPWR net51 sky130_fd_sc_hd__dlygate4sd3_1
XFILLER_0_97_596 VPWR VGND VPWR VGND sky130_ef_sc_hd__decap_12
XFILLER_0_57_405 VGND VGND VPWR VPWR sky130_fd_sc_hd__decap_8
XFILLER_0_29_107 VGND VGND VPWR VPWR sky130_fd_sc_hd__fill_1
XFILLER_0_57_449 VGND VGND VPWR VPWR sky130_fd_sc_hd__decap_8
XFILLER_0_65_493 VGND VGND VPWR VPWR sky130_fd_sc_hd__decap_4
XFILLER_0_38_696 VGND VGND VPWR VPWR sky130_fd_sc_hd__decap_4
XFILLER_0_52_121 VPWR VGND VPWR VGND sky130_ef_sc_hd__decap_12
XFILLER_0_111_69 VPWR VGND VPWR VGND sky130_ef_sc_hd__decap_12
Xhold409 sum1\[11\] VGND VGND VPWR VPWR net451 sky130_fd_sc_hd__dlygate4sd3_1
XFILLER_0_52_165 VPWR VGND VPWR VGND sky130_ef_sc_hd__decap_12
XFILLER_0_20_45 VGND VGND VPWR VPWR sky130_fd_sc_hd__decap_4
XFILLER_0_123_587 VGND VGND VPWR VPWR sky130_fd_sc_hd__fill_1
XFILLER_0_21_541 VGND VGND VPWR VPWR sky130_fd_sc_hd__decap_3
XFILLER_0_96_38 VPWR VGND VPWR VGND sky130_ef_sc_hd__decap_12
XFILLER_0_96_27 VGND VGND VPWR VPWR sky130_fd_sc_hd__fill_1
XFILLER_0_21_574 VGND VGND VPWR VPWR sky130_fd_sc_hd__fill_2
XTAP_703 VGND VPWR sky130_fd_sc_hd__tapvpwrvgnd_1
XTAP_714 VGND VPWR sky130_fd_sc_hd__tapvpwrvgnd_1
XTAP_725 VGND VPWR sky130_fd_sc_hd__tapvpwrvgnd_1
X_5020_ _2044_ _2049_ _2038_ VGND VGND VPWR VPWR _2050_ sky130_fd_sc_hd__a21o_1
XTAP_736 VGND VPWR sky130_fd_sc_hd__tapvpwrvgnd_1
XTAP_747 VGND VPWR sky130_fd_sc_hd__tapvpwrvgnd_1
XTAP_758 VGND VPWR sky130_fd_sc_hd__tapvpwrvgnd_1
Xclkbuf_leaf_2_clk clknet_3_2__leaf_clk VGND VGND VPWR VPWR clknet_leaf_2_clk sky130_fd_sc_hd__clkbuf_16
XTAP_769 VGND VPWR sky130_fd_sc_hd__tapvpwrvgnd_1
XFILLER_0_88_541 VPWR VGND VPWR VGND sky130_ef_sc_hd__decap_12
X_8710_ clknet_leaf_55_clk _0118_ _0461_ VGND VGND VPWR VPWR bit_sum4\[1\] sky130_fd_sc_hd__dfrtp_1
X_6971_ _3766_ _3895_ _3900_ VGND VGND VPWR VPWR _3958_ sky130_fd_sc_hd__o21ai_2
X_5922_ _2919_ _2921_ _2929_ VGND VGND VPWR VPWR _2931_ sky130_fd_sc_hd__nand3_1
XFILLER_0_76_714 VGND VGND VPWR VPWR sky130_fd_sc_hd__fill_1
XFILLER_0_48_427 VGND VGND VPWR VPWR sky130_fd_sc_hd__decap_4
X_8641_ clknet_leaf_13_clk net98 _0392_ VGND VGND VPWR VPWR s5\[6\] sky130_fd_sc_hd__dfrtp_2
XFILLER_0_61_41 VPWR VGND VPWR VGND sky130_ef_sc_hd__decap_12
XFILLER_0_8_502 VGND VGND VPWR VPWR sky130_fd_sc_hd__decap_8
X_5853_ _2843_ _2854_ _2853_ VGND VGND VPWR VPWR _2865_ sky130_fd_sc_hd__o21ba_1
XFILLER_0_118_326 VPWR VGND VPWR VGND sky130_ef_sc_hd__decap_12
X_4804_ _1644_ _1646_ _1668_ VGND VGND VPWR VPWR _1840_ sky130_fd_sc_hd__o21ai_2
XFILLER_0_63_408 VGND VGND VPWR VPWR sky130_fd_sc_hd__fill_1
X_8572_ clknet_leaf_33_clk _0067_ _0323_ VGND VGND VPWR VPWR sum2\[7\] sky130_fd_sc_hd__dfrtp_1
X_5784_ _2790_ _2791_ VGND VGND VPWR VPWR _2799_ sky130_fd_sc_hd__or2_1
X_7523_ _4160_ VGND VGND VPWR VPWR _0520_ sky130_fd_sc_hd__inv_2
X_4735_ _1770_ _1771_ VGND VGND VPWR VPWR _1772_ sky130_fd_sc_hd__nor2_1
XFILLER_0_8_557 VPWR VGND VPWR VGND sky130_ef_sc_hd__decap_12
XFILLER_0_16_324 VGND VGND VPWR VPWR sky130_fd_sc_hd__decap_3
XFILLER_0_29_685 VPWR VGND VPWR VGND sky130_ef_sc_hd__decap_12
XFILLER_0_43_143 VPWR VGND VPWR VGND sky130_ef_sc_hd__decap_12
X_4666_ _1700_ _1701_ _1684_ _1703_ VGND VGND VPWR VPWR _1704_ sky130_fd_sc_hd__o211ai_2
X_7454_ _4147_ VGND VGND VPWR VPWR _4153_ sky130_fd_sc_hd__buf_4
XFILLER_0_44_699 VGND VGND VPWR VPWR sky130_fd_sc_hd__fill_1
XFILLER_0_114_587 VGND VGND VPWR VPWR sky130_fd_sc_hd__fill_1
X_4597_ sh6\[7\] VGND VGND VPWR VPWR _1636_ sky130_fd_sc_hd__buf_4
XFILLER_0_102_727 VGND VGND VPWR VPWR sky130_fd_sc_hd__decap_8
X_7385_ _4145_ VGND VGND VPWR VPWR _0397_ sky130_fd_sc_hd__inv_2
X_6405_ _3399_ _3401_ _3403_ VGND VGND VPWR VPWR _3404_ sky130_fd_sc_hd__a21o_1
XFILLER_0_12_530 VGND VGND VPWR VPWR sky130_fd_sc_hd__fill_2
X_6336_ _3334_ VGND VGND VPWR VPWR _3335_ sky130_fd_sc_hd__buf_2
X_6267_ _3234_ _3241_ _3265_ VGND VGND VPWR VPWR _3270_ sky130_fd_sc_hd__a21o_1
X_6198_ _2886_ _2875_ _3199_ VGND VGND VPWR VPWR _3203_ sky130_fd_sc_hd__a21o_1
X_8006_ _0799_ _0854_ _0795_ VGND VGND VPWR VPWR _0855_ sky130_fd_sc_hd__o21ai_2
X_5218_ _2243_ _2244_ _2183_ VGND VGND VPWR VPWR _2246_ sky130_fd_sc_hd__nand3_4
X_5149_ _2069_ _2068_ _2073_ sh14\[2\] VGND VGND VPWR VPWR _2178_ sky130_fd_sc_hd__o211a_1
XFILLER_0_67_725 VGND VGND VPWR VPWR sky130_fd_sc_hd__decap_3
XFILLER_0_39_416 VGND VGND VPWR VPWR sky130_fd_sc_hd__fill_2
X_8839_ clknet_leaf_4_clk net294 _0590_ VGND VGND VPWR VPWR sh11\[3\] sky130_fd_sc_hd__dfrtp_4
XFILLER_0_39_449 VGND VGND VPWR VPWR sky130_fd_sc_hd__fill_1
XFILLER_0_34_110 VPWR VGND VPWR VGND sky130_ef_sc_hd__decap_12
XFILLER_0_62_452 VGND VGND VPWR VPWR sky130_fd_sc_hd__decap_6
XFILLER_0_120_524 VGND VGND VPWR VPWR sky130_fd_sc_hd__decap_8
XFILLER_0_82_29 VPWR VGND VPWR VGND sky130_ef_sc_hd__decap_12
XFILLER_0_85_500 VGND VGND VPWR VPWR sky130_fd_sc_hd__decap_4
XFILLER_0_97_382 VGND VGND VPWR VPWR sky130_fd_sc_hd__decap_6
XFILLER_0_57_279 VGND VGND VPWR VPWR sky130_fd_sc_hd__fill_1
XFILLER_0_26_622 VGND VGND VPWR VPWR sky130_fd_sc_hd__fill_1
XFILLER_0_25_121 VGND VGND VPWR VPWR sky130_fd_sc_hd__decap_8
X_4520_ _1492_ _1498_ _1563_ VGND VGND VPWR VPWR _1564_ sky130_fd_sc_hd__a21o_1
X_4451_ _1494_ _1495_ _1488_ VGND VGND VPWR VPWR _1496_ sky130_fd_sc_hd__nand3_1
XFILLER_0_103_3 VPWR VGND VPWR VGND sky130_ef_sc_hd__decap_12
Xhold206 sum2\[10\] VGND VGND VPWR VPWR net248 sky130_fd_sc_hd__dlygate4sd3_1
Xhold217 carry3\[5\] VGND VGND VPWR VPWR net259 sky130_fd_sc_hd__dlygate4sd3_1
XFILLER_0_13_349 VPWR VGND VPWR VGND sky130_ef_sc_hd__decap_12
Xhold228 _0670_ VGND VGND VPWR VPWR net270 sky130_fd_sc_hd__dlygate4sd3_1
Xhold239 sum4\[9\] VGND VGND VPWR VPWR net281 sky130_fd_sc_hd__dlygate4sd3_1
X_7170_ _4124_ VGND VGND VPWR VPWR _0203_ sky130_fd_sc_hd__inv_2
XFILLER_0_0_221 VGND VGND VPWR VPWR sky130_fd_sc_hd__decap_3
XFILLER_0_41_669 VGND VGND VPWR VPWR sky130_fd_sc_hd__decap_3
X_4382_ _1277_ _1426_ _1427_ VGND VGND VPWR VPWR _1428_ sky130_fd_sc_hd__o21ai_2
X_6121_ _3126_ _3127_ _2868_ VGND VGND VPWR VPWR _3128_ sky130_fd_sc_hd__a21oi_1
XTAP_500 VGND VPWR sky130_fd_sc_hd__tapvpwrvgnd_1
XFILLER_0_0_265 VPWR VGND VPWR VGND sky130_ef_sc_hd__decap_12
XTAP_522 VGND VPWR sky130_fd_sc_hd__tapvpwrvgnd_1
XTAP_511 VGND VPWR sky130_fd_sc_hd__tapvpwrvgnd_1
XTAP_533 VGND VPWR sky130_fd_sc_hd__tapvpwrvgnd_1
X_6052_ _3045_ _3052_ _3057_ VGND VGND VPWR VPWR _3060_ sky130_fd_sc_hd__o21ai_1
XTAP_544 VGND VPWR sky130_fd_sc_hd__tapvpwrvgnd_1
XTAP_555 VGND VPWR sky130_fd_sc_hd__tapvpwrvgnd_1
XTAP_566 VGND VPWR sky130_fd_sc_hd__tapvpwrvgnd_1
X_5003_ _2032_ _2034_ VGND VGND VPWR VPWR _0188_ sky130_fd_sc_hd__nand2_1
XTAP_577 VGND VPWR sky130_fd_sc_hd__tapvpwrvgnd_1
XTAP_588 VGND VPWR sky130_fd_sc_hd__tapvpwrvgnd_1
XTAP_599 VGND VPWR sky130_fd_sc_hd__tapvpwrvgnd_1
XFILLER_0_56_85 VPWR VGND VPWR VGND sky130_ef_sc_hd__decap_12
X_6954_ _3930_ _3933_ _3935_ VGND VGND VPWR VPWR _3941_ sky130_fd_sc_hd__o21ai_2
X_5905_ _2878_ _2879_ sh3\[6\] VGND VGND VPWR VPWR _2914_ sky130_fd_sc_hd__o21a_1
XFILLER_0_76_544 VGND VGND VPWR VPWR sky130_fd_sc_hd__fill_2
XFILLER_0_76_566 VGND VGND VPWR VPWR sky130_fd_sc_hd__decap_8
X_6885_ _3866_ _3864_ _3862_ VGND VGND VPWR VPWR _3873_ sky130_fd_sc_hd__a21oi_2
XFILLER_0_48_268 VGND VGND VPWR VPWR sky130_fd_sc_hd__fill_1
X_8624_ clknet_leaf_55_clk net151 _0375_ VGND VGND VPWR VPWR s3\[7\] sky130_fd_sc_hd__dfrtp_1
XFILLER_0_118_123 VGND VGND VPWR VPWR sky130_fd_sc_hd__fill_1
XFILLER_0_63_205 VGND VGND VPWR VPWR sky130_fd_sc_hd__decap_8
XFILLER_0_8_354 VGND VGND VPWR VPWR sky130_fd_sc_hd__fill_2
XFILLER_0_17_600 VGND VGND VPWR VPWR sky130_fd_sc_hd__fill_1
X_5836_ _2849_ _2822_ _2847_ _2820_ VGND VGND VPWR VPWR _2850_ sky130_fd_sc_hd__o211ai_1
X_8555_ clknet_leaf_39_clk _0085_ _0306_ VGND VGND VPWR VPWR sum4\[5\] sky130_fd_sc_hd__dfrtp_1
XFILLER_0_8_365 VGND VGND VPWR VPWR sky130_fd_sc_hd__decap_6
X_5767_ _2778_ _2779_ _2781_ VGND VGND VPWR VPWR _2782_ sky130_fd_sc_hd__a21oi_1
XFILLER_0_17_644 VGND VGND VPWR VPWR sky130_fd_sc_hd__decap_4
XFILLER_0_17_666 VGND VGND VPWR VPWR sky130_fd_sc_hd__decap_6
XFILLER_0_29_493 VGND VGND VPWR VPWR sky130_fd_sc_hd__decap_8
X_7506_ _4157_ VGND VGND VPWR VPWR _0506_ sky130_fd_sc_hd__inv_2
X_4718_ _1746_ _1752_ VGND VGND VPWR VPWR _1756_ sky130_fd_sc_hd__nand2_1
X_8486_ clknet_leaf_25_clk net95 _0237_ VGND VGND VPWR VPWR net24 sky130_fd_sc_hd__dfrtp_1
XFILLER_0_16_176 VGND VGND VPWR VPWR sky130_fd_sc_hd__fill_2
X_5698_ _2713_ _2714_ _2711_ _2708_ VGND VGND VPWR VPWR _2715_ sky130_fd_sc_hd__o211a_1
X_4649_ _1643_ sh2\[7\] VGND VGND VPWR VPWR _1687_ sky130_fd_sc_hd__and2_1
XFILLER_0_31_113 VPWR VGND VPWR VGND sky130_ef_sc_hd__decap_12
X_7437_ _4151_ VGND VGND VPWR VPWR _0443_ sky130_fd_sc_hd__inv_2
XFILLER_0_102_557 VGND VGND VPWR VPWR sky130_fd_sc_hd__decap_4
X_7368_ _4144_ VGND VGND VPWR VPWR _0381_ sky130_fd_sc_hd__inv_2
XFILLER_0_12_360 VGND VGND VPWR VPWR sky130_fd_sc_hd__decap_4
X_6319_ _3303_ _3305_ VGND VGND VPWR VPWR _3319_ sky130_fd_sc_hd__nand2_1
X_7299_ _4136_ VGND VGND VPWR VPWR _4138_ sky130_fd_sc_hd__buf_4
XFILLER_0_98_168 VPWR VGND VPWR VGND sky130_ef_sc_hd__decap_12
XFILLER_0_79_393 VPWR VGND VPWR VGND sky130_ef_sc_hd__decap_12
XFILLER_0_94_363 VGND VGND VPWR VPWR sky130_fd_sc_hd__fill_1
XFILLER_0_39_246 VGND VGND VPWR VPWR sky130_fd_sc_hd__fill_2
XFILLER_0_109_167 VGND VGND VPWR VPWR sky130_fd_sc_hd__fill_1
XFILLER_0_23_614 VGND VGND VPWR VPWR sky130_fd_sc_hd__fill_2
XFILLER_0_90_580 VGND VGND VPWR VPWR sky130_fd_sc_hd__decap_8
XFILLER_0_23_669 VGND VGND VPWR VPWR sky130_fd_sc_hd__decap_3
XFILLER_0_50_477 VPWR VGND VPWR VGND sky130_ef_sc_hd__decap_12
XFILLER_0_22_179 VGND VGND VPWR VPWR sky130_fd_sc_hd__fill_1
XFILLER_0_120_365 VGND VGND VPWR VPWR sky130_fd_sc_hd__fill_1
XFILLER_0_93_39 VPWR VGND VPWR VGND sky130_ef_sc_hd__decap_12
XFILLER_0_89_113 VGND VGND VPWR VPWR sky130_fd_sc_hd__decap_4
XFILLER_0_26_11 VGND VGND VPWR VPWR sky130_fd_sc_hd__decap_3
XFILLER_0_117_57 VPWR VGND VPWR VGND sky130_ef_sc_hd__decap_12
XFILLER_0_77_319 VPWR VGND VPWR VGND sky130_ef_sc_hd__decap_12
XFILLER_0_58_533 VGND VGND VPWR VPWR sky130_fd_sc_hd__decap_8
X_6670_ _3620_ _3630_ VGND VGND VPWR VPWR _3664_ sky130_fd_sc_hd__nand2_1
XFILLER_0_73_536 VGND VGND VPWR VPWR sky130_fd_sc_hd__fill_1
XFILLER_0_42_65 VPWR VGND VPWR VGND sky130_ef_sc_hd__decap_12
XFILLER_0_45_216 VGND VGND VPWR VPWR sky130_fd_sc_hd__decap_8
X_5621_ _2563_ _2558_ _2569_ _2631_ _2636_ VGND VGND VPWR VPWR _2639_ sky130_fd_sc_hd__o2111ai_4
XFILLER_0_5_302 VGND VGND VPWR VPWR sky130_fd_sc_hd__decap_3
XFILLER_0_45_249 VPWR VGND VPWR VGND sky130_ef_sc_hd__decap_12
X_8340_ _1167_ _1165_ _1175_ VGND VGND VPWR VPWR _1177_ sky130_fd_sc_hd__and3_1
X_5552_ _2481_ _2511_ _2513_ _2509_ _2516_ VGND VGND VPWR VPWR _2571_ sky130_fd_sc_hd__o221a_1
X_4503_ _1274_ _1384_ sh14\[5\] VGND VGND VPWR VPWR _1547_ sky130_fd_sc_hd__o21ai_4
X_8271_ _1001_ _1081_ _1083_ VGND VGND VPWR VPWR _1115_ sky130_fd_sc_hd__o21ai_1
XFILLER_0_14_636 VGND VGND VPWR VPWR sky130_fd_sc_hd__fill_1
XFILLER_0_14_669 VPWR VGND VPWR VGND sky130_ef_sc_hd__decap_12
X_5483_ _2466_ _2502_ VGND VGND VPWR VPWR _2503_ sky130_fd_sc_hd__nor2_1
XFILLER_0_123_181 VPWR VGND VPWR VGND sky130_ef_sc_hd__decap_12
X_4434_ _1411_ _1476_ _1479_ VGND VGND VPWR VPWR _1480_ sky130_fd_sc_hd__o21a_1
X_7222_ _4130_ VGND VGND VPWR VPWR _0249_ sky130_fd_sc_hd__inv_2
XFILLER_0_1_541 VPWR VGND VPWR VGND sky130_ef_sc_hd__decap_12
X_4365_ _1409_ _1410_ _1407_ VGND VGND VPWR VPWR _1412_ sky130_fd_sc_hd__and3_1
X_7153_ _4121_ VGND VGND VPWR VPWR _4122_ sky130_fd_sc_hd__buf_8
XFILLER_0_6_65 VPWR VGND VPWR VGND sky130_ef_sc_hd__decap_12
XFILLER_0_1_585 VPWR VGND VPWR VGND sky130_ef_sc_hd__decap_12
X_6104_ _3109_ _3110_ VGND VGND VPWR VPWR _3111_ sky130_fd_sc_hd__nand2_1
XTAP_341 VGND VPWR sky130_fd_sc_hd__tapvpwrvgnd_1
X_7084_ _3797_ _3740_ _4017_ VGND VGND VPWR VPWR _4068_ sky130_fd_sc_hd__o21a_1
XTAP_330 VGND VPWR sky130_fd_sc_hd__tapvpwrvgnd_1
X_6035_ _2976_ _3036_ _3041_ VGND VGND VPWR VPWR _3043_ sky130_fd_sc_hd__nand3b_2
X_4296_ _1261_ _1257_ _1263_ VGND VGND VPWR VPWR _1344_ sky130_fd_sc_hd__o21ai_1
XTAP_385 VGND VPWR sky130_fd_sc_hd__tapvpwrvgnd_1
XTAP_374 VGND VPWR sky130_fd_sc_hd__tapvpwrvgnd_1
XTAP_363 VGND VPWR sky130_fd_sc_hd__tapvpwrvgnd_1
XTAP_352 VGND VPWR sky130_fd_sc_hd__tapvpwrvgnd_1
XTAP_396 VGND VPWR sky130_fd_sc_hd__tapvpwrvgnd_1
XTAP_1529 VGND VPWR sky130_fd_sc_hd__tapvpwrvgnd_1
XTAP_1518 VGND VPWR sky130_fd_sc_hd__tapvpwrvgnd_1
XTAP_1507 VGND VPWR sky130_fd_sc_hd__tapvpwrvgnd_1
XFILLER_0_95_138 VGND VGND VPWR VPWR sky130_fd_sc_hd__decap_6
XPHY_25 VGND VGND VPWR VPWR sky130_fd_sc_hd__decap_3
XPHY_14 VGND VGND VPWR VPWR sky130_fd_sc_hd__decap_3
XPHY_36 VGND VGND VPWR VPWR sky130_fd_sc_hd__decap_3
XPHY_47 VGND VGND VPWR VPWR sky130_fd_sc_hd__decap_3
X_7986_ _0828_ _0833_ _0834_ VGND VGND VPWR VPWR _0835_ sky130_fd_sc_hd__a21oi_2
X_6937_ _3846_ _3908_ _3920_ _3923_ VGND VGND VPWR VPWR _3924_ sky130_fd_sc_hd__o211a_2
XPHY_58 VGND VGND VPWR VPWR sky130_fd_sc_hd__decap_3
XPHY_69 VGND VGND VPWR VPWR sky130_fd_sc_hd__decap_3
XFILLER_0_37_706 VPWR VGND VPWR VGND sky130_ef_sc_hd__decap_12
XFILLER_0_119_432 VGND VGND VPWR VPWR sky130_fd_sc_hd__decap_6
XFILLER_0_64_536 VGND VGND VPWR VPWR sky130_fd_sc_hd__decap_6
XFILLER_0_9_641 VPWR VGND VPWR VGND sky130_ef_sc_hd__decap_12
X_6868_ _3778_ _3780_ _3847_ _3852_ _3743_ VGND VGND VPWR VPWR _3856_ sky130_fd_sc_hd__o2111ai_4
XFILLER_0_52_709 VGND VGND VPWR VPWR sky130_fd_sc_hd__decap_6
XFILLER_0_9_685 VPWR VGND VPWR VGND sky130_ef_sc_hd__decap_12
X_5819_ _2521_ _2672_ _2779_ VGND VGND VPWR VPWR _2833_ sky130_fd_sc_hd__a21oi_1
X_8607_ clknet_leaf_53_clk net83 _0358_ VGND VGND VPWR VPWR s1\[8\] sky130_fd_sc_hd__dfrtp_1
X_8538_ clknet_leaf_31_clk _0072_ _0289_ VGND VGND VPWR VPWR sum3\[12\] sky130_fd_sc_hd__dfrtp_1
XFILLER_0_8_195 VGND VGND VPWR VPWR sky130_fd_sc_hd__fill_1
X_6799_ _3787_ net29 VGND VGND VPWR VPWR _3788_ sky130_fd_sc_hd__and2_1
XFILLER_0_106_159 VPWR VGND VPWR VGND sky130_ef_sc_hd__decap_12
XFILLER_0_32_433 VGND VGND VPWR VPWR sky130_fd_sc_hd__decap_3
XFILLER_0_44_282 VGND VGND VPWR VPWR sky130_fd_sc_hd__decap_6
X_8469_ clknet_leaf_36_clk net139 _0220_ VGND VGND VPWR VPWR s0\[1\] sky130_fd_sc_hd__dfrtp_1
XFILLER_0_102_387 VPWR VGND VPWR VGND sky130_ef_sc_hd__decap_12
XFILLER_0_102_365 VGND VGND VPWR VPWR sky130_fd_sc_hd__decap_8
XFILLER_0_99_433 VPWR VGND VPWR VGND sky130_ef_sc_hd__decap_12
XFILLER_0_87_617 VGND VGND VPWR VPWR sky130_fd_sc_hd__decap_6
XFILLER_0_87_606 VGND VGND VPWR VPWR sky130_fd_sc_hd__fill_2
XFILLER_0_103_15 VGND VGND VPWR VPWR sky130_fd_sc_hd__fill_1
XFILLER_0_82_300 VGND VGND VPWR VPWR sky130_fd_sc_hd__decap_8
XFILLER_0_67_374 VPWR VGND VPWR VGND sky130_ef_sc_hd__decap_12
XFILLER_0_55_503 VGND VGND VPWR VPWR sky130_fd_sc_hd__fill_1
XFILLER_0_94_182 VPWR VGND VPWR VGND sky130_ef_sc_hd__decap_12
XFILLER_0_43_709 VPWR VGND VPWR VGND sky130_ef_sc_hd__decap_12
XFILLER_0_11_617 VGND VGND VPWR VPWR sky130_fd_sc_hd__decap_3
XFILLER_0_121_685 VPWR VGND VPWR VGND sky130_ef_sc_hd__decap_12
XFILLER_0_10_127 VGND VGND VPWR VPWR sky130_fd_sc_hd__fill_1
XFILLER_0_120_195 VGND VGND VPWR VPWR sky130_fd_sc_hd__fill_1
XFILLER_0_37_98 VGND VGND VPWR VPWR sky130_fd_sc_hd__decap_6
XFILLER_0_77_105 VGND VGND VPWR VPWR sky130_fd_sc_hd__decap_6
X_7840_ sum3\[11\] net424 _0705_ VGND VGND VPWR VPWR _0031_ sky130_fd_sc_hd__o21a_1
X_4983_ _1987_ _1988_ VGND VGND VPWR VPWR _2016_ sky130_fd_sc_hd__nand2_1
X_7771_ net269 _0668_ _0669_ VGND VGND VPWR VPWR _0671_ sky130_fd_sc_hd__or3_1
XFILLER_0_77_149 VGND VGND VPWR VPWR sky130_fd_sc_hd__decap_6
XFILLER_0_58_352 VPWR VGND VPWR VGND sky130_ef_sc_hd__decap_12
XFILLER_0_53_75 VPWR VGND VPWR VGND sky130_ef_sc_hd__decap_12
X_6722_ sh0\[1\] VGND VGND VPWR VPWR _3712_ sky130_fd_sc_hd__clkbuf_4
X_6653_ _3478_ _3479_ _3337_ _3541_ VGND VGND VPWR VPWR _3648_ sky130_fd_sc_hd__o22a_1
XFILLER_0_116_446 VGND VGND VPWR VPWR sky130_fd_sc_hd__fill_1
X_5604_ sh1\[0\] sh2\[0\] VGND VGND VPWR VPWR _2622_ sky130_fd_sc_hd__and2_2
X_6584_ _3570_ _3574_ _3578_ VGND VGND VPWR VPWR _3580_ sky130_fd_sc_hd__a21o_1
X_8323_ sum5\[8\] s7\[8\] _1139_ VGND VGND VPWR VPWR _1161_ sky130_fd_sc_hd__a21bo_1
XFILLER_0_6_699 VGND VGND VPWR VPWR sky130_fd_sc_hd__fill_1
X_5535_ _2479_ _2482_ VGND VGND VPWR VPWR _2554_ sky130_fd_sc_hd__and2_2
XFILLER_0_112_641 VGND VGND VPWR VPWR sky130_fd_sc_hd__decap_3
XFILLER_0_75_3 VPWR VGND VPWR VGND sky130_ef_sc_hd__decap_12
X_8254_ _1098_ VGND VGND VPWR VPWR _0114_ sky130_fd_sc_hd__clkbuf_1
X_5466_ _2478_ _2485_ _2482_ VGND VGND VPWR VPWR _2486_ sky130_fd_sc_hd__nand3b_2
XFILLER_0_14_477 VPWR VGND VPWR VGND sky130_ef_sc_hd__decap_12
XFILLER_0_41_285 VGND VGND VPWR VPWR sky130_fd_sc_hd__fill_1
X_4417_ _1454_ _1460_ _1462_ VGND VGND VPWR VPWR _1463_ sky130_fd_sc_hd__nand3_4
XFILLER_0_78_83 VGND VGND VPWR VPWR sky130_fd_sc_hd__fill_1
X_7205_ _4128_ VGND VGND VPWR VPWR _0234_ sky130_fd_sc_hd__inv_2
X_8185_ _1000_ _1001_ VGND VGND VPWR VPWR _1031_ sky130_fd_sc_hd__nand2_1
X_5397_ _2313_ _2363_ VGND VGND VPWR VPWR _2422_ sky130_fd_sc_hd__nand2_1
X_4348_ _1393_ _1394_ VGND VGND VPWR VPWR _1395_ sky130_fd_sc_hd__nand2_4
X_7136_ net446 s1\[3\] VGND VGND VPWR VPWR _4113_ sky130_fd_sc_hd__xnor2_1
X_4279_ _1322_ _1325_ _1326_ VGND VGND VPWR VPWR _1327_ sky130_fd_sc_hd__nand3_1
X_7067_ _4050_ _4051_ _3987_ VGND VGND VPWR VPWR _4052_ sky130_fd_sc_hd__nand3b_2
X_6018_ _2890_ _2883_ _2954_ VGND VGND VPWR VPWR _3026_ sky130_fd_sc_hd__o21ai_1
XTAP_1304 VGND VPWR sky130_fd_sc_hd__tapvpwrvgnd_1
XTAP_1348 VGND VPWR sky130_fd_sc_hd__tapvpwrvgnd_1
XTAP_1337 VGND VPWR sky130_fd_sc_hd__tapvpwrvgnd_1
XTAP_1326 VGND VPWR sky130_fd_sc_hd__tapvpwrvgnd_1
XTAP_1315 VGND VPWR sky130_fd_sc_hd__tapvpwrvgnd_1
X_7969_ _0811_ _0814_ _0815_ _0817_ VGND VGND VPWR VPWR _0818_ sky130_fd_sc_hd__o211ai_4
XFILLER_0_49_330 VGND VGND VPWR VPWR sky130_fd_sc_hd__decap_6
XFILLER_0_92_620 VPWR VGND VPWR VGND sky130_ef_sc_hd__decap_12
XTAP_1359 VGND VPWR sky130_fd_sc_hd__tapvpwrvgnd_1
XFILLER_0_91_130 VGND VGND VPWR VPWR sky130_fd_sc_hd__fill_1
XFILLER_0_64_333 VGND VGND VPWR VPWR sky130_fd_sc_hd__fill_1
XFILLER_0_119_273 VGND VGND VPWR VPWR sky130_fd_sc_hd__decap_6
XFILLER_0_107_435 VGND VGND VPWR VPWR sky130_fd_sc_hd__fill_1
XFILLER_0_91_163 VGND VGND VPWR VPWR sky130_fd_sc_hd__decap_4
XFILLER_0_103_685 VPWR VGND VPWR VGND sky130_ef_sc_hd__decap_12
XFILLER_0_60_594 VGND VGND VPWR VPWR sky130_fd_sc_hd__decap_3
XFILLER_0_20_447 VPWR VGND VPWR VGND sky130_ef_sc_hd__decap_12
XFILLER_0_90_29 VPWR VGND VPWR VGND sky130_ef_sc_hd__decap_12
XFILLER_0_87_469 VGND VGND VPWR VPWR sky130_fd_sc_hd__decap_3
XFILLER_0_87_447 VGND VGND VPWR VPWR sky130_fd_sc_hd__fill_1
XFILLER_0_59_149 VGND VGND VPWR VPWR sky130_fd_sc_hd__decap_6
XTAP_1860 VGND VPWR sky130_fd_sc_hd__tapvpwrvgnd_1
XTAP_1882 VGND VPWR sky130_fd_sc_hd__tapvpwrvgnd_1
XTAP_1871 VGND VPWR sky130_fd_sc_hd__tapvpwrvgnd_1
XFILLER_0_67_182 VGND VGND VPWR VPWR sky130_fd_sc_hd__decap_3
XFILLER_0_28_536 VPWR VGND VPWR VGND sky130_ef_sc_hd__decap_12
XFILLER_0_99_27 VGND VGND VPWR VPWR sky130_fd_sc_hd__fill_1
XFILLER_0_82_141 VPWR VGND VPWR VGND sky130_ef_sc_hd__decap_12
XFILLER_0_15_208 VGND VGND VPWR VPWR sky130_fd_sc_hd__fill_1
XFILLER_0_23_263 VPWR VGND VPWR VGND sky130_ef_sc_hd__decap_12
X_5320_ _2344_ _2345_ VGND VGND VPWR VPWR _2346_ sky130_fd_sc_hd__nor2_1
XFILLER_0_51_561 VGND VGND VPWR VPWR sky130_fd_sc_hd__fill_1
XFILLER_0_11_425 VGND VGND VPWR VPWR sky130_fd_sc_hd__decap_6
X_5251_ _2252_ _2261_ _2266_ _2277_ VGND VGND VPWR VPWR _2278_ sky130_fd_sc_hd__o211a_2
X_5182_ _2094_ _2091_ _2209_ VGND VGND VPWR VPWR _2210_ sky130_fd_sc_hd__o21ai_1
XFILLER_0_48_97 VGND VGND VPWR VPWR sky130_fd_sc_hd__decap_4
XFILLER_0_3_55 VGND VGND VPWR VPWR sky130_fd_sc_hd__fill_1
XFILLER_0_64_41 VGND VGND VPWR VPWR sky130_fd_sc_hd__decap_6
X_8872_ clknet_leaf_12_clk net276 _0623_ VGND VGND VPWR VPWR sh15\[4\] sky130_fd_sc_hd__dfrtp_4
X_7823_ carry2\[10\] sum2\[11\] VGND VGND VPWR VPWR _0697_ sky130_fd_sc_hd__xnor2_1
X_7754_ carry4\[10\] net452 VGND VGND VPWR VPWR _0657_ sky130_fd_sc_hd__nor2_1
XFILLER_0_59_683 VGND VGND VPWR VPWR sky130_fd_sc_hd__decap_3
XFILLER_0_46_300 VGND VGND VPWR VPWR sky130_fd_sc_hd__decap_8
X_4966_ _1984_ _1980_ _1983_ _1985_ _1929_ VGND VGND VPWR VPWR _1999_ sky130_fd_sc_hd__a32oi_4
X_6705_ _3696_ _3691_ _3695_ VGND VGND VPWR VPWR _0126_ sky130_fd_sc_hd__a21o_1
XFILLER_0_59_694 VGND VGND VPWR VPWR sky130_fd_sc_hd__fill_1
X_4897_ _1911_ _1917_ _1922_ VGND VGND VPWR VPWR _1932_ sky130_fd_sc_hd__nand3_1
XFILLER_0_73_141 VGND VGND VPWR VPWR sky130_fd_sc_hd__fill_1
X_7685_ _4206_ VGND VGND VPWR VPWR _0000_ sky130_fd_sc_hd__clkbuf_1
X_6636_ _3620_ _3626_ _3630_ VGND VGND VPWR VPWR _3631_ sky130_fd_sc_hd__nand3_2
XFILLER_0_73_185 VGND VGND VPWR VPWR sky130_fd_sc_hd__fill_1
XFILLER_0_61_314 VGND VGND VPWR VPWR sky130_fd_sc_hd__decap_3
XFILLER_0_104_438 VPWR VGND VPWR VGND sky130_ef_sc_hd__decap_12
X_6567_ _3556_ _3555_ sh6\[4\] VGND VGND VPWR VPWR _3563_ sky130_fd_sc_hd__o21ai_1
XFILLER_0_61_347 VGND VGND VPWR VPWR sky130_fd_sc_hd__decap_4
X_8306_ sum5\[7\] s7\[7\] VGND VGND VPWR VPWR _1145_ sky130_fd_sc_hd__nor2_1
X_5518_ _2535_ _2536_ VGND VGND VPWR VPWR _2537_ sky130_fd_sc_hd__nand2_1
XFILLER_0_30_701 VPWR VGND VPWR VGND sky130_ef_sc_hd__decap_12
X_6498_ _3301_ _3492_ _3493_ _3494_ VGND VGND VPWR VPWR _3495_ sky130_fd_sc_hd__o211ai_4
XFILLER_0_100_622 VGND VGND VPWR VPWR sky130_fd_sc_hd__fill_2
X_8237_ _1001_ _1081_ VGND VGND VPWR VPWR _1082_ sky130_fd_sc_hd__nor2_1
X_5449_ sh12\[0\] VGND VGND VPWR VPWR _2469_ sky130_fd_sc_hd__inv_2
X_8168_ _1004_ _1013_ _0776_ VGND VGND VPWR VPWR _1014_ sky130_fd_sc_hd__o21ai_2
X_7119_ _4086_ _4084_ _4085_ _4100_ VGND VGND VPWR VPWR _4102_ sky130_fd_sc_hd__a31o_1
X_8099_ _0929_ _0942_ _0945_ VGND VGND VPWR VPWR _0946_ sky130_fd_sc_hd__nand3_4
XTAP_1123 VGND VPWR sky130_fd_sc_hd__tapvpwrvgnd_1
XTAP_1112 VGND VPWR sky130_fd_sc_hd__tapvpwrvgnd_1
XTAP_1101 VGND VPWR sky130_fd_sc_hd__tapvpwrvgnd_1
XTAP_1156 VGND VPWR sky130_fd_sc_hd__tapvpwrvgnd_1
XTAP_1145 VGND VPWR sky130_fd_sc_hd__tapvpwrvgnd_1
XTAP_1134 VGND VPWR sky130_fd_sc_hd__tapvpwrvgnd_1
XTAP_1189 VGND VPWR sky130_fd_sc_hd__tapvpwrvgnd_1
XTAP_1178 VGND VPWR sky130_fd_sc_hd__tapvpwrvgnd_1
XTAP_1167 VGND VPWR sky130_fd_sc_hd__tapvpwrvgnd_1
XFILLER_0_37_322 VPWR VGND VPWR VGND sky130_ef_sc_hd__decap_12
XFILLER_0_108_733 VGND VGND VPWR VPWR sky130_fd_sc_hd__fill_2
XFILLER_0_64_141 VPWR VGND VPWR VGND sky130_ef_sc_hd__decap_12
XFILLER_0_25_517 VGND VGND VPWR VPWR sky130_fd_sc_hd__fill_2
XFILLER_0_80_645 VGND VGND VPWR VPWR sky130_fd_sc_hd__decap_8
XFILLER_0_65_697 VPWR VGND VPWR VGND sky130_ef_sc_hd__decap_12
XFILLER_0_52_303 VGND VGND VPWR VPWR sky130_fd_sc_hd__decap_4
XFILLER_0_100_27 VGND VGND VPWR VPWR sky130_fd_sc_hd__fill_1
XFILLER_0_33_561 VPWR VGND VPWR VGND sky130_ef_sc_hd__decap_12
XFILLER_0_122_257 VGND VGND VPWR VPWR sky130_fd_sc_hd__fill_1
XFILLER_0_100_49 VGND VGND VPWR VPWR sky130_fd_sc_hd__fill_1
XFILLER_0_0_617 VPWR VGND VPWR VGND sky130_ef_sc_hd__decap_12
XTAP_907 VGND VPWR sky130_fd_sc_hd__tapvpwrvgnd_1
XTAP_918 VGND VPWR sky130_fd_sc_hd__tapvpwrvgnd_1
XTAP_929 VGND VPWR sky130_fd_sc_hd__tapvpwrvgnd_1
XFILLER_0_88_701 VGND VGND VPWR VPWR sky130_fd_sc_hd__decap_3
XFILLER_0_18_89 VPWR VGND VPWR VGND sky130_ef_sc_hd__decap_12
XFILLER_0_87_200 VGND VGND VPWR VPWR sky130_fd_sc_hd__fill_1
X_4820_ _1784_ _1780_ _1786_ VGND VGND VPWR VPWR _1856_ sky130_fd_sc_hd__o21a_1
XFILLER_0_28_300 VGND VGND VPWR VPWR sky130_fd_sc_hd__decap_8
XFILLER_0_7_205 VPWR VGND VPWR VGND sky130_ef_sc_hd__decap_12
XTAP_1690 VGND VPWR sky130_fd_sc_hd__tapvpwrvgnd_1
X_4751_ _1704_ _1715_ VGND VGND VPWR VPWR _1788_ sky130_fd_sc_hd__nand2_1
XFILLER_0_16_506 VGND VGND VPWR VPWR sky130_fd_sc_hd__decap_6
X_4682_ _1719_ VGND VGND VPWR VPWR _1720_ sky130_fd_sc_hd__clkbuf_2
X_7470_ _4154_ VGND VGND VPWR VPWR _0473_ sky130_fd_sc_hd__inv_2
XFILLER_0_83_494 VGND VGND VPWR VPWR sky130_fd_sc_hd__decap_8
XFILLER_0_70_111 VGND VGND VPWR VPWR sky130_fd_sc_hd__fill_2
XFILLER_0_56_697 VGND VGND VPWR VPWR sky130_fd_sc_hd__decap_3
XFILLER_0_28_377 VGND VGND VPWR VPWR sky130_fd_sc_hd__fill_1
XFILLER_0_113_202 VGND VGND VPWR VPWR sky130_fd_sc_hd__decap_6
X_6421_ _3379_ _3380_ _3381_ _3418_ VGND VGND VPWR VPWR _3419_ sky130_fd_sc_hd__a31oi_2
XFILLER_0_3_400 VGND VGND VPWR VPWR sky130_fd_sc_hd__fill_1
XFILLER_0_12_701 VPWR VGND VPWR VGND sky130_ef_sc_hd__decap_12
X_6352_ _3350_ _3347_ _3341_ VGND VGND VPWR VPWR _3351_ sky130_fd_sc_hd__a21oi_1
XFILLER_0_59_52 VGND VGND VPWR VPWR sky130_fd_sc_hd__decap_4
XFILLER_0_11_233 VGND VGND VPWR VPWR sky130_fd_sc_hd__fill_1
XFILLER_0_11_222 VGND VGND VPWR VPWR sky130_fd_sc_hd__fill_2
XFILLER_0_51_380 VPWR VGND VPWR VGND sky130_ef_sc_hd__decap_12
X_6283_ _2948_ VGND VGND VPWR VPWR _3284_ sky130_fd_sc_hd__inv_2
X_5303_ _2327_ _2328_ VGND VGND VPWR VPWR _2329_ sky130_fd_sc_hd__and2_2
X_8022_ _0772_ VGND VGND VPWR VPWR _0870_ sky130_fd_sc_hd__inv_2
X_5234_ _2256_ _2260_ VGND VGND VPWR VPWR _2261_ sky130_fd_sc_hd__nand2_1
X_5165_ _2102_ sh9\[2\] VGND VGND VPWR VPWR _2193_ sky130_fd_sc_hd__nor2_1
XFILLER_0_75_51 VGND VGND VPWR VPWR sky130_fd_sc_hd__decap_4
X_5096_ _2043_ _2042_ _2048_ VGND VGND VPWR VPWR _2125_ sky130_fd_sc_hd__o21ai_2
XFILLER_0_78_233 VGND VGND VPWR VPWR sky130_fd_sc_hd__fill_2
X_8855_ clknet_leaf_2_clk net192 _0606_ VGND VGND VPWR VPWR sh13\[3\] sky130_fd_sc_hd__dfrtp_4
XFILLER_0_39_609 VGND VGND VPWR VPWR sky130_fd_sc_hd__decap_4
XPHY_206 VGND VGND VPWR VPWR sky130_fd_sc_hd__decap_3
X_7806_ s0\[8\] net383 _0688_ VGND VGND VPWR VPWR _0008_ sky130_fd_sc_hd__o21a_1
XPHY_239 VGND VGND VPWR VPWR sky130_fd_sc_hd__decap_3
XPHY_228 VGND VGND VPWR VPWR sky130_fd_sc_hd__decap_3
XFILLER_0_109_508 VPWR VGND VPWR VGND sky130_ef_sc_hd__decap_12
XPHY_217 VGND VGND VPWR VPWR sky130_fd_sc_hd__decap_3
X_5998_ _3000_ _3001_ _3003_ VGND VGND VPWR VPWR _3006_ sky130_fd_sc_hd__o21ai_1
X_8786_ clknet_leaf_7_clk net344 _0537_ VGND VGND VPWR VPWR sh4\[6\] sky130_fd_sc_hd__dfrtp_1
XFILLER_0_93_225 VPWR VGND VPWR VGND sky130_ef_sc_hd__decap_12
XFILLER_0_47_642 VGND VGND VPWR VPWR sky130_fd_sc_hd__decap_4
X_4949_ _1976_ _1978_ _1981_ _1982_ VGND VGND VPWR VPWR _1983_ sky130_fd_sc_hd__o22ai_4
X_7737_ net376 _0643_ VGND VGND VPWR VPWR _0097_ sky130_fd_sc_hd__nand2_1
XFILLER_0_19_355 VPWR VGND VPWR VGND sky130_ef_sc_hd__decap_12
X_7668_ _4192_ _4193_ VGND VGND VPWR VPWR _0080_ sky130_fd_sc_hd__nand2_1
X_6619_ _3611_ _3613_ VGND VGND VPWR VPWR _3614_ sky130_fd_sc_hd__nor2_1
XFILLER_0_34_336 VGND VGND VPWR VPWR sky130_fd_sc_hd__fill_1
X_7599_ _4167_ VGND VGND VPWR VPWR _0589_ sky130_fd_sc_hd__inv_2
XFILLER_0_61_199 VGND VGND VPWR VPWR sky130_fd_sc_hd__fill_2
XFILLER_0_69_233 VGND VGND VPWR VPWR sky130_fd_sc_hd__decap_6
XFILLER_0_84_225 VGND VGND VPWR VPWR sky130_fd_sc_hd__decap_6
XFILLER_0_65_461 VGND VGND VPWR VPWR sky130_fd_sc_hd__decap_4
XFILLER_0_111_37 VGND VGND VPWR VPWR sky130_fd_sc_hd__decap_6
XFILLER_0_108_563 VGND VGND VPWR VPWR sky130_fd_sc_hd__decap_8
XFILLER_0_53_667 VGND VGND VPWR VPWR sky130_fd_sc_hd__decap_4
XFILLER_0_52_133 VGND VGND VPWR VPWR sky130_fd_sc_hd__decap_6
XFILLER_0_123_533 VPWR VGND VPWR VGND sky130_ef_sc_hd__decap_12
XFILLER_0_52_177 VPWR VGND VPWR VGND sky130_ef_sc_hd__decap_12
XFILLER_0_40_317 VGND VGND VPWR VPWR sky130_fd_sc_hd__fill_2
XFILLER_0_111_706 VPWR VGND VPWR VGND sky130_ef_sc_hd__decap_12
XFILLER_0_21_553 VGND VGND VPWR VPWR sky130_fd_sc_hd__decap_6
XTAP_704 VGND VPWR sky130_fd_sc_hd__tapvpwrvgnd_1
XTAP_715 VGND VPWR sky130_fd_sc_hd__tapvpwrvgnd_1
XFILLER_0_29_55 VGND VGND VPWR VPWR sky130_fd_sc_hd__fill_1
XTAP_726 VGND VPWR sky130_fd_sc_hd__tapvpwrvgnd_1
XTAP_737 VGND VPWR sky130_fd_sc_hd__tapvpwrvgnd_1
XTAP_748 VGND VPWR sky130_fd_sc_hd__tapvpwrvgnd_1
XTAP_759 VGND VPWR sky130_fd_sc_hd__tapvpwrvgnd_1
X_6970_ _3953_ sh15\[1\] VGND VGND VPWR VPWR _3957_ sky130_fd_sc_hd__nand2_1
X_5921_ _2919_ _2921_ _2929_ VGND VGND VPWR VPWR _2930_ sky130_fd_sc_hd__a21o_1
XFILLER_0_88_531 VGND VGND VPWR VPWR sky130_fd_sc_hd__fill_1
X_8640_ clknet_leaf_13_clk net112 _0391_ VGND VGND VPWR VPWR s5\[5\] sky130_fd_sc_hd__dfrtp_1
X_5852_ _2851_ _2771_ _2857_ VGND VGND VPWR VPWR _2864_ sky130_fd_sc_hd__a21boi_1
XFILLER_0_118_338 VGND VGND VPWR VPWR sky130_fd_sc_hd__decap_8
X_4803_ _1678_ _1676_ _1791_ VGND VGND VPWR VPWR _1839_ sky130_fd_sc_hd__o21bai_4
XFILLER_0_91_729 VGND VGND VPWR VPWR sky130_fd_sc_hd__decap_6
XFILLER_0_61_53 VGND VGND VPWR VPWR sky130_fd_sc_hd__decap_3
X_8571_ clknet_leaf_34_clk _0066_ _0322_ VGND VGND VPWR VPWR sum2\[6\] sky130_fd_sc_hd__dfrtp_1
X_5783_ _2793_ _2794_ _2795_ _2797_ VGND VGND VPWR VPWR _2798_ sky130_fd_sc_hd__o211a_1
XFILLER_0_29_653 VPWR VGND VPWR VGND sky130_ef_sc_hd__decap_12
X_4734_ sh4\[7\] sh5\[7\] VGND VGND VPWR VPWR _1771_ sky130_fd_sc_hd__and2_1
XFILLER_0_90_239 VPWR VGND VPWR VGND sky130_ef_sc_hd__decap_12
X_7522_ _4160_ VGND VGND VPWR VPWR _0519_ sky130_fd_sc_hd__inv_2
XFILLER_0_56_483 VGND VGND VPWR VPWR sky130_fd_sc_hd__fill_1
XFILLER_0_8_569 VPWR VGND VPWR VGND sky130_ef_sc_hd__decap_12
XFILLER_0_28_174 VGND VGND VPWR VPWR sky130_fd_sc_hd__decap_4
XFILLER_0_29_697 VPWR VGND VPWR VGND sky130_ef_sc_hd__decap_12
XFILLER_0_43_100 VGND VGND VPWR VPWR sky130_fd_sc_hd__fill_1
XFILLER_0_16_347 VPWR VGND VPWR VGND sky130_ef_sc_hd__decap_12
XFILLER_0_43_111 VGND VGND VPWR VPWR sky130_fd_sc_hd__fill_1
XFILLER_0_44_645 VPWR VGND VPWR VGND sky130_ef_sc_hd__decap_12
X_4665_ _1701_ _1702_ _1649_ VGND VGND VPWR VPWR _1703_ sky130_fd_sc_hd__o21bai_2
X_7453_ _4152_ VGND VGND VPWR VPWR _0458_ sky130_fd_sc_hd__inv_2
XFILLER_0_43_155 VGND VGND VPWR VPWR sky130_fd_sc_hd__decap_4
X_4596_ _1344_ _1634_ _1635_ _1350_ VGND VGND VPWR VPWR _0127_ sky130_fd_sc_hd__a22oi_1
X_7384_ _4145_ VGND VGND VPWR VPWR _0396_ sky130_fd_sc_hd__inv_2
X_6404_ _3360_ _3288_ _3359_ _3402_ VGND VGND VPWR VPWR _3403_ sky130_fd_sc_hd__a31o_1
XFILLER_0_101_238 VGND VGND VPWR VPWR sky130_fd_sc_hd__decap_4
X_6335_ sh7\[4\] net33 VGND VGND VPWR VPWR _3334_ sky130_fd_sc_hd__and2_1
XFILLER_0_12_564 VGND VGND VPWR VPWR sky130_fd_sc_hd__decap_3
X_6266_ _3239_ _3231_ _3235_ VGND VGND VPWR VPWR _3269_ sky130_fd_sc_hd__and3_1
XFILLER_0_86_83 VGND VGND VPWR VPWR sky130_fd_sc_hd__fill_1
X_8005_ _0751_ _0794_ sh14\[3\] VGND VGND VPWR VPWR _0854_ sky130_fd_sc_hd__o21a_1
X_6197_ _3138_ _3197_ _3198_ _3199_ _3201_ VGND VGND VPWR VPWR _3202_ sky130_fd_sc_hd__o221ai_4
X_5217_ _2186_ _2187_ _2243_ _2244_ VGND VGND VPWR VPWR _2245_ sky130_fd_sc_hd__a22o_1
XFILLER_0_98_306 VGND VGND VPWR VPWR sky130_fd_sc_hd__fill_2
X_5148_ _2175_ _2167_ _2174_ VGND VGND VPWR VPWR _2177_ sky130_fd_sc_hd__nand3b_2
X_5079_ _2103_ _2105_ _2107_ VGND VGND VPWR VPWR _2108_ sky130_fd_sc_hd__o21a_1
X_8838_ clknet_leaf_59_clk net190 _0589_ VGND VGND VPWR VPWR sh11\[2\] sky130_fd_sc_hd__dfrtp_1
X_8769_ clknet_leaf_10_clk net175 _0520_ VGND VGND VPWR VPWR sh2\[5\] sky130_fd_sc_hd__dfrtp_4
XFILLER_0_109_316 VGND VGND VPWR VPWR sky130_fd_sc_hd__decap_3
XFILLER_0_94_589 VPWR VGND VPWR VGND sky130_ef_sc_hd__decap_12
XFILLER_0_35_623 VGND VGND VPWR VPWR sky130_fd_sc_hd__fill_2
XFILLER_0_105_511 VGND VGND VPWR VPWR sky130_fd_sc_hd__fill_1
XFILLER_0_105_500 VGND VGND VPWR VPWR sky130_fd_sc_hd__decap_4
XFILLER_0_34_122 VGND VGND VPWR VPWR sky130_fd_sc_hd__fill_2
XFILLER_0_35_634 VPWR VGND VPWR VGND sky130_ef_sc_hd__decap_12
XFILLER_0_117_393 VGND VGND VPWR VPWR sky130_fd_sc_hd__fill_1
XFILLER_0_62_475 VGND VGND VPWR VPWR sky130_fd_sc_hd__fill_1
XFILLER_0_50_659 VGND VGND VPWR VPWR sky130_fd_sc_hd__decap_4
XFILLER_0_105_588 VPWR VGND VPWR VGND sky130_ef_sc_hd__decap_12
XFILLER_0_100_293 VGND VGND VPWR VPWR sky130_fd_sc_hd__fill_1
XFILLER_0_106_15 VPWR VGND VPWR VGND sky130_ef_sc_hd__decap_12
XFILLER_0_97_350 VGND VGND VPWR VPWR sky130_fd_sc_hd__fill_1
XFILLER_0_15_57 VPWR VGND VPWR VGND sky130_ef_sc_hd__decap_12
XFILLER_0_57_236 VGND VGND VPWR VPWR sky130_fd_sc_hd__decap_4
XFILLER_0_57_225 VGND VGND VPWR VPWR sky130_fd_sc_hd__fill_1
XFILLER_0_73_718 VGND VGND VPWR VPWR sky130_fd_sc_hd__decap_8
XFILLER_0_57_269 VGND VGND VPWR VPWR sky130_fd_sc_hd__fill_2
XFILLER_0_26_645 VGND VGND VPWR VPWR sky130_fd_sc_hd__fill_1
X_4450_ _1231_ sh5\[5\] VGND VGND VPWR VPWR _1495_ sky130_fd_sc_hd__or2_1
XFILLER_0_111_503 VGND VGND VPWR VPWR sky130_fd_sc_hd__fill_1
Xhold207 _0020_ VGND VGND VPWR VPWR net249 sky130_fd_sc_hd__dlygate4sd3_1
X_4381_ _1277_ _1278_ _1384_ VGND VGND VPWR VPWR _1427_ sky130_fd_sc_hd__o21ai_1
Xhold229 s4\[10\] VGND VGND VPWR VPWR net271 sky130_fd_sc_hd__dlygate4sd3_1
Xhold218 _0036_ VGND VGND VPWR VPWR net260 sky130_fd_sc_hd__dlygate4sd3_1
X_6120_ _2977_ _3057_ _3052_ _3045_ VGND VGND VPWR VPWR _3127_ sky130_fd_sc_hd__o2bb2a_1
XFILLER_0_0_277 VGND VGND VPWR VPWR sky130_fd_sc_hd__decap_3
XTAP_501 VGND VPWR sky130_fd_sc_hd__tapvpwrvgnd_1
XTAP_523 VGND VPWR sky130_fd_sc_hd__tapvpwrvgnd_1
XTAP_512 VGND VPWR sky130_fd_sc_hd__tapvpwrvgnd_1
XTAP_534 VGND VPWR sky130_fd_sc_hd__tapvpwrvgnd_1
X_6051_ _3045_ _3052_ _3057_ _3058_ VGND VGND VPWR VPWR _3059_ sky130_fd_sc_hd__o211ai_2
XTAP_545 VGND VPWR sky130_fd_sc_hd__tapvpwrvgnd_1
XTAP_556 VGND VPWR sky130_fd_sc_hd__tapvpwrvgnd_1
XTAP_567 VGND VPWR sky130_fd_sc_hd__tapvpwrvgnd_1
X_5002_ _2025_ _2026_ _2033_ VGND VGND VPWR VPWR _2034_ sky130_fd_sc_hd__nand3_1
XTAP_578 VGND VPWR sky130_fd_sc_hd__tapvpwrvgnd_1
XTAP_589 VGND VPWR sky130_fd_sc_hd__tapvpwrvgnd_1
XFILLER_0_56_97 VPWR VGND VPWR VGND sky130_ef_sc_hd__decap_12
XFILLER_0_72_41 VGND VGND VPWR VPWR sky130_fd_sc_hd__fill_2
X_6953_ _3920_ _3923_ _3925_ VGND VGND VPWR VPWR _3940_ sky130_fd_sc_hd__a21o_1
X_5904_ _2910_ _2909_ _2912_ VGND VGND VPWR VPWR _2913_ sky130_fd_sc_hd__o21ai_4
X_6884_ _3859_ _3860_ _3862_ _3864_ VGND VGND VPWR VPWR _3872_ sky130_fd_sc_hd__o211a_2
Xclkbuf_3_5__f_clk clknet_0_clk VGND VGND VPWR VPWR clknet_3_5__leaf_clk sky130_fd_sc_hd__clkbuf_16
X_8623_ clknet_leaf_54_clk net140 _0374_ VGND VGND VPWR VPWR s3\[6\] sky130_fd_sc_hd__dfrtp_1
X_5835_ _2809_ VGND VGND VPWR VPWR _2849_ sky130_fd_sc_hd__inv_2
XFILLER_0_118_146 VPWR VGND VPWR VGND sky130_ef_sc_hd__decap_12
XFILLER_0_76_589 VPWR VGND VPWR VGND sky130_ef_sc_hd__decap_12
X_8554_ clknet_leaf_39_clk _0084_ _0305_ VGND VGND VPWR VPWR sum4\[4\] sky130_fd_sc_hd__dfrtp_1
X_5766_ _2778_ _2780_ sh14\[0\] VGND VGND VPWR VPWR _2781_ sky130_fd_sc_hd__a21oi_1
X_7505_ _4157_ VGND VGND VPWR VPWR _0505_ sky130_fd_sc_hd__inv_2
X_4717_ _1734_ _1750_ _1729_ VGND VGND VPWR VPWR _1755_ sky130_fd_sc_hd__nand3_1
X_8485_ clknet_leaf_40_clk net124 _0236_ VGND VGND VPWR VPWR net23 sky130_fd_sc_hd__dfrtp_1
X_5697_ _2666_ _2698_ _2701_ VGND VGND VPWR VPWR _2714_ sky130_fd_sc_hd__and3_1
X_4648_ _1650_ _1651_ _1685_ VGND VGND VPWR VPWR _1686_ sky130_fd_sc_hd__o21a_1
X_7436_ _4151_ VGND VGND VPWR VPWR _0442_ sky130_fd_sc_hd__inv_2
XFILLER_0_102_514 VGND VGND VPWR VPWR sky130_fd_sc_hd__decap_3
XFILLER_0_4_583 VGND VGND VPWR VPWR sky130_fd_sc_hd__fill_2
XFILLER_0_31_169 VPWR VGND VPWR VGND sky130_ef_sc_hd__decap_12
X_4579_ _1616_ _1617_ _1534_ _1589_ VGND VGND VPWR VPWR _1621_ sky130_fd_sc_hd__o211a_1
X_7367_ _4144_ VGND VGND VPWR VPWR _0380_ sky130_fd_sc_hd__inv_2
X_6318_ _3314_ _3316_ _3317_ VGND VGND VPWR VPWR _3318_ sky130_fd_sc_hd__a21oi_1
X_7298_ _4137_ VGND VGND VPWR VPWR _0318_ sky130_fd_sc_hd__inv_2
X_6249_ _3218_ _3215_ _3251_ net26 VGND VGND VPWR VPWR _3253_ sky130_fd_sc_hd__o22ai_4
XFILLER_0_99_604 VGND VGND VPWR VPWR sky130_fd_sc_hd__decap_4
XFILLER_0_99_615 VGND VGND VPWR VPWR sky130_fd_sc_hd__fill_1
XFILLER_0_86_309 VPWR VGND VPWR VGND sky130_ef_sc_hd__decap_12
XFILLER_0_94_386 VGND VGND VPWR VPWR sky130_fd_sc_hd__fill_2
XFILLER_0_82_515 VPWR VGND VPWR VGND sky130_ef_sc_hd__decap_12
XFILLER_0_55_729 VGND VGND VPWR VPWR sky130_fd_sc_hd__decap_6
XFILLER_0_50_401 VPWR VGND VPWR VGND sky130_ef_sc_hd__decap_12
XFILLER_0_105_352 VPWR VGND VPWR VGND sky130_ef_sc_hd__decap_12
XFILLER_0_120_322 VGND VGND VPWR VPWR sky130_fd_sc_hd__decap_3
XFILLER_0_10_309 VPWR VGND VPWR VGND sky130_ef_sc_hd__decap_12
XFILLER_0_50_489 VPWR VGND VPWR VGND sky130_ef_sc_hd__decap_12
XFILLER_0_101_591 VGND VGND VPWR VPWR sky130_fd_sc_hd__decap_6
XFILLER_0_117_69 VGND VGND VPWR VPWR sky130_fd_sc_hd__fill_2
Xhold90 bit_sum4\[4\] VGND VGND VPWR VPWR net132 sky130_fd_sc_hd__dlygate4sd3_1
XFILLER_0_89_169 VGND VGND VPWR VPWR sky130_fd_sc_hd__decap_8
XFILLER_0_58_589 VGND VGND VPWR VPWR sky130_fd_sc_hd__fill_1
XFILLER_0_42_77 VGND VGND VPWR VPWR sky130_fd_sc_hd__decap_6
X_5620_ _2631_ _2636_ _2637_ VGND VGND VPWR VPWR _2638_ sky130_fd_sc_hd__a21o_1
X_5551_ _2563_ _2569_ VGND VGND VPWR VPWR _2570_ sky130_fd_sc_hd__nand2_1
XFILLER_0_26_475 VGND VGND VPWR VPWR sky130_fd_sc_hd__fill_1
X_4502_ _1544_ _1545_ sh14\[5\] VGND VGND VPWR VPWR _1546_ sky130_fd_sc_hd__o21ba_1
X_8270_ _1110_ _1112_ _1072_ VGND VGND VPWR VPWR _1114_ sky130_fd_sc_hd__nand3_2
XFILLER_0_53_261 VGND VGND VPWR VPWR sky130_fd_sc_hd__decap_3
XFILLER_0_5_369 VPWR VGND VPWR VGND sky130_ef_sc_hd__decap_12
XFILLER_0_14_626 VGND VGND VPWR VPWR sky130_fd_sc_hd__fill_1
X_7221_ _4125_ VGND VGND VPWR VPWR _4130_ sky130_fd_sc_hd__buf_4
X_5482_ _2476_ _2501_ VGND VGND VPWR VPWR _2502_ sky130_fd_sc_hd__xor2_1
XFILLER_0_41_456 VGND VGND VPWR VPWR sky130_fd_sc_hd__decap_3
XFILLER_0_123_193 VGND VGND VPWR VPWR sky130_fd_sc_hd__decap_3
X_4433_ _1477_ sh15\[5\] _1478_ VGND VGND VPWR VPWR _1479_ sky130_fd_sc_hd__nand3_1
XFILLER_0_1_553 VGND VGND VPWR VPWR sky130_fd_sc_hd__decap_6
XFILLER_0_111_355 VPWR VGND VPWR VGND sky130_ef_sc_hd__decap_12
X_4364_ _1407_ _1409_ _1410_ VGND VGND VPWR VPWR _1411_ sky130_fd_sc_hd__a21oi_2
X_7152_ net1 VGND VGND VPWR VPWR _4121_ sky130_fd_sc_hd__clkbuf_4
X_6103_ _3036_ _3041_ _2906_ sh12\[6\] VGND VGND VPWR VPWR _3110_ sky130_fd_sc_hd__nand4_1
X_4295_ _1340_ _1337_ _1342_ VGND VGND VPWR VPWR _1343_ sky130_fd_sc_hd__or3b_1
XTAP_342 VGND VPWR sky130_fd_sc_hd__tapvpwrvgnd_1
XFILLER_0_6_77 VGND VGND VPWR VPWR sky130_fd_sc_hd__decap_6
XTAP_331 VGND VPWR sky130_fd_sc_hd__tapvpwrvgnd_1
XTAP_320 VGND VPWR sky130_fd_sc_hd__tapvpwrvgnd_1
XFILLER_0_1_597 VPWR VGND VPWR VGND sky130_ef_sc_hd__decap_12
X_7083_ _4033_ _4029_ VGND VGND VPWR VPWR _4067_ sky130_fd_sc_hd__nand2_1
X_6034_ _3036_ _3041_ _2976_ VGND VGND VPWR VPWR _3042_ sky130_fd_sc_hd__a21bo_1
XTAP_375 VGND VPWR sky130_fd_sc_hd__tapvpwrvgnd_1
XTAP_364 VGND VPWR sky130_fd_sc_hd__tapvpwrvgnd_1
XTAP_353 VGND VPWR sky130_fd_sc_hd__tapvpwrvgnd_1
XTAP_397 VGND VPWR sky130_fd_sc_hd__tapvpwrvgnd_1
XTAP_386 VGND VPWR sky130_fd_sc_hd__tapvpwrvgnd_1
XFILLER_0_83_51 VGND VGND VPWR VPWR sky130_fd_sc_hd__decap_4
XFILLER_0_68_309 VGND VGND VPWR VPWR sky130_fd_sc_hd__decap_8
X_7985_ _0785_ _0783_ _0790_ _0789_ VGND VGND VPWR VPWR _0834_ sky130_fd_sc_hd__o2bb2ai_4
XFILLER_0_49_501 VGND VGND VPWR VPWR sky130_fd_sc_hd__decap_3
XTAP_1519 VGND VPWR sky130_fd_sc_hd__tapvpwrvgnd_1
XTAP_1508 VGND VPWR sky130_fd_sc_hd__tapvpwrvgnd_1
XFILLER_0_95_117 VGND VGND VPWR VPWR sky130_fd_sc_hd__fill_1
XFILLER_0_89_670 VGND VGND VPWR VPWR sky130_fd_sc_hd__fill_2
XPHY_26 VGND VGND VPWR VPWR sky130_fd_sc_hd__decap_3
X_6936_ _3919_ _3915_ _3921_ _3922_ VGND VGND VPWR VPWR _3923_ sky130_fd_sc_hd__o2bb2ai_4
XPHY_15 VGND VGND VPWR VPWR sky130_fd_sc_hd__decap_3
XPHY_37 VGND VGND VPWR VPWR sky130_fd_sc_hd__decap_3
XFILLER_0_88_180 VPWR VGND VPWR VGND sky130_ef_sc_hd__decap_12
XPHY_48 VGND VGND VPWR VPWR sky130_fd_sc_hd__decap_3
XPHY_59 VGND VGND VPWR VPWR sky130_fd_sc_hd__decap_3
XFILLER_0_76_386 VGND VGND VPWR VPWR sky130_fd_sc_hd__decap_4
XFILLER_0_64_526 VGND VGND VPWR VPWR sky130_fd_sc_hd__decap_6
XFILLER_0_9_653 VPWR VGND VPWR VGND sky130_ef_sc_hd__decap_12
X_6867_ _3847_ _3852_ _3853_ _3854_ VGND VGND VPWR VPWR _3855_ sky130_fd_sc_hd__o2bb2ai_2
XFILLER_0_37_718 VGND VGND VPWR VPWR sky130_fd_sc_hd__decap_8
XFILLER_0_37_729 VGND VGND VPWR VPWR sky130_fd_sc_hd__decap_6
XFILLER_0_107_617 VPWR VGND VPWR VGND sky130_ef_sc_hd__decap_12
XFILLER_0_91_334 VGND VGND VPWR VPWR sky130_fd_sc_hd__fill_2
XFILLER_0_91_323 VGND VGND VPWR VPWR sky130_fd_sc_hd__decap_8
XFILLER_0_8_141 VPWR VGND VPWR VGND sky130_ef_sc_hd__decap_12
X_5818_ _2826_ _2773_ _2783_ _2786_ _2777_ VGND VGND VPWR VPWR _2832_ sky130_fd_sc_hd__a221o_1
XFILLER_0_17_420 VGND VGND VPWR VPWR sky130_fd_sc_hd__fill_1
X_6798_ sh11\[1\] VGND VGND VPWR VPWR _3787_ sky130_fd_sc_hd__buf_2
X_8606_ clknet_leaf_52_clk net73 _0357_ VGND VGND VPWR VPWR s1\[7\] sky130_fd_sc_hd__dfrtp_1
XFILLER_0_91_378 VGND VGND VPWR VPWR sky130_fd_sc_hd__fill_2
X_8537_ clknet_leaf_31_clk net307 _0288_ VGND VGND VPWR VPWR sum3\[11\] sky130_fd_sc_hd__dfrtp_1
XFILLER_0_9_697 VPWR VGND VPWR VGND sky130_ef_sc_hd__decap_12
X_5749_ _2762_ _2763_ _2764_ VGND VGND VPWR VPWR _2765_ sky130_fd_sc_hd__nand3b_4
XFILLER_0_60_721 VGND VGND VPWR VPWR sky130_fd_sc_hd__decap_6
XFILLER_0_44_261 VGND VGND VPWR VPWR sky130_fd_sc_hd__fill_1
X_8468_ clknet_leaf_36_clk net143 _0219_ VGND VGND VPWR VPWR s0\[0\] sky130_fd_sc_hd__dfrtp_1
X_8399_ sh10\[5\] _1227_ _1228_ VGND VGND VPWR VPWR _1229_ sky130_fd_sc_hd__a21o_2
XFILLER_0_20_629 VGND VGND VPWR VPWR sky130_fd_sc_hd__decap_3
X_7419_ _4149_ VGND VGND VPWR VPWR _0427_ sky130_fd_sc_hd__inv_2
XFILLER_0_12_191 VGND VGND VPWR VPWR sky130_fd_sc_hd__fill_1
XFILLER_0_102_399 VGND VGND VPWR VPWR sky130_fd_sc_hd__decap_3
XFILLER_0_99_445 VGND VGND VPWR VPWR sky130_fd_sc_hd__decap_3
XFILLER_0_95_640 VGND VGND VPWR VPWR sky130_fd_sc_hd__fill_2
XFILLER_0_94_161 VGND VGND VPWR VPWR sky130_fd_sc_hd__fill_2
XFILLER_0_67_386 VGND VGND VPWR VPWR sky130_fd_sc_hd__decap_6
XFILLER_0_94_194 VGND VGND VPWR VPWR sky130_fd_sc_hd__fill_2
XFILLER_0_55_559 VGND VGND VPWR VPWR sky130_fd_sc_hd__fill_1
XFILLER_0_42_209 VPWR VGND VPWR VGND sky130_ef_sc_hd__decap_12
XFILLER_0_35_261 VPWR VGND VPWR VGND sky130_ef_sc_hd__decap_12
XFILLER_0_88_29 VPWR VGND VPWR VGND sky130_ef_sc_hd__decap_12
XFILLER_0_50_253 VGND VGND VPWR VPWR sky130_fd_sc_hd__decap_8
XFILLER_0_120_141 VGND VGND VPWR VPWR sky130_fd_sc_hd__decap_6
XFILLER_0_121_697 VPWR VGND VPWR VGND sky130_ef_sc_hd__decap_12
XFILLER_0_37_55 VGND VGND VPWR VPWR sky130_fd_sc_hd__fill_1
XFILLER_0_53_43 VGND VGND VPWR VPWR sky130_fd_sc_hd__fill_2
X_4982_ _2012_ _1989_ _2014_ VGND VGND VPWR VPWR _2015_ sky130_fd_sc_hd__and3_1
X_7770_ _0668_ _0669_ net269 VGND VGND VPWR VPWR _0670_ sky130_fd_sc_hd__o21ai_1
XFILLER_0_58_320 VGND VGND VPWR VPWR sky130_fd_sc_hd__decap_3
XFILLER_0_85_150 VGND VGND VPWR VPWR sky130_fd_sc_hd__fill_1
X_6721_ _3708_ _3709_ _3710_ VGND VGND VPWR VPWR _3711_ sky130_fd_sc_hd__o21bai_2
XFILLER_0_19_729 VGND VGND VPWR VPWR sky130_fd_sc_hd__decap_6
XFILLER_0_73_345 VGND VGND VPWR VPWR sky130_fd_sc_hd__decap_4
XFILLER_0_73_334 VGND VGND VPWR VPWR sky130_fd_sc_hd__fill_2
X_6652_ _3537_ _3540_ VGND VGND VPWR VPWR _3647_ sky130_fd_sc_hd__nand2_1
XFILLER_0_18_228 VGND VGND VPWR VPWR sky130_fd_sc_hd__decap_3
XFILLER_0_6_645 VPWR VGND VPWR VGND sky130_ef_sc_hd__decap_12
X_5603_ sh1\[0\] _2506_ VGND VGND VPWR VPWR _2621_ sky130_fd_sc_hd__nor2_1
XFILLER_0_5_111 VGND VGND VPWR VPWR sky130_fd_sc_hd__fill_1
X_6583_ _3570_ _3574_ _3578_ VGND VGND VPWR VPWR _3579_ sky130_fd_sc_hd__nand3_1
X_8322_ _1157_ _1159_ VGND VGND VPWR VPWR _1160_ sky130_fd_sc_hd__nand2_1
XFILLER_0_14_401 VPWR VGND VPWR VGND sky130_ef_sc_hd__decap_12
XFILLER_0_26_261 VGND VGND VPWR VPWR sky130_fd_sc_hd__decap_8
X_5534_ _2479_ sh2\[0\] sh6\[0\] VGND VGND VPWR VPWR _2553_ sky130_fd_sc_hd__o21a_1
XFILLER_0_41_231 VGND VGND VPWR VPWR sky130_fd_sc_hd__fill_1
XFILLER_0_112_653 VGND VGND VPWR VPWR sky130_fd_sc_hd__fill_2
X_8253_ _1095_ _1097_ VGND VGND VPWR VPWR _1098_ sky130_fd_sc_hd__and2_1
X_5465_ _2484_ _2477_ VGND VGND VPWR VPWR _2485_ sky130_fd_sc_hd__nand2_1
XFILLER_0_14_489 VGND VGND VPWR VPWR sky130_fd_sc_hd__decap_6
X_4416_ _1461_ _1435_ _1439_ VGND VGND VPWR VPWR _1462_ sky130_fd_sc_hd__nand3_1
XFILLER_0_68_3 VGND VGND VPWR VPWR sky130_fd_sc_hd__decap_8
X_8184_ _0996_ _0998_ _1027_ _1029_ VGND VGND VPWR VPWR _1030_ sky130_fd_sc_hd__o211ai_4
X_7204_ _4128_ VGND VGND VPWR VPWR _0233_ sky130_fd_sc_hd__inv_2
XFILLER_0_10_640 VGND VGND VPWR VPWR sky130_fd_sc_hd__decap_4
X_5396_ _2418_ _2419_ _2420_ _2365_ VGND VGND VPWR VPWR _2421_ sky130_fd_sc_hd__a22o_1
X_7135_ net266 _4112_ VGND VGND VPWR VPWR _0052_ sky130_fd_sc_hd__xnor2_1
X_4347_ _1387_ _1392_ _1227_ sh12\[5\] VGND VGND VPWR VPWR _1394_ sky130_fd_sc_hd__nand4_2
X_4278_ _1285_ _1323_ _1324_ VGND VGND VPWR VPWR _1326_ sky130_fd_sc_hd__nand3_1
XFILLER_0_94_50 VPWR VGND VPWR VGND sky130_ef_sc_hd__decap_12
X_7066_ _4049_ _4045_ _4047_ VGND VGND VPWR VPWR _4051_ sky130_fd_sc_hd__nand3_2
X_6017_ _3013_ _3021_ _3024_ VGND VGND VPWR VPWR _3025_ sky130_fd_sc_hd__a21o_1
XTAP_1305 VGND VPWR sky130_fd_sc_hd__tapvpwrvgnd_1
XFILLER_0_96_459 VGND VGND VPWR VPWR sky130_fd_sc_hd__decap_8
XTAP_1338 VGND VPWR sky130_fd_sc_hd__tapvpwrvgnd_1
XTAP_1327 VGND VPWR sky130_fd_sc_hd__tapvpwrvgnd_1
XTAP_1316 VGND VPWR sky130_fd_sc_hd__tapvpwrvgnd_1
X_7968_ _0813_ _0816_ _0740_ VGND VGND VPWR VPWR _0817_ sky130_fd_sc_hd__o21ai_1
XTAP_1349 VGND VPWR sky130_fd_sc_hd__tapvpwrvgnd_1
XFILLER_0_77_673 VGND VGND VPWR VPWR sky130_fd_sc_hd__fill_2
X_7899_ _0746_ _0747_ _0748_ VGND VGND VPWR VPWR _0749_ sky130_fd_sc_hd__o21ai_1
X_6919_ _3797_ _3747_ _3736_ VGND VGND VPWR VPWR _3906_ sky130_fd_sc_hd__o21a_1
XFILLER_0_49_353 VGND VGND VPWR VPWR sky130_fd_sc_hd__fill_2
XFILLER_0_49_375 VPWR VGND VPWR VGND sky130_ef_sc_hd__decap_12
XFILLER_0_92_632 VPWR VGND VPWR VGND sky130_ef_sc_hd__decap_12
XFILLER_0_107_414 VGND VGND VPWR VPWR sky130_fd_sc_hd__decap_6
XFILLER_0_20_415 VGND VGND VPWR VPWR sky130_fd_sc_hd__decap_4
XFILLER_0_102_141 VGND VGND VPWR VPWR sky130_fd_sc_hd__fill_2
XFILLER_0_103_697 VPWR VGND VPWR VGND sky130_ef_sc_hd__decap_12
Xhold390 sh4\[4\] VGND VGND VPWR VPWR net432 sky130_fd_sc_hd__dlygate4sd3_1
XFILLER_0_20_459 VGND VGND VPWR VPWR sky130_fd_sc_hd__fill_2
XFILLER_0_114_15 VPWR VGND VPWR VGND sky130_ef_sc_hd__decap_12
XTAP_1861 VGND VPWR sky130_fd_sc_hd__tapvpwrvgnd_1
XTAP_1850 VGND VPWR sky130_fd_sc_hd__tapvpwrvgnd_1
XFILLER_0_74_109 VPWR VGND VPWR VGND sky130_ef_sc_hd__decap_12
XFILLER_0_67_150 VGND VGND VPWR VPWR sky130_fd_sc_hd__decap_3
XTAP_1883 VGND VPWR sky130_fd_sc_hd__tapvpwrvgnd_1
XTAP_1872 VGND VPWR sky130_fd_sc_hd__tapvpwrvgnd_1
XFILLER_0_83_621 VPWR VGND VPWR VGND sky130_ef_sc_hd__decap_12
XFILLER_0_55_334 VGND VGND VPWR VPWR sky130_fd_sc_hd__fill_2
XFILLER_0_23_57 VGND VGND VPWR VPWR sky130_fd_sc_hd__decap_8
XFILLER_0_28_548 VPWR VGND VPWR VGND sky130_ef_sc_hd__decap_12
XFILLER_0_83_654 VGND VGND VPWR VPWR sky130_fd_sc_hd__fill_1
XFILLER_0_82_153 VPWR VGND VPWR VGND sky130_ef_sc_hd__decap_12
XFILLER_0_70_348 VPWR VGND VPWR VGND sky130_ef_sc_hd__decap_12
XFILLER_0_3_615 VGND VGND VPWR VPWR sky130_fd_sc_hd__fill_1
XFILLER_0_11_404 VGND VGND VPWR VPWR sky130_fd_sc_hd__fill_1
XFILLER_0_23_275 VGND VGND VPWR VPWR sky130_fd_sc_hd__decap_4
X_5250_ _2216_ _2217_ _2248_ _2212_ VGND VGND VPWR VPWR _2277_ sky130_fd_sc_hd__o22ai_2
X_5181_ _2052_ _2037_ sh3\[2\] VGND VGND VPWR VPWR _2209_ sky130_fd_sc_hd__o21a_1
XFILLER_0_64_64 VGND VGND VPWR VPWR sky130_fd_sc_hd__fill_1
X_8871_ clknet_3_0__leaf_clk net439 _0622_ VGND VGND VPWR VPWR sh15\[3\] sky130_fd_sc_hd__dfrtp_4
X_7822_ net271 _0696_ VGND VGND VPWR VPWR _0070_ sky130_fd_sc_hd__xnor2_1
X_4965_ _1998_ VGND VGND VPWR VPWR _0186_ sky130_fd_sc_hd__clkbuf_1
X_7753_ carry4\[10\] s6\[11\] VGND VGND VPWR VPWR _0656_ sky130_fd_sc_hd__and2_1
XFILLER_0_80_41 VPWR VGND VPWR VGND sky130_ef_sc_hd__decap_12
X_6704_ _3688_ VGND VGND VPWR VPWR _3696_ sky130_fd_sc_hd__inv_2
XFILLER_0_74_643 VGND VGND VPWR VPWR sky130_fd_sc_hd__fill_1
XFILLER_0_58_194 VGND VGND VPWR VPWR sky130_fd_sc_hd__fill_2
X_4896_ _1924_ _1925_ _1911_ VGND VGND VPWR VPWR _1931_ sky130_fd_sc_hd__o21bai_1
XFILLER_0_104_81 VGND VGND VPWR VPWR sky130_fd_sc_hd__decap_3
XFILLER_0_80_85 VPWR VGND VPWR VGND sky130_ef_sc_hd__decap_12
X_7684_ net399 net290 VGND VGND VPWR VPWR _4206_ sky130_fd_sc_hd__and2_1
X_6635_ _3627_ _3628_ VGND VGND VPWR VPWR _3630_ sky130_fd_sc_hd__nor2_1
XFILLER_0_15_721 VGND VGND VPWR VPWR sky130_fd_sc_hd__decap_6
XFILLER_0_34_529 VGND VGND VPWR VPWR sky130_fd_sc_hd__decap_3
XFILLER_0_46_389 VGND VGND VPWR VPWR sky130_fd_sc_hd__fill_2
X_6566_ _3295_ _3297_ _3554_ VGND VGND VPWR VPWR _3562_ sky130_fd_sc_hd__a21oi_1
XFILLER_0_61_337 VGND VGND VPWR VPWR sky130_fd_sc_hd__decap_4
X_8305_ sum5\[7\] s7\[7\] VGND VGND VPWR VPWR _1144_ sky130_fd_sc_hd__nand2_1
XFILLER_0_14_253 VGND VGND VPWR VPWR sky130_fd_sc_hd__decap_8
X_5517_ _2492_ _2534_ sh14\[0\] VGND VGND VPWR VPWR _2536_ sky130_fd_sc_hd__o21ai_1
XFILLER_0_30_713 VPWR VGND VPWR VGND sky130_ef_sc_hd__decap_12
X_6497_ _3301_ _3304_ _3289_ VGND VGND VPWR VPWR _3494_ sky130_fd_sc_hd__o21ai_2
X_8236_ _1075_ _1079_ _1080_ VGND VGND VPWR VPWR _1081_ sky130_fd_sc_hd__a21oi_2
XFILLER_0_100_612 VGND VGND VPWR VPWR sky130_fd_sc_hd__fill_2
XFILLER_0_2_681 VPWR VGND VPWR VGND sky130_ef_sc_hd__decap_12
X_5448_ sh10\[0\] net30 VGND VGND VPWR VPWR _2468_ sky130_fd_sc_hd__and2_2
XFILLER_0_100_645 VPWR VGND VPWR VGND sky130_ef_sc_hd__decap_12
X_8167_ _0736_ _0750_ VGND VGND VPWR VPWR _1013_ sky130_fd_sc_hd__nor2_1
X_5379_ _2402_ _2370_ _2403_ VGND VGND VPWR VPWR _2404_ sky130_fd_sc_hd__a21oi_2
X_8098_ _0937_ _0941_ _0944_ VGND VGND VPWR VPWR _0945_ sky130_fd_sc_hd__a21o_1
X_7118_ _4099_ _4100_ VGND VGND VPWR VPWR _4101_ sky130_fd_sc_hd__nor2_1
X_7049_ _4026_ _4028_ _4032_ _4033_ VGND VGND VPWR VPWR _4034_ sky130_fd_sc_hd__o211ai_1
XTAP_1113 VGND VPWR sky130_fd_sc_hd__tapvpwrvgnd_1
XTAP_1102 VGND VPWR sky130_fd_sc_hd__tapvpwrvgnd_1
XTAP_1146 VGND VPWR sky130_fd_sc_hd__tapvpwrvgnd_1
XTAP_1124 VGND VPWR sky130_fd_sc_hd__tapvpwrvgnd_1
XTAP_1135 VGND VPWR sky130_fd_sc_hd__tapvpwrvgnd_1
XFILLER_0_56_109 VGND VGND VPWR VPWR sky130_fd_sc_hd__fill_2
XFILLER_0_108_701 VPWR VGND VPWR VGND sky130_ef_sc_hd__decap_12
XTAP_1179 VGND VPWR sky130_fd_sc_hd__tapvpwrvgnd_1
XTAP_1168 VGND VPWR sky130_fd_sc_hd__tapvpwrvgnd_1
XTAP_1157 VGND VPWR sky130_fd_sc_hd__tapvpwrvgnd_1
XFILLER_0_37_334 VGND VGND VPWR VPWR sky130_fd_sc_hd__fill_2
XFILLER_0_107_211 VPWR VGND VPWR VGND sky130_ef_sc_hd__decap_12
XFILLER_0_92_451 VPWR VGND VPWR VGND sky130_ef_sc_hd__decap_12
XFILLER_0_64_153 VGND VGND VPWR VPWR sky130_fd_sc_hd__decap_6
XFILLER_0_37_356 VGND VGND VPWR VPWR sky130_fd_sc_hd__decap_8
XFILLER_0_80_668 VGND VGND VPWR VPWR sky130_fd_sc_hd__decap_3
XFILLER_0_33_540 VGND VGND VPWR VPWR sky130_fd_sc_hd__fill_2
XFILLER_0_33_573 VGND VGND VPWR VPWR sky130_fd_sc_hd__decap_6
XFILLER_0_122_269 VGND VGND VPWR VPWR sky130_fd_sc_hd__fill_2
XFILLER_0_110_409 VGND VGND VPWR VPWR sky130_fd_sc_hd__decap_8
XFILLER_0_103_461 VPWR VGND VPWR VGND sky130_ef_sc_hd__decap_12
XFILLER_0_60_370 VPWR VGND VPWR VGND sky130_ef_sc_hd__decap_12
XFILLER_0_0_629 VPWR VGND VPWR VGND sky130_ef_sc_hd__decap_12
XFILLER_0_33_595 VPWR VGND VPWR VGND sky130_ef_sc_hd__decap_12
XTAP_908 VGND VPWR sky130_fd_sc_hd__tapvpwrvgnd_1
XTAP_919 VGND VPWR sky130_fd_sc_hd__tapvpwrvgnd_1
XFILLER_0_87_278 VGND VGND VPWR VPWR sky130_fd_sc_hd__fill_2
X_4750_ _1784_ _1785_ _1786_ VGND VGND VPWR VPWR _1787_ sky130_fd_sc_hd__nand3b_4
XTAP_1691 VGND VPWR sky130_fd_sc_hd__tapvpwrvgnd_1
XTAP_1680 VGND VPWR sky130_fd_sc_hd__tapvpwrvgnd_1
XFILLER_0_56_665 VPWR VGND VPWR VGND sky130_ef_sc_hd__decap_12
XFILLER_0_56_643 VGND VGND VPWR VPWR sky130_fd_sc_hd__fill_1
XFILLER_0_7_217 VGND VGND VPWR VPWR sky130_fd_sc_hd__decap_6
X_4681_ sh11\[7\] sh12\[7\] VGND VGND VPWR VPWR _1719_ sky130_fd_sc_hd__and2_1
XFILLER_0_71_613 VGND VGND VPWR VPWR sky130_fd_sc_hd__decap_3
XFILLER_0_70_134 VGND VGND VPWR VPWR sky130_fd_sc_hd__decap_6
X_6420_ _3394_ VGND VGND VPWR VPWR _3418_ sky130_fd_sc_hd__inv_2
XFILLER_0_43_337 VPWR VGND VPWR VGND sky130_ef_sc_hd__decap_12
X_6351_ _3301_ _3329_ _3328_ _3327_ _3349_ VGND VGND VPWR VPWR _3350_ sky130_fd_sc_hd__o221ai_4
XFILLER_0_12_713 VPWR VGND VPWR VGND sky130_ef_sc_hd__decap_12
XFILLER_0_3_445 VGND VGND VPWR VPWR sky130_fd_sc_hd__decap_3
X_5302_ _2040_ _2104_ VGND VGND VPWR VPWR _2328_ sky130_fd_sc_hd__nand2_1
X_6282_ _2995_ _2947_ VGND VGND VPWR VPWR _3283_ sky130_fd_sc_hd__nor2_1
X_8021_ _0730_ VGND VGND VPWR VPWR _0869_ sky130_fd_sc_hd__inv_2
X_5233_ _2055_ _2257_ _2258_ _2259_ VGND VGND VPWR VPWR _2260_ sky130_fd_sc_hd__o211ai_4
X_5164_ _2074_ _2135_ VGND VGND VPWR VPWR _2192_ sky130_fd_sc_hd__nand2_2
X_5095_ _2069_ _2068_ _2073_ sh14\[2\] VGND VGND VPWR VPWR _2124_ sky130_fd_sc_hd__o211ai_1
X_8854_ clknet_leaf_59_clk net329 _0605_ VGND VGND VPWR VPWR sh13\[2\] sky130_fd_sc_hd__dfrtp_1
XPHY_207 VGND VGND VPWR VPWR sky130_fd_sc_hd__decap_3
XFILLER_0_91_84 VPWR VGND VPWR VGND sky130_ef_sc_hd__decap_12
X_7805_ s0\[8\] s1\[8\] net207 VGND VGND VPWR VPWR _0688_ sky130_fd_sc_hd__a21o_1
XPHY_229 VGND VGND VPWR VPWR sky130_fd_sc_hd__decap_3
X_8785_ clknet_leaf_9_clk net198 _0536_ VGND VGND VPWR VPWR sh4\[5\] sky130_fd_sc_hd__dfrtp_1
XPHY_218 VGND VGND VPWR VPWR sky130_fd_sc_hd__decap_3
X_5997_ _2890_ _2883_ net39 VGND VGND VPWR VPWR _3005_ sky130_fd_sc_hd__a21oi_1
XFILLER_0_93_237 VPWR VGND VPWR VGND sky130_ef_sc_hd__decap_12
XFILLER_0_93_215 VGND VGND VPWR VPWR sky130_fd_sc_hd__fill_2
XFILLER_0_47_621 VGND VGND VPWR VPWR sky130_fd_sc_hd__fill_1
X_4948_ _1972_ _1968_ _1971_ VGND VGND VPWR VPWR _1982_ sky130_fd_sc_hd__and3_1
X_7736_ net375 _0640_ _0641_ VGND VGND VPWR VPWR _0643_ sky130_fd_sc_hd__or3_1
X_4879_ _1652_ _1641_ _1636_ VGND VGND VPWR VPWR _1914_ sky130_fd_sc_hd__o21ai_1
XFILLER_0_117_553 VGND VGND VPWR VPWR sky130_fd_sc_hd__decap_6
X_7667_ net342 _4190_ _4191_ VGND VGND VPWR VPWR _4193_ sky130_fd_sc_hd__or3_1
XFILLER_0_19_367 VPWR VGND VPWR VGND sky130_ef_sc_hd__decap_12
X_6618_ _3609_ _3612_ sh14\[4\] VGND VGND VPWR VPWR _3613_ sky130_fd_sc_hd__o21ba_1
X_7598_ _4158_ VGND VGND VPWR VPWR _4167_ sky130_fd_sc_hd__buf_8
XFILLER_0_61_167 VGND VGND VPWR VPWR sky130_fd_sc_hd__fill_1
XFILLER_0_70_690 VGND VGND VPWR VPWR sky130_fd_sc_hd__decap_8
X_6549_ _3482_ _3545_ VGND VGND VPWR VPWR _0121_ sky130_fd_sc_hd__xnor2_1
X_8219_ _1062_ _1060_ _1063_ VGND VGND VPWR VPWR _1064_ sky130_fd_sc_hd__a21o_1
XFILLER_0_100_475 VGND VGND VPWR VPWR sky130_fd_sc_hd__fill_1
XFILLER_0_85_727 VGND VGND VPWR VPWR sky130_fd_sc_hd__fill_1
XFILLER_0_69_278 VGND VGND VPWR VPWR sky130_fd_sc_hd__fill_2
XFILLER_0_84_248 VGND VGND VPWR VPWR sky130_fd_sc_hd__decap_4
XFILLER_0_38_643 VGND VGND VPWR VPWR sky130_fd_sc_hd__fill_1
XFILLER_0_80_421 VPWR VGND VPWR VGND sky130_ef_sc_hd__decap_12
XFILLER_0_4_209 VGND VGND VPWR VPWR sky130_fd_sc_hd__decap_8
XFILLER_0_123_545 VGND VGND VPWR VPWR sky130_fd_sc_hd__decap_8
XFILLER_0_80_465 VGND VGND VPWR VPWR sky130_fd_sc_hd__decap_8
XFILLER_0_111_729 VGND VGND VPWR VPWR sky130_fd_sc_hd__decap_6
XFILLER_0_111_718 VGND VGND VPWR VPWR sky130_fd_sc_hd__decap_8
XFILLER_0_52_189 VGND VGND VPWR VPWR sky130_fd_sc_hd__decap_6
XFILLER_0_123_589 VGND VGND VPWR VPWR sky130_fd_sc_hd__decap_8
XFILLER_0_96_29 VGND VGND VPWR VPWR sky130_fd_sc_hd__decap_6
XTAP_705 VGND VPWR sky130_fd_sc_hd__tapvpwrvgnd_1
XTAP_716 VGND VPWR sky130_fd_sc_hd__tapvpwrvgnd_1
XFILLER_0_29_45 VGND VGND VPWR VPWR sky130_fd_sc_hd__fill_1
XTAP_727 VGND VPWR sky130_fd_sc_hd__tapvpwrvgnd_1
XTAP_738 VGND VPWR sky130_fd_sc_hd__tapvpwrvgnd_1
XTAP_749 VGND VPWR sky130_fd_sc_hd__tapvpwrvgnd_1
X_5920_ _2924_ _2926_ _2923_ _2928_ VGND VGND VPWR VPWR _2929_ sky130_fd_sc_hd__o22ai_2
XFILLER_0_0_57 VPWR VGND VPWR VGND sky130_ef_sc_hd__decap_12
X_5851_ _2859_ _2863_ VGND VGND VPWR VPWR _0179_ sky130_fd_sc_hd__nor2_1
XFILLER_0_118_317 VGND VGND VPWR VPWR sky130_fd_sc_hd__decap_3
XFILLER_0_118_306 VGND VGND VPWR VPWR sky130_fd_sc_hd__fill_2
X_4802_ _1638_ _1722_ _1791_ VGND VGND VPWR VPWR _1838_ sky130_fd_sc_hd__o21ai_4
X_5782_ _2796_ _2789_ _2790_ _2791_ VGND VGND VPWR VPWR _2797_ sky130_fd_sc_hd__o2bb2ai_4
XFILLER_0_29_665 VGND VGND VPWR VPWR sky130_fd_sc_hd__decap_6
X_8570_ clknet_leaf_34_clk _0065_ _0321_ VGND VGND VPWR VPWR sum2\[5\] sky130_fd_sc_hd__dfrtp_1
X_4733_ _1649_ _1641_ VGND VGND VPWR VPWR _1770_ sky130_fd_sc_hd__nor2_1
X_7521_ _4158_ VGND VGND VPWR VPWR _4160_ sky130_fd_sc_hd__clkbuf_16
XFILLER_0_16_304 VGND VGND VPWR VPWR sky130_fd_sc_hd__decap_4
XFILLER_0_16_315 VGND VGND VPWR VPWR sky130_fd_sc_hd__decap_4
XFILLER_0_71_421 VGND VGND VPWR VPWR sky130_fd_sc_hd__fill_1
X_7452_ _4152_ VGND VGND VPWR VPWR _0457_ sky130_fd_sc_hd__inv_2
XFILLER_0_28_197 VGND VGND VPWR VPWR sky130_fd_sc_hd__decap_8
XFILLER_0_44_657 VPWR VGND VPWR VGND sky130_ef_sc_hd__decap_12
X_4664_ _1643_ net40 VGND VGND VPWR VPWR _1702_ sky130_fd_sc_hd__nor2_1
X_6403_ sh14\[4\] _3358_ VGND VGND VPWR VPWR _3402_ sky130_fd_sc_hd__nor2_1
XFILLER_0_9_55 VGND VGND VPWR VPWR sky130_fd_sc_hd__fill_1
XFILLER_0_16_359 VGND VGND VPWR VPWR sky130_fd_sc_hd__decap_4
XFILLER_0_43_167 VGND VGND VPWR VPWR sky130_fd_sc_hd__fill_1
X_4595_ _1260_ _1230_ _1257_ _1263_ _1633_ VGND VGND VPWR VPWR _1635_ sky130_fd_sc_hd__o311a_1
X_7383_ _4145_ VGND VGND VPWR VPWR _0395_ sky130_fd_sc_hd__inv_2
XFILLER_0_52_690 VGND VGND VPWR VPWR sky130_fd_sc_hd__decap_8
XFILLER_0_101_206 VGND VGND VPWR VPWR sky130_fd_sc_hd__decap_4
X_6334_ sh7\[4\] net33 VGND VGND VPWR VPWR _3333_ sky130_fd_sc_hd__nor2_2
X_6265_ _3267_ _3268_ VGND VGND VPWR VPWR _0142_ sky130_fd_sc_hd__nand2_2
XFILLER_0_12_598 VGND VGND VPWR VPWR sky130_fd_sc_hd__fill_1
X_5216_ _2238_ _2242_ _2106_ VGND VGND VPWR VPWR _2244_ sky130_fd_sc_hd__nand3_2
X_8004_ _0851_ _0846_ _0849_ VGND VGND VPWR VPWR _0853_ sky130_fd_sc_hd__nand3_2
XFILLER_0_50_3 VPWR VGND VPWR VGND sky130_ef_sc_hd__decap_12
X_6196_ _3198_ _3200_ _2910_ VGND VGND VPWR VPWR _3201_ sky130_fd_sc_hd__o21ai_4
X_5147_ _2167_ _2174_ _2175_ VGND VGND VPWR VPWR _2176_ sky130_fd_sc_hd__a21bo_1
X_5078_ _2106_ VGND VGND VPWR VPWR _2107_ sky130_fd_sc_hd__inv_2
X_8837_ clknet_leaf_49_clk net185 _0588_ VGND VGND VPWR VPWR sh11\[1\] sky130_fd_sc_hd__dfrtp_1
X_8768_ clknet_leaf_4_clk net167 _0519_ VGND VGND VPWR VPWR sh2\[4\] sky130_fd_sc_hd__dfrtp_2
XFILLER_0_66_248 VGND VGND VPWR VPWR sky130_fd_sc_hd__decap_4
XFILLER_0_62_410 VGND VGND VPWR VPWR sky130_fd_sc_hd__fill_1
X_7719_ net241 _0631_ VGND VGND VPWR VPWR _0068_ sky130_fd_sc_hd__xnor2_1
XFILLER_0_35_646 VGND VGND VPWR VPWR sky130_fd_sc_hd__fill_1
X_8699_ clknet_leaf_56_clk _0100_ _0450_ VGND VGND VPWR VPWR bit_sum3\[0\] sky130_fd_sc_hd__dfrtp_1
XFILLER_0_105_534 VPWR VGND VPWR VGND sky130_ef_sc_hd__decap_12
XFILLER_0_34_145 VGND VGND VPWR VPWR sky130_fd_sc_hd__decap_8
XFILLER_0_105_556 VGND VGND VPWR VPWR sky130_fd_sc_hd__decap_4
XFILLER_0_62_487 VPWR VGND VPWR VGND sky130_ef_sc_hd__decap_12
XFILLER_0_15_370 VGND VGND VPWR VPWR sky130_fd_sc_hd__decap_4
XFILLER_0_50_627 VPWR VGND VPWR VGND sky130_ef_sc_hd__decap_12
XFILLER_0_120_559 VPWR VGND VPWR VGND sky130_ef_sc_hd__decap_12
XFILLER_0_106_27 VGND VGND VPWR VPWR sky130_fd_sc_hd__fill_1
XFILLER_0_58_705 VGND VGND VPWR VPWR sky130_fd_sc_hd__fill_1
XFILLER_0_15_69 VGND VGND VPWR VPWR sky130_fd_sc_hd__decap_8
XFILLER_0_122_15 VPWR VGND VPWR VGND sky130_ef_sc_hd__decap_12
XFILLER_0_38_451 VGND VGND VPWR VPWR sky130_fd_sc_hd__decap_8
XFILLER_0_38_462 VGND VGND VPWR VPWR sky130_fd_sc_hd__decap_4
XFILLER_0_31_57 VGND VGND VPWR VPWR sky130_fd_sc_hd__decap_8
XFILLER_0_110_6 VPWR VGND VPWR VGND sky130_ef_sc_hd__decap_12
XFILLER_0_108_383 VPWR VGND VPWR VGND sky130_ef_sc_hd__decap_12
XFILLER_0_53_465 VGND VGND VPWR VPWR sky130_fd_sc_hd__decap_8
XFILLER_0_25_145 VGND VGND VPWR VPWR sky130_fd_sc_hd__decap_3
XFILLER_0_25_167 VGND VGND VPWR VPWR sky130_fd_sc_hd__fill_1
XFILLER_0_41_605 VGND VGND VPWR VPWR sky130_fd_sc_hd__decap_8
Xhold208 s3\[11\] VGND VGND VPWR VPWR net250 sky130_fd_sc_hd__dlygate4sd3_1
XFILLER_0_53_487 VGND VGND VPWR VPWR sky130_fd_sc_hd__decap_4
X_4380_ _1245_ _1299_ _1384_ VGND VGND VPWR VPWR _1426_ sky130_fd_sc_hd__o21bai_2
Xhold219 sum1\[11\] VGND VGND VPWR VPWR net261 sky130_fd_sc_hd__dlygate4sd3_1
XTAP_502 VGND VPWR sky130_fd_sc_hd__tapvpwrvgnd_1
XTAP_524 VGND VPWR sky130_fd_sc_hd__tapvpwrvgnd_1
XTAP_513 VGND VPWR sky130_fd_sc_hd__tapvpwrvgnd_1
X_6050_ _2974_ _2924_ _2975_ _2976_ VGND VGND VPWR VPWR _3058_ sky130_fd_sc_hd__a211o_1
XTAP_535 VGND VPWR sky130_fd_sc_hd__tapvpwrvgnd_1
XTAP_546 VGND VPWR sky130_fd_sc_hd__tapvpwrvgnd_1
XTAP_557 VGND VPWR sky130_fd_sc_hd__tapvpwrvgnd_1
X_5001_ _2030_ _2031_ VGND VGND VPWR VPWR _2033_ sky130_fd_sc_hd__nor2_1
XTAP_568 VGND VPWR sky130_fd_sc_hd__tapvpwrvgnd_1
XTAP_579 VGND VPWR sky130_fd_sc_hd__tapvpwrvgnd_1
XFILLER_0_88_340 VPWR VGND VPWR VGND sky130_ef_sc_hd__decap_12
X_6952_ _3846_ _3908_ _3920_ _3923_ VGND VGND VPWR VPWR _3939_ sky130_fd_sc_hd__o211ai_2
X_5903_ _2879_ _2911_ VGND VGND VPWR VPWR _2912_ sky130_fd_sc_hd__nand2_1
X_6883_ _3855_ _3856_ _3870_ VGND VGND VPWR VPWR _3871_ sky130_fd_sc_hd__nand3_1
XFILLER_0_119_615 VGND VGND VPWR VPWR sky130_fd_sc_hd__fill_1
X_5834_ _2823_ _2820_ _2847_ VGND VGND VPWR VPWR _2848_ sky130_fd_sc_hd__a21o_1
X_8622_ clknet_leaf_56_clk net123 _0373_ VGND VGND VPWR VPWR s3\[5\] sky130_fd_sc_hd__dfrtp_1
XFILLER_0_8_345 VGND VGND VPWR VPWR sky130_fd_sc_hd__fill_1
XFILLER_0_17_613 VGND VGND VPWR VPWR sky130_fd_sc_hd__decap_3
XFILLER_0_118_158 VGND VGND VPWR VPWR sky130_fd_sc_hd__decap_8
XFILLER_0_106_309 VGND VGND VPWR VPWR sky130_fd_sc_hd__decap_6
X_8553_ clknet_leaf_39_clk net121 _0304_ VGND VGND VPWR VPWR sum4\[3\] sky130_fd_sc_hd__dfrtp_1
X_5765_ _2521_ sh9\[0\] VGND VGND VPWR VPWR _2780_ sky130_fd_sc_hd__or2_1
XFILLER_0_44_421 VGND VGND VPWR VPWR sky130_fd_sc_hd__decap_4
XFILLER_0_44_432 VGND VGND VPWR VPWR sky130_fd_sc_hd__fill_2
XFILLER_0_98_3 VPWR VGND VPWR VGND sky130_ef_sc_hd__decap_12
X_4716_ _1751_ _1753_ VGND VGND VPWR VPWR _1754_ sky130_fd_sc_hd__nand2_1
X_7504_ _4157_ VGND VGND VPWR VPWR _0504_ sky130_fd_sc_hd__inv_2
XFILLER_0_71_240 VGND VGND VPWR VPWR sky130_fd_sc_hd__decap_6
X_8484_ clknet_leaf_40_clk net150 _0235_ VGND VGND VPWR VPWR net22 sky130_fd_sc_hd__dfrtp_1
X_5696_ _2610_ _2709_ _2706_ VGND VGND VPWR VPWR _2713_ sky130_fd_sc_hd__o21ai_1
X_4647_ net41 _1643_ net40 VGND VGND VPWR VPWR _1685_ sky130_fd_sc_hd__o21ai_1
XFILLER_0_112_81 VGND VGND VPWR VPWR sky130_fd_sc_hd__decap_3
XFILLER_0_32_638 VGND VGND VPWR VPWR sky130_fd_sc_hd__decap_6
XFILLER_0_32_649 VPWR VGND VPWR VGND sky130_ef_sc_hd__decap_12
X_7435_ _4151_ VGND VGND VPWR VPWR _0441_ sky130_fd_sc_hd__inv_2
X_7366_ _4144_ VGND VGND VPWR VPWR _0379_ sky130_fd_sc_hd__inv_2
XFILLER_0_31_137 VGND VGND VPWR VPWR sky130_fd_sc_hd__fill_1
XFILLER_0_31_148 VGND VGND VPWR VPWR sky130_fd_sc_hd__decap_3
X_4578_ _1619_ _1620_ VGND VGND VPWR VPWR _0133_ sky130_fd_sc_hd__nand2_1
X_6317_ _3292_ _3288_ _3289_ VGND VGND VPWR VPWR _3317_ sky130_fd_sc_hd__a21oi_1
X_7297_ _4137_ VGND VGND VPWR VPWR _0317_ sky130_fd_sc_hd__inv_2
X_6248_ _3193_ _3245_ _3248_ _3250_ VGND VGND VPWR VPWR _3252_ sky130_fd_sc_hd__nor4_1
X_6179_ _3130_ sh15\[6\] _3125_ _3180_ _3184_ VGND VGND VPWR VPWR _3185_ sky130_fd_sc_hd__a32o_1
XFILLER_0_39_204 VGND VGND VPWR VPWR sky130_fd_sc_hd__decap_8
XFILLER_0_94_365 VGND VGND VPWR VPWR sky130_fd_sc_hd__fill_2
XFILLER_0_82_527 VGND VGND VPWR VPWR sky130_fd_sc_hd__fill_1
XFILLER_0_109_158 VGND VGND VPWR VPWR sky130_fd_sc_hd__decap_3
XFILLER_0_47_270 VGND VGND VPWR VPWR sky130_fd_sc_hd__decap_8
XFILLER_0_47_281 VPWR VGND VPWR VGND sky130_ef_sc_hd__decap_12
XFILLER_0_62_251 VGND VGND VPWR VPWR sky130_fd_sc_hd__fill_1
XFILLER_0_35_465 VGND VGND VPWR VPWR sky130_fd_sc_hd__decap_8
XFILLER_0_105_331 VGND VGND VPWR VPWR sky130_fd_sc_hd__fill_1
XFILLER_0_50_413 VGND VGND VPWR VPWR sky130_fd_sc_hd__decap_6
XFILLER_0_105_364 VGND VGND VPWR VPWR sky130_fd_sc_hd__decap_3
XFILLER_0_22_159 VPWR VGND VPWR VGND sky130_ef_sc_hd__decap_12
XFILLER_0_120_345 VGND VGND VPWR VPWR sky130_fd_sc_hd__fill_2
XFILLER_0_120_356 VGND VGND VPWR VPWR sky130_fd_sc_hd__decap_4
XFILLER_0_117_15 VPWR VGND VPWR VGND sky130_ef_sc_hd__decap_12
XFILLER_0_89_137 VGND VGND VPWR VPWR sky130_fd_sc_hd__decap_8
XFILLER_0_89_126 VGND VGND VPWR VPWR sky130_fd_sc_hd__decap_3
Xhold80 sum5\[1\] VGND VGND VPWR VPWR net122 sky130_fd_sc_hd__dlygate4sd3_1
Xhold91 sum3\[2\] VGND VGND VPWR VPWR net133 sky130_fd_sc_hd__dlygate4sd3_1
XFILLER_0_89_159 VGND VGND VPWR VPWR sky130_fd_sc_hd__decap_3
XFILLER_0_85_387 VGND VGND VPWR VPWR sky130_fd_sc_hd__fill_2
XFILLER_0_116_607 VPWR VGND VPWR VGND sky130_ef_sc_hd__decap_12
XFILLER_0_115_117 VGND VGND VPWR VPWR sky130_fd_sc_hd__fill_1
XFILLER_0_109_670 VGND VGND VPWR VPWR sky130_fd_sc_hd__fill_2
X_5550_ _2564_ _2567_ _2568_ VGND VGND VPWR VPWR _2569_ sky130_fd_sc_hd__nand3_4
X_4501_ sh13\[5\] _1384_ VGND VGND VPWR VPWR _1545_ sky130_fd_sc_hd__and2_2
X_5481_ _2488_ _2498_ _2500_ VGND VGND VPWR VPWR _2501_ sky130_fd_sc_hd__a21o_1
XFILLER_0_111_312 VPWR VGND VPWR VGND sky130_ef_sc_hd__decap_12
X_4432_ _1473_ _1471_ _1472_ VGND VGND VPWR VPWR _1478_ sky130_fd_sc_hd__nand3_2
X_7220_ _4129_ VGND VGND VPWR VPWR _0248_ sky130_fd_sc_hd__inv_2
XFILLER_0_13_159 VGND VGND VPWR VPWR sky130_fd_sc_hd__decap_8
XFILLER_0_41_446 VGND VGND VPWR VPWR sky130_fd_sc_hd__fill_2
XFILLER_0_111_367 VGND VGND VPWR VPWR sky130_fd_sc_hd__decap_8
X_4363_ _1340_ _1342_ _1337_ VGND VGND VPWR VPWR _1410_ sky130_fd_sc_hd__a21oi_2
X_7151_ _0000_ net291 VGND VGND VPWR VPWR _0050_ sky130_fd_sc_hd__nor2_1
X_6102_ _2906_ net28 _3036_ _3041_ VGND VGND VPWR VPWR _3109_ sky130_fd_sc_hd__a22o_1
X_4294_ _1319_ _1320_ _1336_ VGND VGND VPWR VPWR _1342_ sky130_fd_sc_hd__nand3_1
XTAP_332 VGND VPWR sky130_fd_sc_hd__tapvpwrvgnd_1
XTAP_321 VGND VPWR sky130_fd_sc_hd__tapvpwrvgnd_1
XTAP_310 VGND VPWR sky130_fd_sc_hd__tapvpwrvgnd_1
X_7082_ _4063_ _4013_ _4011_ _4062_ VGND VGND VPWR VPWR _4066_ sky130_fd_sc_hd__o211ai_2
X_6033_ _3034_ _3038_ _3039_ _3040_ VGND VGND VPWR VPWR _3041_ sky130_fd_sc_hd__o211ai_4
XTAP_376 VGND VPWR sky130_fd_sc_hd__tapvpwrvgnd_1
XTAP_365 VGND VPWR sky130_fd_sc_hd__tapvpwrvgnd_1
XTAP_343 VGND VPWR sky130_fd_sc_hd__tapvpwrvgnd_1
XTAP_354 VGND VPWR sky130_fd_sc_hd__tapvpwrvgnd_1
XTAP_398 VGND VPWR sky130_fd_sc_hd__tapvpwrvgnd_1
XTAP_387 VGND VPWR sky130_fd_sc_hd__tapvpwrvgnd_1
XFILLER_0_13_3 VPWR VGND VPWR VGND sky130_ef_sc_hd__decap_12
X_7984_ _0818_ _0821_ _0832_ VGND VGND VPWR VPWR _0833_ sky130_fd_sc_hd__nand3_1
XTAP_1509 VGND VPWR sky130_fd_sc_hd__tapvpwrvgnd_1
XPHY_16 VGND VGND VPWR VPWR sky130_fd_sc_hd__decap_3
XPHY_27 VGND VGND VPWR VPWR sky130_fd_sc_hd__decap_3
X_6935_ _3767_ _3769_ _3858_ VGND VGND VPWR VPWR _3922_ sky130_fd_sc_hd__and3_1
XPHY_38 VGND VGND VPWR VPWR sky130_fd_sc_hd__decap_3
XFILLER_0_88_192 VGND VGND VPWR VPWR sky130_fd_sc_hd__decap_4
XFILLER_0_76_321 VGND VGND VPWR VPWR sky130_fd_sc_hd__fill_1
XPHY_49 VGND VGND VPWR VPWR sky130_fd_sc_hd__decap_3
XFILLER_0_76_365 VGND VGND VPWR VPWR sky130_fd_sc_hd__decap_4
Xclkbuf_leaf_61_clk clknet_3_0__leaf_clk VGND VGND VPWR VPWR clknet_leaf_61_clk sky130_fd_sc_hd__clkbuf_16
X_6866_ _3743_ VGND VGND VPWR VPWR _3854_ sky130_fd_sc_hd__inv_2
XFILLER_0_9_665 VGND VGND VPWR VPWR sky130_fd_sc_hd__decap_6
XFILLER_0_8_153 VPWR VGND VPWR VGND sky130_ef_sc_hd__decap_12
X_5817_ _2825_ _2779_ _2829_ _2830_ VGND VGND VPWR VPWR _2831_ sky130_fd_sc_hd__o22ai_4
X_6797_ _3768_ _3752_ sh13\[1\] VGND VGND VPWR VPWR _3786_ sky130_fd_sc_hd__o21ai_1
XFILLER_0_29_281 VGND VGND VPWR VPWR sky130_fd_sc_hd__decap_4
X_8605_ clknet_leaf_52_clk net53 _0356_ VGND VGND VPWR VPWR s1\[6\] sky130_fd_sc_hd__dfrtp_1
XFILLER_0_107_629 VPWR VGND VPWR VGND sky130_ef_sc_hd__decap_12
XFILLER_0_91_357 VGND VGND VPWR VPWR sky130_fd_sc_hd__decap_6
X_8536_ clknet_leaf_31_clk net272 _0287_ VGND VGND VPWR VPWR sum3\[10\] sky130_fd_sc_hd__dfrtp_1
XFILLER_0_8_197 VPWR VGND VPWR VGND sky130_ef_sc_hd__decap_12
X_5748_ _2753_ _2757_ _2724_ VGND VGND VPWR VPWR _2764_ sky130_fd_sc_hd__a21o_1
XFILLER_0_44_240 VGND VGND VPWR VPWR sky130_fd_sc_hd__fill_1
XFILLER_0_106_139 VGND VGND VPWR VPWR sky130_fd_sc_hd__fill_1
XFILLER_0_17_476 VGND VGND VPWR VPWR sky130_fd_sc_hd__decap_6
XFILLER_0_115_673 VPWR VGND VPWR VGND sky130_ef_sc_hd__decap_12
X_8467_ clknet_leaf_28_clk net327 _0218_ VGND VGND VPWR VPWR carry5\[14\] sky130_fd_sc_hd__dfrtp_1
X_5679_ _2683_ _2688_ _2692_ VGND VGND VPWR VPWR _2696_ sky130_fd_sc_hd__a21oi_1
X_8398_ sh10\[5\] sh11\[5\] sh12\[5\] VGND VGND VPWR VPWR _1228_ sky130_fd_sc_hd__o21ai_2
X_7418_ _4149_ VGND VGND VPWR VPWR _0426_ sky130_fd_sc_hd__inv_2
X_7349_ _4142_ VGND VGND VPWR VPWR _0364_ sky130_fd_sc_hd__inv_2
XFILLER_0_99_424 VGND VGND VPWR VPWR sky130_fd_sc_hd__decap_3
XFILLER_0_99_479 VGND VGND VPWR VPWR sky130_fd_sc_hd__fill_1
Xclkbuf_leaf_52_clk clknet_3_4__leaf_clk VGND VGND VPWR VPWR clknet_leaf_52_clk sky130_fd_sc_hd__clkbuf_16
XFILLER_0_82_324 VGND VGND VPWR VPWR sky130_fd_sc_hd__decap_4
XFILLER_0_12_15 VPWR VGND VPWR VGND sky130_ef_sc_hd__decap_12
XFILLER_0_35_273 VGND VGND VPWR VPWR sky130_fd_sc_hd__decap_6
XFILLER_0_121_610 VGND VGND VPWR VPWR sky130_fd_sc_hd__decap_6
XFILLER_0_2_318 VGND VGND VPWR VPWR sky130_fd_sc_hd__decap_3
XFILLER_0_50_221 VPWR VGND VPWR VGND sky130_ef_sc_hd__decap_12
XFILLER_0_120_197 VPWR VGND VPWR VGND sky130_ef_sc_hd__decap_12
X_4981_ _2013_ _2009_ _1999_ VGND VGND VPWR VPWR _2014_ sky130_fd_sc_hd__o21ai_2
XFILLER_0_53_55 VGND VGND VPWR VPWR sky130_fd_sc_hd__fill_1
XFILLER_0_86_674 VGND VGND VPWR VPWR sky130_fd_sc_hd__fill_1
XFILLER_0_58_365 VPWR VGND VPWR VGND sky130_ef_sc_hd__decap_12
X_6720_ sh3\[1\] VGND VGND VPWR VPWR _3710_ sky130_fd_sc_hd__clkbuf_4
Xclkbuf_leaf_43_clk clknet_3_5__leaf_clk VGND VGND VPWR VPWR clknet_leaf_43_clk sky130_fd_sc_hd__clkbuf_16
X_6651_ _3593_ _3594_ _3544_ VGND VGND VPWR VPWR _3646_ sky130_fd_sc_hd__o21ai_1
XFILLER_0_6_602 VPWR VGND VPWR VGND sky130_ef_sc_hd__decap_12
XFILLER_0_116_426 VGND VGND VPWR VPWR sky130_fd_sc_hd__decap_4
X_6582_ _3576_ _3577_ VGND VGND VPWR VPWR _3578_ sky130_fd_sc_hd__nor2_1
X_5602_ _2618_ _2619_ _2493_ VGND VGND VPWR VPWR _2620_ sky130_fd_sc_hd__o21ba_1
XFILLER_0_26_240 VPWR VGND VPWR VGND sky130_ef_sc_hd__decap_12
X_8321_ _1155_ _1158_ carry5\[8\] VGND VGND VPWR VPWR _1159_ sky130_fd_sc_hd__o21bai_1
XFILLER_0_6_657 VPWR VGND VPWR VGND sky130_ef_sc_hd__decap_12
XFILLER_0_14_413 VGND VGND VPWR VPWR sky130_fd_sc_hd__decap_6
X_5533_ _2550_ _2549_ _2547_ _2524_ VGND VGND VPWR VPWR _2552_ sky130_fd_sc_hd__o211a_1
XFILLER_0_5_167 VGND VGND VPWR VPWR sky130_fd_sc_hd__fill_1
XFILLER_0_111_120 VGND VGND VPWR VPWR sky130_fd_sc_hd__fill_1
XFILLER_0_78_41 VPWR VGND VPWR VGND sky130_ef_sc_hd__decap_12
X_8252_ _1096_ _1046_ _1044_ _1094_ VGND VGND VPWR VPWR _1097_ sky130_fd_sc_hd__o211ai_2
X_5464_ sh1\[0\] VGND VGND VPWR VPWR _2484_ sky130_fd_sc_hd__clkbuf_4
X_4415_ _1442_ _1445_ _1389_ _1449_ VGND VGND VPWR VPWR _1461_ sky130_fd_sc_hd__o2bb2a_1
XFILLER_0_78_85 VPWR VGND VPWR VGND sky130_ef_sc_hd__decap_12
X_8183_ _1022_ _1026_ _1028_ VGND VGND VPWR VPWR _1029_ sky130_fd_sc_hd__a21o_1
X_7203_ _4128_ VGND VGND VPWR VPWR _0232_ sky130_fd_sc_hd__inv_2
X_5395_ _2246_ _2312_ _2313_ _2363_ VGND VGND VPWR VPWR _2420_ sky130_fd_sc_hd__o211ai_1
X_4346_ _1227_ sh12\[5\] _1387_ _1392_ VGND VGND VPWR VPWR _1393_ sky130_fd_sc_hd__a22o_1
X_7134_ s0\[2\] s1\[2\] VGND VGND VPWR VPWR _4112_ sky130_fd_sc_hd__xnor2_1
X_4277_ _1285_ _1323_ _1324_ VGND VGND VPWR VPWR _1325_ sky130_fd_sc_hd__a21o_1
XFILLER_0_94_62 VGND VGND VPWR VPWR sky130_fd_sc_hd__fill_1
X_7065_ _4045_ _4047_ _4049_ VGND VGND VPWR VPWR _4050_ sky130_fd_sc_hd__a21oi_2
X_6016_ _2962_ _2953_ _3023_ VGND VGND VPWR VPWR _3024_ sky130_fd_sc_hd__a21oi_2
XTAP_1339 VGND VPWR sky130_fd_sc_hd__tapvpwrvgnd_1
XTAP_1328 VGND VPWR sky130_fd_sc_hd__tapvpwrvgnd_1
XTAP_1317 VGND VPWR sky130_fd_sc_hd__tapvpwrvgnd_1
XTAP_1306 VGND VPWR sky130_fd_sc_hd__tapvpwrvgnd_1
X_7967_ net42 sh3\[3\] VGND VGND VPWR VPWR _0816_ sky130_fd_sc_hd__and2_2
XFILLER_0_49_321 VGND VGND VPWR VPWR sky130_fd_sc_hd__fill_1
Xclkbuf_leaf_34_clk clknet_3_4__leaf_clk VGND VGND VPWR VPWR clknet_leaf_34_clk sky130_fd_sc_hd__clkbuf_16
X_7898_ net35 VGND VGND VPWR VPWR _0748_ sky130_fd_sc_hd__buf_2
X_6918_ _3838_ _3845_ _3839_ VGND VGND VPWR VPWR _3905_ sky130_fd_sc_hd__o21ai_1
XFILLER_0_76_173 VGND VGND VPWR VPWR sky130_fd_sc_hd__fill_1
X_6849_ sh1\[1\] _3703_ VGND VGND VPWR VPWR _3837_ sky130_fd_sc_hd__nor2_1
XFILLER_0_37_549 VGND VGND VPWR VPWR sky130_fd_sc_hd__decap_3
XFILLER_0_49_387 VGND VGND VPWR VPWR sky130_fd_sc_hd__fill_1
XFILLER_0_64_357 VGND VGND VPWR VPWR sky130_fd_sc_hd__decap_3
XFILLER_0_92_699 VGND VGND VPWR VPWR sky130_fd_sc_hd__fill_1
XFILLER_0_17_251 VGND VGND VPWR VPWR sky130_fd_sc_hd__decap_8
X_8519_ clknet_leaf_26_clk _0099_ _0270_ VGND VGND VPWR VPWR sum5\[9\] sky130_fd_sc_hd__dfrtp_1
XFILLER_0_17_295 VGND VGND VPWR VPWR sky130_fd_sc_hd__fill_2
XFILLER_0_32_287 VPWR VGND VPWR VGND sky130_ef_sc_hd__decap_12
Xhold380 carry3\[11\] VGND VGND VPWR VPWR net422 sky130_fd_sc_hd__dlygate4sd3_1
Xhold391 sh15\[1\] VGND VGND VPWR VPWR net433 sky130_fd_sc_hd__dlygate4sd3_1
XTAP_1851 VGND VPWR sky130_fd_sc_hd__tapvpwrvgnd_1
XTAP_1840 VGND VPWR sky130_fd_sc_hd__tapvpwrvgnd_1
XFILLER_0_114_27 VGND VGND VPWR VPWR sky130_fd_sc_hd__fill_1
Xclkbuf_leaf_25_clk clknet_3_7__leaf_clk VGND VGND VPWR VPWR clknet_leaf_25_clk sky130_fd_sc_hd__clkbuf_16
XTAP_1884 VGND VPWR sky130_fd_sc_hd__tapvpwrvgnd_1
XTAP_1873 VGND VPWR sky130_fd_sc_hd__tapvpwrvgnd_1
XTAP_1862 VGND VPWR sky130_fd_sc_hd__tapvpwrvgnd_1
XFILLER_0_83_633 VGND VGND VPWR VPWR sky130_fd_sc_hd__fill_1
XFILLER_0_83_611 VGND VGND VPWR VPWR sky130_fd_sc_hd__decap_4
XFILLER_0_68_696 VGND VGND VPWR VPWR sky130_fd_sc_hd__decap_4
XFILLER_0_82_121 VPWR VGND VPWR VGND sky130_ef_sc_hd__decap_12
XFILLER_0_83_699 VGND VGND VPWR VPWR sky130_fd_sc_hd__fill_1
XFILLER_0_82_165 VPWR VGND VPWR VGND sky130_ef_sc_hd__decap_12
XFILLER_0_11_449 VGND VGND VPWR VPWR sky130_fd_sc_hd__decap_6
XFILLER_0_48_33 VGND VGND VPWR VPWR sky130_fd_sc_hd__fill_1
X_5180_ _2206_ _2207_ _2051_ VGND VGND VPWR VPWR _2208_ sky130_fd_sc_hd__o21ai_2
XFILLER_0_3_57 VPWR VGND VPWR VGND sky130_ef_sc_hd__decap_12
X_8870_ clknet_leaf_58_clk net366 _0621_ VGND VGND VPWR VPWR sh15\[2\] sky130_fd_sc_hd__dfrtp_4
X_7821_ carry2\[9\] sum2\[10\] VGND VGND VPWR VPWR _0696_ sky130_fd_sc_hd__xnor2_1
XFILLER_0_59_641 VGND VGND VPWR VPWR sky130_fd_sc_hd__fill_1
X_4964_ _1996_ _1997_ VGND VGND VPWR VPWR _1998_ sky130_fd_sc_hd__and2_1
Xclkbuf_leaf_16_clk clknet_3_6__leaf_clk VGND VGND VPWR VPWR clknet_leaf_16_clk sky130_fd_sc_hd__clkbuf_16
X_7752_ net365 _0655_ VGND VGND VPWR VPWR _0090_ sky130_fd_sc_hd__nand2_1
XFILLER_0_19_505 VGND VGND VPWR VPWR sky130_fd_sc_hd__fill_1
X_6703_ _3687_ _3693_ _3695_ VGND VGND VPWR VPWR _0125_ sky130_fd_sc_hd__a21oi_1
XFILLER_0_80_53 VPWR VGND VPWR VGND sky130_ef_sc_hd__decap_12
X_4895_ _1928_ _1723_ _1929_ VGND VGND VPWR VPWR _1930_ sky130_fd_sc_hd__a21oi_1
X_7683_ _4204_ _4205_ VGND VGND VPWR VPWR _0083_ sky130_fd_sc_hd__nand2_1
XFILLER_0_80_97 VPWR VGND VPWR VGND sky130_ef_sc_hd__decap_12
XFILLER_0_74_677 VGND VGND VPWR VPWR sky130_fd_sc_hd__fill_1
XFILLER_0_73_121 VPWR VGND VPWR VGND sky130_ef_sc_hd__decap_12
X_6634_ _3620_ _3626_ _3627_ _3628_ VGND VGND VPWR VPWR _3629_ sky130_fd_sc_hd__o2bb2ai_2
XFILLER_0_74_688 VPWR VGND VPWR VGND sky130_ef_sc_hd__decap_12
XFILLER_0_73_176 VGND VGND VPWR VPWR sky130_fd_sc_hd__fill_1
XFILLER_0_104_429 VGND VGND VPWR VPWR sky130_fd_sc_hd__decap_4
XFILLER_0_89_51 VGND VGND VPWR VPWR sky130_fd_sc_hd__decap_4
X_6565_ _3560_ _3556_ VGND VGND VPWR VPWR _3561_ sky130_fd_sc_hd__nand2_4
XFILLER_0_80_3 VPWR VGND VPWR VGND sky130_ef_sc_hd__decap_12
X_6496_ _3295_ _3289_ _3428_ VGND VGND VPWR VPWR _3493_ sky130_fd_sc_hd__a21oi_2
X_8304_ _1141_ _1142_ carry5\[7\] VGND VGND VPWR VPWR _1143_ sky130_fd_sc_hd__o21bai_1
X_5516_ _2489_ _2491_ sh14\[0\] _2534_ VGND VGND VPWR VPWR _2535_ sky130_fd_sc_hd__a211o_1
XFILLER_0_42_552 VGND VGND VPWR VPWR sky130_fd_sc_hd__decap_3
XFILLER_0_112_440 VGND VGND VPWR VPWR sky130_fd_sc_hd__decap_8
X_8235_ _1028_ _1026_ _1022_ VGND VGND VPWR VPWR _1080_ sky130_fd_sc_hd__a21bo_1
X_5447_ sh10\[0\] net30 VGND VGND VPWR VPWR _2467_ sky130_fd_sc_hd__nor2_1
XFILLER_0_30_725 VGND VGND VPWR VPWR sky130_fd_sc_hd__decap_8
XFILLER_0_2_693 VGND VGND VPWR VPWR sky130_fd_sc_hd__decap_6
X_8166_ _0736_ _0737_ _0723_ VGND VGND VPWR VPWR _1012_ sky130_fd_sc_hd__o21a_1
XFILLER_0_1_181 VPWR VGND VPWR VGND sky130_ef_sc_hd__decap_12
X_5378_ _2048_ _2041_ _2110_ _2343_ VGND VGND VPWR VPWR _2403_ sky130_fd_sc_hd__a22o_1
X_4329_ _1292_ _1302_ _1296_ VGND VGND VPWR VPWR _1376_ sky130_fd_sc_hd__a21boi_4
X_8097_ _0765_ _0931_ _0943_ VGND VGND VPWR VPWR _0944_ sky130_fd_sc_hd__o21ai_2
X_7117_ _4073_ _4070_ _4079_ _4085_ VGND VGND VPWR VPWR _4100_ sky130_fd_sc_hd__a22oi_2
X_7048_ _4022_ _4020_ _3973_ VGND VGND VPWR VPWR _4033_ sky130_fd_sc_hd__a21o_1
XFILLER_0_97_725 VGND VGND VPWR VPWR sky130_fd_sc_hd__decap_3
XFILLER_0_69_449 VGND VGND VPWR VPWR sky130_fd_sc_hd__decap_3
XTAP_1114 VGND VPWR sky130_fd_sc_hd__tapvpwrvgnd_1
XTAP_1103 VGND VPWR sky130_fd_sc_hd__tapvpwrvgnd_1
XTAP_1147 VGND VPWR sky130_fd_sc_hd__tapvpwrvgnd_1
XTAP_1125 VGND VPWR sky130_fd_sc_hd__tapvpwrvgnd_1
XTAP_1136 VGND VPWR sky130_fd_sc_hd__tapvpwrvgnd_1
XTAP_1169 VGND VPWR sky130_fd_sc_hd__tapvpwrvgnd_1
XTAP_1158 VGND VPWR sky130_fd_sc_hd__tapvpwrvgnd_1
XFILLER_0_108_713 VPWR VGND VPWR VGND sky130_ef_sc_hd__decap_12
XFILLER_0_92_441 VGND VGND VPWR VPWR sky130_fd_sc_hd__decap_6
XFILLER_0_64_132 VGND VGND VPWR VPWR sky130_fd_sc_hd__fill_2
XFILLER_0_107_223 VGND VGND VPWR VPWR sky130_fd_sc_hd__fill_1
XFILLER_0_92_463 VPWR VGND VPWR VGND sky130_ef_sc_hd__decap_12
XFILLER_0_64_165 VGND VGND VPWR VPWR sky130_fd_sc_hd__decap_4
XFILLER_0_107_278 VGND VGND VPWR VPWR sky130_fd_sc_hd__fill_2
XFILLER_0_107_289 VGND VGND VPWR VPWR sky130_fd_sc_hd__decap_8
XFILLER_0_100_29 VGND VGND VPWR VPWR sky130_fd_sc_hd__fill_2
XFILLER_0_60_382 VPWR VGND VPWR VGND sky130_ef_sc_hd__decap_12
XFILLER_0_103_473 VGND VGND VPWR VPWR sky130_fd_sc_hd__decap_3
XFILLER_0_20_246 VGND VGND VPWR VPWR sky130_fd_sc_hd__decap_6
XFILLER_0_20_257 VGND VGND VPWR VPWR sky130_fd_sc_hd__fill_1
XTAP_909 VGND VPWR sky130_fd_sc_hd__tapvpwrvgnd_1
XFILLER_0_18_58 VGND VGND VPWR VPWR sky130_fd_sc_hd__fill_1
XTAP_1692 VGND VPWR sky130_fd_sc_hd__tapvpwrvgnd_1
XTAP_1681 VGND VPWR sky130_fd_sc_hd__tapvpwrvgnd_1
XTAP_1670 VGND VPWR sky130_fd_sc_hd__tapvpwrvgnd_1
XFILLER_0_28_357 VGND VGND VPWR VPWR sky130_fd_sc_hd__decap_3
X_4680_ _1662_ sh12\[7\] VGND VGND VPWR VPWR _1718_ sky130_fd_sc_hd__nor2_1
XFILLER_0_56_677 VPWR VGND VPWR VGND sky130_ef_sc_hd__decap_12
XFILLER_0_43_305 VGND VGND VPWR VPWR sky130_fd_sc_hd__fill_1
XFILLER_0_119_3 VPWR VGND VPWR VGND sky130_ef_sc_hd__decap_12
XFILLER_0_71_669 VGND VGND VPWR VPWR sky130_fd_sc_hd__decap_3
X_6350_ _3328_ _3331_ _3311_ VGND VGND VPWR VPWR _3349_ sky130_fd_sc_hd__o21ai_2
XFILLER_0_3_413 VGND VGND VPWR VPWR sky130_fd_sc_hd__fill_1
XFILLER_0_59_21 VGND VGND VPWR VPWR sky130_fd_sc_hd__decap_6
XFILLER_0_12_725 VGND VGND VPWR VPWR sky130_fd_sc_hd__decap_8
X_5301_ _2040_ _2102_ VGND VGND VPWR VPWR _2327_ sky130_fd_sc_hd__or2_1
XFILLER_0_51_360 VGND VGND VPWR VPWR sky130_fd_sc_hd__decap_8
X_6281_ _3281_ _3282_ VGND VGND VPWR VPWR _0144_ sky130_fd_sc_hd__nand2_2
XFILLER_0_51_393 VGND VGND VPWR VPWR sky130_fd_sc_hd__fill_1
Xclkbuf_leaf_5_clk clknet_3_2__leaf_clk VGND VGND VPWR VPWR clknet_leaf_5_clk sky130_fd_sc_hd__clkbuf_16
XFILLER_0_59_87 VPWR VGND VPWR VGND sky130_ef_sc_hd__decap_12
X_8020_ _0866_ _0867_ _0734_ VGND VGND VPWR VPWR _0868_ sky130_fd_sc_hd__o21bai_4
XFILLER_0_11_268 VGND VGND VPWR VPWR sky130_fd_sc_hd__decap_8
X_5232_ _2053_ _2054_ _2038_ VGND VGND VPWR VPWR _2259_ sky130_fd_sc_hd__o21ai_2
X_5163_ _2102_ sh9\[2\] VGND VGND VPWR VPWR _2191_ sky130_fd_sc_hd__and2_1
X_5094_ _2071_ _2069_ sh14\[2\] _2122_ VGND VGND VPWR VPWR _2123_ sky130_fd_sc_hd__a211o_1
XFILLER_0_79_725 VGND VGND VPWR VPWR sky130_fd_sc_hd__decap_3
X_8853_ clknet_leaf_53_clk net29 _0604_ VGND VGND VPWR VPWR sh13\[1\] sky130_fd_sc_hd__dfrtp_4
XFILLER_0_93_205 VGND VGND VPWR VPWR sky130_fd_sc_hd__fill_1
X_7804_ s0\[7\] net387 _0687_ VGND VGND VPWR VPWR _0007_ sky130_fd_sc_hd__o21a_1
XPHY_219 VGND VGND VPWR VPWR sky130_fd_sc_hd__decap_3
XPHY_208 VGND VGND VPWR VPWR sky130_fd_sc_hd__decap_3
X_5996_ _2950_ _2998_ _3000_ _3001_ _3003_ VGND VGND VPWR VPWR _3004_ sky130_fd_sc_hd__o221ai_4
XFILLER_0_91_96 VPWR VGND VPWR VGND sky130_ef_sc_hd__decap_12
X_8784_ clknet_leaf_3_clk net213 _0535_ VGND VGND VPWR VPWR sh4\[4\] sky130_fd_sc_hd__dfrtp_4
X_4947_ _1968_ _1971_ _1972_ VGND VGND VPWR VPWR _1981_ sky130_fd_sc_hd__a21oi_2
XFILLER_0_93_249 VGND VGND VPWR VPWR sky130_fd_sc_hd__decap_8
XFILLER_0_74_430 VGND VGND VPWR VPWR sky130_fd_sc_hd__decap_8
X_7735_ _0640_ _0641_ net375 VGND VGND VPWR VPWR _0642_ sky130_fd_sc_hd__o21ai_1
XFILLER_0_19_335 VGND VGND VPWR VPWR sky130_fd_sc_hd__fill_1
X_4878_ _1652_ _1643_ VGND VGND VPWR VPWR _1913_ sky130_fd_sc_hd__nand2_1
XFILLER_0_74_474 VGND VGND VPWR VPWR sky130_fd_sc_hd__fill_2
X_7666_ _4190_ _4191_ net342 VGND VGND VPWR VPWR _4192_ sky130_fd_sc_hd__o21ai_1
XFILLER_0_62_625 VGND VGND VPWR VPWR sky130_fd_sc_hd__decap_4
XFILLER_0_19_379 VPWR VGND VPWR VGND sky130_ef_sc_hd__decap_12
XFILLER_0_46_154 VGND VGND VPWR VPWR sky130_fd_sc_hd__decap_8
XFILLER_0_105_705 VGND VGND VPWR VPWR sky130_fd_sc_hd__decap_3
X_6617_ sh13\[4\] sh9\[4\] VGND VGND VPWR VPWR _3612_ sky130_fd_sc_hd__and2_1
XFILLER_0_61_113 VGND VGND VPWR VPWR sky130_fd_sc_hd__fill_2
XFILLER_0_6_251 VGND VGND VPWR VPWR sky130_fd_sc_hd__fill_1
XFILLER_0_61_146 VGND VGND VPWR VPWR sky130_fd_sc_hd__decap_8
X_7597_ _4166_ VGND VGND VPWR VPWR _0588_ sky130_fd_sc_hd__inv_2
X_6548_ _3543_ _3544_ VGND VGND VPWR VPWR _3545_ sky130_fd_sc_hd__and2b_1
X_6479_ _3475_ _3476_ sh13\[4\] VGND VGND VPWR VPWR _3477_ sky130_fd_sc_hd__a21o_1
XFILLER_0_30_533 VGND VGND VPWR VPWR sky130_fd_sc_hd__fill_1
X_8218_ _0776_ _1013_ _1006_ VGND VGND VPWR VPWR _1063_ sky130_fd_sc_hd__o21ai_1
XFILLER_0_30_599 VGND VGND VPWR VPWR sky130_fd_sc_hd__decap_4
X_8149_ _0925_ _0995_ VGND VGND VPWR VPWR _0112_ sky130_fd_sc_hd__xnor2_1
XFILLER_0_100_487 VPWR VGND VPWR VGND sky130_ef_sc_hd__decap_12
XFILLER_0_38_622 VGND VGND VPWR VPWR sky130_fd_sc_hd__fill_1
XFILLER_0_37_154 VPWR VGND VPWR VGND sky130_ef_sc_hd__decap_12
XFILLER_0_80_433 VPWR VGND VPWR VGND sky130_ef_sc_hd__decap_12
XFILLER_0_20_26 VGND VGND VPWR VPWR sky130_fd_sc_hd__fill_2
XFILLER_0_0_405 VPWR VGND VPWR VGND sky130_ef_sc_hd__decap_12
XFILLER_0_33_393 VGND VGND VPWR VPWR sky130_fd_sc_hd__decap_3
XFILLER_0_103_281 VGND VGND VPWR VPWR sky130_fd_sc_hd__decap_8
XFILLER_0_103_270 VGND VGND VPWR VPWR sky130_fd_sc_hd__decap_8
XFILLER_0_0_449 VPWR VGND VPWR VGND sky130_ef_sc_hd__decap_12
XTAP_706 VGND VPWR sky130_fd_sc_hd__tapvpwrvgnd_1
XTAP_717 VGND VPWR sky130_fd_sc_hd__tapvpwrvgnd_1
XTAP_728 VGND VPWR sky130_fd_sc_hd__tapvpwrvgnd_1
XTAP_739 VGND VPWR sky130_fd_sc_hd__tapvpwrvgnd_1
Xmax_cap1 _2551_ VGND VGND VPWR VPWR net453 sky130_fd_sc_hd__clkbuf_2
XFILLER_0_48_408 VGND VGND VPWR VPWR sky130_fd_sc_hd__fill_2
X_5850_ _2862_ _2857_ _2856_ VGND VGND VPWR VPWR _2863_ sky130_fd_sc_hd__a21oi_1
XFILLER_0_48_419 VGND VGND VPWR VPWR sky130_fd_sc_hd__fill_1
X_4801_ _1775_ _1777_ _1835_ _1646_ _1836_ VGND VGND VPWR VPWR _1837_ sky130_fd_sc_hd__o221a_2
XFILLER_0_0_69 VPWR VGND VPWR VGND sky130_ef_sc_hd__decap_12
X_5781_ _2788_ _2784_ _2787_ VGND VGND VPWR VPWR _2796_ sky130_fd_sc_hd__nand3_4
X_4732_ _1649_ _1637_ _1768_ VGND VGND VPWR VPWR _1769_ sky130_fd_sc_hd__a21oi_1
X_7520_ _4159_ VGND VGND VPWR VPWR _0518_ sky130_fd_sc_hd__inv_2
X_4663_ sh0\[7\] net40 VGND VGND VPWR VPWR _1701_ sky130_fd_sc_hd__and2_2
X_7451_ _4152_ VGND VGND VPWR VPWR _0456_ sky130_fd_sc_hd__inv_2
XFILLER_0_16_338 VGND VGND VPWR VPWR sky130_fd_sc_hd__fill_2
X_6402_ _3400_ _3393_ _3395_ VGND VGND VPWR VPWR _3401_ sky130_fd_sc_hd__nand3_1
XFILLER_0_44_669 VPWR VGND VPWR VGND sky130_ef_sc_hd__decap_12
XFILLER_0_101_50 VGND VGND VPWR VPWR sky130_fd_sc_hd__decap_6
X_4594_ _1350_ _1633_ VGND VGND VPWR VPWR _1634_ sky130_fd_sc_hd__nand2_1
X_7382_ _4145_ VGND VGND VPWR VPWR _0394_ sky130_fd_sc_hd__inv_2
XFILLER_0_24_382 VPWR VGND VPWR VGND sky130_ef_sc_hd__decap_12
X_6333_ _3328_ _3331_ _3311_ VGND VGND VPWR VPWR _3332_ sky130_fd_sc_hd__o21a_1
XFILLER_0_12_533 VGND VGND VPWR VPWR sky130_fd_sc_hd__decap_6
X_6264_ _3228_ _3241_ _3266_ _3243_ VGND VGND VPWR VPWR _3268_ sky130_fd_sc_hd__o211ai_1
XFILLER_0_86_41 VPWR VGND VPWR VGND sky130_ef_sc_hd__decap_12
X_5215_ _2238_ _2242_ _2106_ VGND VGND VPWR VPWR _2243_ sky130_fd_sc_hd__a21o_1
X_8003_ _0846_ _0849_ _0851_ VGND VGND VPWR VPWR _0852_ sky130_fd_sc_hd__a21o_1
X_6195_ _2886_ _2875_ VGND VGND VPWR VPWR _3200_ sky130_fd_sc_hd__nor2_1
XFILLER_0_86_85 VPWR VGND VPWR VGND sky130_ef_sc_hd__decap_12
XFILLER_0_43_3 VPWR VGND VPWR VGND sky130_ef_sc_hd__decap_12
X_5146_ _2120_ _2128_ _2121_ VGND VGND VPWR VPWR _2175_ sky130_fd_sc_hd__a21boi_1
XFILLER_0_19_90 VPWR VGND VPWR VGND sky130_ef_sc_hd__decap_12
X_5077_ sh13\[2\] VGND VGND VPWR VPWR _2106_ sky130_fd_sc_hd__buf_4
XFILLER_0_79_577 VGND VGND VPWR VPWR sky130_fd_sc_hd__decap_4
XFILLER_0_39_408 VGND VGND VPWR VPWR sky130_fd_sc_hd__decap_8
X_8836_ clknet_leaf_50_clk net232 _0587_ VGND VGND VPWR VPWR sh11\[0\] sky130_fd_sc_hd__dfrtp_1
X_5979_ _2987_ VGND VGND VPWR VPWR _2988_ sky130_fd_sc_hd__inv_2
X_8767_ clknet_leaf_5_clk net179 _0518_ VGND VGND VPWR VPWR sh2\[3\] sky130_fd_sc_hd__dfrtp_2
XFILLER_0_19_110 VGND VGND VPWR VPWR sky130_fd_sc_hd__fill_2
XFILLER_0_19_121 VGND VGND VPWR VPWR sky130_fd_sc_hd__fill_1
XFILLER_0_47_452 VPWR VGND VPWR VGND sky130_ef_sc_hd__decap_12
X_7718_ carry1\[7\] sum1\[8\] VGND VGND VPWR VPWR _0631_ sky130_fd_sc_hd__xnor2_1
XFILLER_0_35_658 VPWR VGND VPWR VGND sky130_ef_sc_hd__decap_12
X_8698_ clknet_leaf_58_clk _0162_ _0449_ VGND VGND VPWR VPWR bit_sum2\[9\] sky130_fd_sc_hd__dfrtp_1
X_7649_ sum3\[7\] carry3\[6\] VGND VGND VPWR VPWR _4178_ sky130_fd_sc_hd__and2_1
XFILLER_0_105_546 VGND VGND VPWR VPWR sky130_fd_sc_hd__decap_4
XFILLER_0_62_499 VGND VGND VPWR VPWR sky130_fd_sc_hd__decap_3
XFILLER_0_50_639 VGND VGND VPWR VPWR sky130_fd_sc_hd__decap_4
XFILLER_0_15_393 VGND VGND VPWR VPWR sky130_fd_sc_hd__decap_8
XFILLER_0_100_251 VGND VGND VPWR VPWR sky130_fd_sc_hd__fill_1
XFILLER_0_15_15 VPWR VGND VPWR VGND sky130_ef_sc_hd__decap_12
XFILLER_0_57_205 VPWR VGND VPWR VGND sky130_ef_sc_hd__decap_12
XFILLER_0_85_558 VGND VGND VPWR VPWR sky130_fd_sc_hd__fill_2
XFILLER_0_122_27 VGND VGND VPWR VPWR sky130_fd_sc_hd__fill_1
XFILLER_0_38_474 VGND VGND VPWR VPWR sky130_fd_sc_hd__fill_2
XFILLER_0_65_293 VGND VGND VPWR VPWR sky130_fd_sc_hd__decap_3
XFILLER_0_31_47 VGND VGND VPWR VPWR sky130_fd_sc_hd__decap_3
XFILLER_0_108_395 VGND VGND VPWR VPWR sky130_fd_sc_hd__decap_6
XFILLER_0_108_373 VGND VGND VPWR VPWR sky130_fd_sc_hd__fill_2
XFILLER_0_13_308 VGND VGND VPWR VPWR sky130_fd_sc_hd__fill_2
XFILLER_0_25_135 VGND VGND VPWR VPWR sky130_fd_sc_hd__decap_4
XFILLER_0_25_157 VGND VGND VPWR VPWR sky130_fd_sc_hd__fill_1
XFILLER_0_123_321 VPWR VGND VPWR VGND sky130_ef_sc_hd__decap_12
XFILLER_0_34_680 VPWR VGND VPWR VGND sky130_ef_sc_hd__decap_12
XFILLER_0_123_376 VPWR VGND VPWR VGND sky130_ef_sc_hd__decap_12
XFILLER_0_123_365 VGND VGND VPWR VPWR sky130_fd_sc_hd__decap_4
Xhold209 carry2\[2\] VGND VGND VPWR VPWR net251 sky130_fd_sc_hd__dlygate4sd3_1
XFILLER_0_33_190 VPWR VGND VPWR VGND sky130_ef_sc_hd__decap_12
XTAP_503 VGND VPWR sky130_fd_sc_hd__tapvpwrvgnd_1
XTAP_525 VGND VPWR sky130_fd_sc_hd__tapvpwrvgnd_1
XTAP_514 VGND VPWR sky130_fd_sc_hd__tapvpwrvgnd_1
X_5000_ _2025_ _2026_ _2030_ _2031_ VGND VGND VPWR VPWR _2032_ sky130_fd_sc_hd__o2bb2ai_1
XTAP_536 VGND VPWR sky130_fd_sc_hd__tapvpwrvgnd_1
XTAP_547 VGND VPWR sky130_fd_sc_hd__tapvpwrvgnd_1
XTAP_558 VGND VPWR sky130_fd_sc_hd__tapvpwrvgnd_1
XTAP_569 VGND VPWR sky130_fd_sc_hd__tapvpwrvgnd_1
X_6951_ _3855_ _3870_ _3878_ VGND VGND VPWR VPWR _3938_ sky130_fd_sc_hd__a21oi_2
X_5902_ sh2\[6\] VGND VGND VPWR VPWR _2911_ sky130_fd_sc_hd__clkbuf_4
XFILLER_0_88_363 VGND VGND VPWR VPWR sky130_fd_sc_hd__fill_1
XFILLER_0_76_536 VGND VGND VPWR VPWR sky130_fd_sc_hd__decap_8
X_6882_ _3857_ _3868_ _3869_ VGND VGND VPWR VPWR _3870_ sky130_fd_sc_hd__a21oi_1
X_5833_ _2843_ _2845_ _2846_ VGND VGND VPWR VPWR _2847_ sky130_fd_sc_hd__o21ai_2
X_8621_ clknet_leaf_56_clk net125 _0372_ VGND VGND VPWR VPWR s3\[4\] sky130_fd_sc_hd__dfrtp_1
XFILLER_0_118_137 VGND VGND VPWR VPWR sky130_fd_sc_hd__decap_3
X_8552_ clknet_leaf_39_clk net133 _0303_ VGND VGND VPWR VPWR sum4\[2\] sky130_fd_sc_hd__dfrtp_1
X_7503_ _4157_ VGND VGND VPWR VPWR _0503_ sky130_fd_sc_hd__inv_2
XFILLER_0_56_271 VPWR VGND VPWR VGND sky130_ef_sc_hd__decap_12
X_5764_ _2521_ _2672_ sh14\[0\] VGND VGND VPWR VPWR _2779_ sky130_fd_sc_hd__o21a_1
X_4715_ _1734_ _1750_ _1729_ _1752_ _1746_ VGND VGND VPWR VPWR _1753_ sky130_fd_sc_hd__a32oi_4
X_5695_ _2708_ _2710_ _2711_ VGND VGND VPWR VPWR _2712_ sky130_fd_sc_hd__a21oi_2
X_8483_ clknet_leaf_41_clk net159 _0234_ VGND VGND VPWR VPWR net21 sky130_fd_sc_hd__dfrtp_1
XFILLER_0_114_321 VPWR VGND VPWR VGND sky130_ef_sc_hd__decap_12
X_4646_ _1651_ _1682_ _1683_ VGND VGND VPWR VPWR _1684_ sky130_fd_sc_hd__o21ai_4
XFILLER_0_4_530 VGND VGND VPWR VPWR sky130_fd_sc_hd__fill_2
XFILLER_0_16_168 VGND VGND VPWR VPWR sky130_fd_sc_hd__decap_8
X_7434_ _4151_ VGND VGND VPWR VPWR _0440_ sky130_fd_sc_hd__inv_2
X_4577_ _1616_ _1617_ _1594_ _1591_ VGND VGND VPWR VPWR _1620_ sky130_fd_sc_hd__o211ai_1
X_7365_ _4136_ VGND VGND VPWR VPWR _4144_ sky130_fd_sc_hd__buf_4
XFILLER_0_24_190 VGND VGND VPWR VPWR sky130_fd_sc_hd__fill_2
XFILLER_0_114_398 VGND VGND VPWR VPWR sky130_fd_sc_hd__fill_1
X_6316_ _3315_ _3305_ _3302_ VGND VGND VPWR VPWR _3316_ sky130_fd_sc_hd__a21bo_1
X_7296_ _4137_ VGND VGND VPWR VPWR _0316_ sky130_fd_sc_hd__inv_2
X_6247_ _3193_ _3245_ _3248_ _3250_ VGND VGND VPWR VPWR _3251_ sky130_fd_sc_hd__o22a_1
X_6178_ _3175_ _3181_ _3183_ VGND VGND VPWR VPWR _3184_ sky130_fd_sc_hd__nand3b_1
XFILLER_0_99_617 VPWR VGND VPWR VGND sky130_ef_sc_hd__decap_12
X_5129_ _2157_ _2153_ _2151_ VGND VGND VPWR VPWR _2158_ sky130_fd_sc_hd__a21oi_1
XFILLER_0_79_385 VGND VGND VPWR VPWR sky130_fd_sc_hd__decap_6
XFILLER_0_67_525 VGND VGND VPWR VPWR sky130_fd_sc_hd__decap_6
XFILLER_0_67_514 VGND VGND VPWR VPWR sky130_fd_sc_hd__decap_3
X_8819_ clknet_leaf_16_clk net170 _0570_ VGND VGND VPWR VPWR sh8\[7\] sky130_fd_sc_hd__dfrtp_1
XFILLER_0_109_148 VGND VGND VPWR VPWR sky130_fd_sc_hd__fill_1
XFILLER_0_47_293 VGND VGND VPWR VPWR sky130_fd_sc_hd__decap_3
XFILLER_0_23_617 VPWR VGND VPWR VGND sky130_ef_sc_hd__decap_12
XFILLER_0_120_302 VGND VGND VPWR VPWR sky130_fd_sc_hd__fill_2
XFILLER_0_22_127 VPWR VGND VPWR VGND sky130_ef_sc_hd__decap_12
XFILLER_0_50_436 VPWR VGND VPWR VGND sky130_ef_sc_hd__decap_12
XFILLER_0_30_193 VGND VGND VPWR VPWR sky130_fd_sc_hd__decap_3
XFILLER_0_117_27 VPWR VGND VPWR VGND sky130_ef_sc_hd__decap_12
Xhold92 bit_sum7\[1\] VGND VGND VPWR VPWR net134 sky130_fd_sc_hd__dlygate4sd3_1
Xhold70 bit_sum5\[0\] VGND VGND VPWR VPWR net112 sky130_fd_sc_hd__dlygate4sd3_1
XFILLER_0_26_25 VGND VGND VPWR VPWR sky130_fd_sc_hd__decap_3
Xhold81 bit_sum3\[2\] VGND VGND VPWR VPWR net123 sky130_fd_sc_hd__dlygate4sd3_1
XFILLER_0_26_69 VPWR VGND VPWR VGND sky130_ef_sc_hd__decap_12
XFILLER_0_98_683 VPWR VGND VPWR VGND sky130_ef_sc_hd__decap_12
XFILLER_0_97_160 VGND VGND VPWR VPWR sky130_fd_sc_hd__fill_1
XFILLER_0_85_300 VPWR VGND VPWR VGND sky130_ef_sc_hd__decap_12
XFILLER_0_85_333 VGND VGND VPWR VPWR sky130_fd_sc_hd__decap_3
XFILLER_0_116_619 VPWR VGND VPWR VGND sky130_ef_sc_hd__decap_12
XFILLER_0_109_660 VGND VGND VPWR VPWR sky130_fd_sc_hd__fill_1
XFILLER_0_38_271 VGND VGND VPWR VPWR sky130_fd_sc_hd__decap_8
X_4500_ _1274_ _1384_ VGND VGND VPWR VPWR _1544_ sky130_fd_sc_hd__nor2_1
XFILLER_0_81_561 VGND VGND VPWR VPWR sky130_fd_sc_hd__fill_2
XFILLER_0_13_116 VGND VGND VPWR VPWR sky130_fd_sc_hd__decap_6
X_5480_ _2488_ _2497_ _2499_ VGND VGND VPWR VPWR _2500_ sky130_fd_sc_hd__a21boi_1
XFILLER_0_5_349 VGND VGND VPWR VPWR sky130_fd_sc_hd__fill_1
XFILLER_0_26_477 VGND VGND VPWR VPWR sky130_fd_sc_hd__decap_3
XFILLER_0_101_3 VGND VGND VPWR VPWR sky130_fd_sc_hd__decap_6
X_4431_ _1465_ _1469_ _1473_ VGND VGND VPWR VPWR _1477_ sky130_fd_sc_hd__o21bai_1
XANTENNA_1 _0111_ VGND VGND VPWR VPWR sky130_fd_sc_hd__diode_2
XFILLER_0_111_324 VGND VGND VPWR VPWR sky130_fd_sc_hd__decap_4
X_4362_ _1408_ _1315_ VGND VGND VPWR VPWR _1409_ sky130_fd_sc_hd__nand2_1
XFILLER_0_21_182 VGND VGND VPWR VPWR sky130_fd_sc_hd__decap_4
X_7150_ s2\[10\] net290 VGND VGND VPWR VPWR _4120_ sky130_fd_sc_hd__nor2_1
X_6101_ _3106_ _3107_ _3104_ VGND VGND VPWR VPWR _3108_ sky130_fd_sc_hd__nand3_1
X_4293_ _1337_ _1338_ _1340_ VGND VGND VPWR VPWR _1341_ sky130_fd_sc_hd__o21ai_1
XFILLER_0_67_65 VGND VGND VPWR VPWR sky130_fd_sc_hd__fill_2
XTAP_333 VGND VPWR sky130_fd_sc_hd__tapvpwrvgnd_1
XTAP_322 VGND VPWR sky130_fd_sc_hd__tapvpwrvgnd_1
XTAP_311 VGND VPWR sky130_fd_sc_hd__tapvpwrvgnd_1
XTAP_300 VGND VPWR sky130_fd_sc_hd__tapvpwrvgnd_1
X_7081_ _4054_ _4052_ _4057_ _4059_ VGND VGND VPWR VPWR _4065_ sky130_fd_sc_hd__a31o_1
X_6032_ _3032_ _3031_ net28 VGND VGND VPWR VPWR _3040_ sky130_fd_sc_hd__o21ai_2
XTAP_366 VGND VPWR sky130_fd_sc_hd__tapvpwrvgnd_1
XTAP_344 VGND VPWR sky130_fd_sc_hd__tapvpwrvgnd_1
XTAP_355 VGND VPWR sky130_fd_sc_hd__tapvpwrvgnd_1
XTAP_399 VGND VPWR sky130_fd_sc_hd__tapvpwrvgnd_1
XTAP_388 VGND VPWR sky130_fd_sc_hd__tapvpwrvgnd_1
XTAP_377 VGND VPWR sky130_fd_sc_hd__tapvpwrvgnd_1
X_7983_ _0825_ _0830_ _0831_ VGND VGND VPWR VPWR _0832_ sky130_fd_sc_hd__o21ai_4
XPHY_28 VGND VGND VPWR VPWR sky130_fd_sc_hd__decap_3
XPHY_17 VGND VGND VPWR VPWR sky130_fd_sc_hd__decap_3
X_6934_ _3767_ _3769_ _3858_ VGND VGND VPWR VPWR _3921_ sky130_fd_sc_hd__a21oi_2
XFILLER_0_49_525 VPWR VGND VPWR VGND sky130_ef_sc_hd__decap_12
XPHY_39 VGND VGND VPWR VPWR sky130_fd_sc_hd__decap_3
XFILLER_0_8_121 VPWR VGND VPWR VGND sky130_ef_sc_hd__decap_12
X_6865_ _3778_ _3780_ VGND VGND VPWR VPWR _3853_ sky130_fd_sc_hd__nor2_1
X_8604_ clknet_leaf_52_clk net108 _0355_ VGND VGND VPWR VPWR s1\[5\] sky130_fd_sc_hd__dfrtp_1
XFILLER_0_107_608 VGND VGND VPWR VPWR sky130_fd_sc_hd__decap_8
XFILLER_0_91_314 VGND VGND VPWR VPWR sky130_fd_sc_hd__decap_4
X_5816_ _2826_ _2773_ _2783_ _2786_ _2777_ VGND VGND VPWR VPWR _2830_ sky130_fd_sc_hd__a221oi_4
X_6796_ _3779_ _3780_ _3783_ _3784_ VGND VGND VPWR VPWR _3785_ sky130_fd_sc_hd__o211ai_2
XFILLER_0_123_81 VGND VGND VPWR VPWR sky130_fd_sc_hd__decap_3
XFILLER_0_106_118 VGND VGND VPWR VPWR sky130_fd_sc_hd__decap_6
X_8535_ clknet_leaf_30_clk net195 _0286_ VGND VGND VPWR VPWR sum3\[9\] sky130_fd_sc_hd__dfrtp_1
XFILLER_0_8_165 VPWR VGND VPWR VGND sky130_ef_sc_hd__decap_12
XFILLER_0_17_444 VGND VGND VPWR VPWR sky130_fd_sc_hd__decap_4
X_5747_ _2724_ _2753_ _2757_ VGND VGND VPWR VPWR _2763_ sky130_fd_sc_hd__nand3_1
X_8466_ clknet_leaf_28_clk net380 _0217_ VGND VGND VPWR VPWR carry5\[13\] sky130_fd_sc_hd__dfrtp_1
XFILLER_0_115_685 VPWR VGND VPWR VGND sky130_ef_sc_hd__decap_12
XFILLER_0_60_734 VGND VGND VPWR VPWR sky130_fd_sc_hd__fill_1
X_5678_ _2678_ _2679_ _2683_ _2688_ VGND VGND VPWR VPWR _2695_ sky130_fd_sc_hd__o211a_1
X_7417_ _4149_ VGND VGND VPWR VPWR _0425_ sky130_fd_sc_hd__inv_2
X_4629_ sh2\[7\] VGND VGND VPWR VPWR _1668_ sky130_fd_sc_hd__buf_4
X_8397_ sh11\[5\] VGND VGND VPWR VPWR _1227_ sky130_fd_sc_hd__buf_4
XFILLER_0_13_661 VGND VGND VPWR VPWR sky130_fd_sc_hd__decap_8
X_7348_ _4142_ VGND VGND VPWR VPWR _0363_ sky130_fd_sc_hd__inv_2
X_7279_ _4135_ VGND VGND VPWR VPWR _0301_ sky130_fd_sc_hd__inv_2
XFILLER_0_67_333 VGND VGND VPWR VPWR sky130_fd_sc_hd__decap_3
XFILLER_0_94_141 VGND VGND VPWR VPWR sky130_fd_sc_hd__decap_4
XFILLER_0_12_27 VGND VGND VPWR VPWR sky130_fd_sc_hd__fill_1
XFILLER_0_63_550 VGND VGND VPWR VPWR sky130_fd_sc_hd__fill_1
XFILLER_0_63_561 VPWR VGND VPWR VGND sky130_ef_sc_hd__decap_12
XFILLER_0_23_425 VGND VGND VPWR VPWR sky130_fd_sc_hd__fill_2
XFILLER_0_23_447 VGND VGND VPWR VPWR sky130_fd_sc_hd__fill_1
XFILLER_0_50_233 VGND VGND VPWR VPWR sky130_fd_sc_hd__decap_8
XFILLER_0_120_121 VPWR VGND VPWR VGND sky130_ef_sc_hd__decap_12
XFILLER_0_11_609 VGND VGND VPWR VPWR sky130_fd_sc_hd__decap_6
XFILLER_0_121_666 VGND VGND VPWR VPWR sky130_fd_sc_hd__decap_6
XFILLER_0_120_154 VGND VGND VPWR VPWR sky130_fd_sc_hd__decap_4
XFILLER_0_37_57 VPWR VGND VPWR VGND sky130_ef_sc_hd__decap_12
XFILLER_0_78_609 VGND VGND VPWR VPWR sky130_fd_sc_hd__fill_1
XFILLER_0_53_23 VPWR VGND VPWR VGND sky130_ef_sc_hd__decap_12
X_4980_ _2008_ _1978_ _2007_ VGND VGND VPWR VPWR _2013_ sky130_fd_sc_hd__and3_1
XFILLER_0_86_653 VGND VGND VPWR VPWR sky130_fd_sc_hd__fill_1
XFILLER_0_58_377 VGND VGND VPWR VPWR sky130_fd_sc_hd__decap_4
XFILLER_0_19_709 VPWR VGND VPWR VGND sky130_ef_sc_hd__decap_12
XFILLER_0_73_314 VPWR VGND VPWR VGND sky130_ef_sc_hd__decap_12
XFILLER_0_73_303 VGND VGND VPWR VPWR sky130_fd_sc_hd__fill_1
X_6650_ _3599_ _3600_ _3644_ VGND VGND VPWR VPWR _3645_ sky130_fd_sc_hd__a21oi_1
XFILLER_0_116_405 VGND VGND VPWR VPWR sky130_fd_sc_hd__fill_1
X_6581_ _3338_ _3451_ _3335_ _3361_ VGND VGND VPWR VPWR _3577_ sky130_fd_sc_hd__a211oi_1
XFILLER_0_73_358 VPWR VGND VPWR VGND sky130_ef_sc_hd__decap_12
X_5601_ sh4\[0\] _2490_ VGND VGND VPWR VPWR _2619_ sky130_fd_sc_hd__nor2_1
XFILLER_0_6_614 VPWR VGND VPWR VGND sky130_ef_sc_hd__decap_12
X_8320_ sum5\[9\] s7\[9\] VGND VGND VPWR VPWR _1158_ sky130_fd_sc_hd__and2_1
XFILLER_0_6_669 VPWR VGND VPWR VGND sky130_ef_sc_hd__decap_12
XFILLER_0_5_113 VPWR VGND VPWR VGND sky130_ef_sc_hd__decap_12
X_5532_ _2524_ _2547_ _2549_ _2550_ VGND VGND VPWR VPWR _2551_ sky130_fd_sc_hd__a211oi_2
XFILLER_0_26_274 VPWR VGND VPWR VGND sky130_ef_sc_hd__decap_12
XFILLER_0_42_701 VPWR VGND VPWR VGND sky130_ef_sc_hd__decap_12
XFILLER_0_81_391 VGND VGND VPWR VPWR sky130_fd_sc_hd__fill_1
XFILLER_0_81_380 VGND VGND VPWR VPWR sky130_fd_sc_hd__decap_4
XFILLER_0_14_447 VGND VGND VPWR VPWR sky130_fd_sc_hd__fill_2
X_5463_ _2478_ _2481_ _2482_ VGND VGND VPWR VPWR _2483_ sky130_fd_sc_hd__o21bai_2
X_8251_ _0994_ _1043_ VGND VGND VPWR VPWR _1096_ sky130_fd_sc_hd__nand2_1
X_4414_ _1455_ _1456_ _1458_ _1459_ VGND VGND VPWR VPWR _1460_ sky130_fd_sc_hd__o22ai_2
XFILLER_0_78_53 VPWR VGND VPWR VGND sky130_ef_sc_hd__decap_12
X_8182_ _1000_ _1001_ VGND VGND VPWR VPWR _1028_ sky130_fd_sc_hd__and2_1
X_7202_ _4128_ VGND VGND VPWR VPWR _0231_ sky130_fd_sc_hd__inv_2
X_5394_ _2411_ _2416_ _2417_ VGND VGND VPWR VPWR _2419_ sky130_fd_sc_hd__nand3_2
XFILLER_0_112_688 VPWR VGND VPWR VGND sky130_ef_sc_hd__decap_12
XFILLER_0_111_165 VGND VGND VPWR VPWR sky130_fd_sc_hd__decap_3
X_4345_ _1385_ _1389_ _1390_ _1391_ VGND VGND VPWR VPWR _1392_ sky130_fd_sc_hd__o211ai_2
X_7133_ net332 _0001_ VGND VGND VPWR VPWR _0051_ sky130_fd_sc_hd__nor2_1
X_4276_ _1275_ _1277_ _1274_ _1279_ VGND VGND VPWR VPWR _1324_ sky130_fd_sc_hd__o22ai_1
X_7064_ _3982_ _4048_ VGND VGND VPWR VPWR _4049_ sky130_fd_sc_hd__nand2_1
X_6015_ _2956_ _3022_ _2955_ VGND VGND VPWR VPWR _3023_ sky130_fd_sc_hd__and3_1
XTAP_1329 VGND VPWR sky130_fd_sc_hd__tapvpwrvgnd_1
XTAP_1318 VGND VPWR sky130_fd_sc_hd__tapvpwrvgnd_1
XTAP_1307 VGND VPWR sky130_fd_sc_hd__tapvpwrvgnd_1
X_7966_ _0776_ _0775_ _0779_ VGND VGND VPWR VPWR _0815_ sky130_fd_sc_hd__o21a_1
XFILLER_0_76_141 VGND VGND VPWR VPWR sky130_fd_sc_hd__decap_8
X_7897_ sh5\[3\] VGND VGND VPWR VPWR _0747_ sky130_fd_sc_hd__clkbuf_4
X_6917_ _3904_ VGND VGND VPWR VPWR _0147_ sky130_fd_sc_hd__clkbuf_1
XFILLER_0_77_686 VGND VGND VPWR VPWR sky130_fd_sc_hd__fill_1
X_6848_ _3715_ _3750_ _3835_ VGND VGND VPWR VPWR _3836_ sky130_fd_sc_hd__a21oi_2
XFILLER_0_107_427 VGND VGND VPWR VPWR sky130_fd_sc_hd__fill_2
X_8518_ clknet_leaf_26_clk _0098_ _0269_ VGND VGND VPWR VPWR sum5\[8\] sky130_fd_sc_hd__dfrtp_2
X_6779_ sh7\[1\] VGND VGND VPWR VPWR _3768_ sky130_fd_sc_hd__buf_2
XFILLER_0_45_550 VGND VGND VPWR VPWR sky130_fd_sc_hd__decap_8
XFILLER_0_45_561 VGND VGND VPWR VPWR sky130_fd_sc_hd__decap_3
XFILLER_0_91_199 VPWR VGND VPWR VGND sky130_ef_sc_hd__decap_12
XFILLER_0_115_493 VGND VGND VPWR VPWR sky130_fd_sc_hd__decap_6
XFILLER_0_60_575 VGND VGND VPWR VPWR sky130_fd_sc_hd__fill_2
X_8449_ clknet_leaf_38_clk net318 _0200_ VGND VGND VPWR VPWR carry3\[4\] sky130_fd_sc_hd__dfrtp_1
XFILLER_0_32_299 VGND VGND VPWR VPWR sky130_fd_sc_hd__decap_8
Xhold381 _0032_ VGND VGND VPWR VPWR net423 sky130_fd_sc_hd__dlygate4sd3_1
XFILLER_0_13_491 VPWR VGND VPWR VGND sky130_ef_sc_hd__decap_12
Xhold370 sh3\[2\] VGND VGND VPWR VPWR net412 sky130_fd_sc_hd__dlygate4sd3_1
Xhold392 sh4\[1\] VGND VGND VPWR VPWR net434 sky130_fd_sc_hd__dlygate4sd3_1
XFILLER_0_99_200 VGND VGND VPWR VPWR sky130_fd_sc_hd__decap_8
XFILLER_0_99_233 VGND VGND VPWR VPWR sky130_fd_sc_hd__fill_1
XFILLER_0_99_288 VGND VGND VPWR VPWR sky130_fd_sc_hd__decap_8
XFILLER_0_99_299 VPWR VGND VPWR VGND sky130_ef_sc_hd__decap_12
XTAP_1852 VGND VPWR sky130_fd_sc_hd__tapvpwrvgnd_1
XTAP_1841 VGND VPWR sky130_fd_sc_hd__tapvpwrvgnd_1
XTAP_1830 VGND VPWR sky130_fd_sc_hd__tapvpwrvgnd_1
XFILLER_0_68_653 VGND VGND VPWR VPWR sky130_fd_sc_hd__decap_3
XTAP_1885 VGND VPWR sky130_fd_sc_hd__tapvpwrvgnd_1
XTAP_1874 VGND VPWR sky130_fd_sc_hd__tapvpwrvgnd_1
XTAP_1863 VGND VPWR sky130_fd_sc_hd__tapvpwrvgnd_1
XFILLER_0_55_325 VGND VGND VPWR VPWR sky130_fd_sc_hd__fill_1
XFILLER_0_23_48 VGND VGND VPWR VPWR sky130_fd_sc_hd__decap_8
XFILLER_0_82_133 VGND VGND VPWR VPWR sky130_fd_sc_hd__decap_6
XFILLER_0_24_701 VPWR VGND VPWR VGND sky130_ef_sc_hd__decap_12
XFILLER_0_3_617 VPWR VGND VPWR VGND sky130_ef_sc_hd__decap_12
XFILLER_0_24_734 VGND VGND VPWR VPWR sky130_fd_sc_hd__fill_1
XFILLER_0_23_244 VGND VGND VPWR VPWR sky130_fd_sc_hd__fill_1
XFILLER_0_121_485 VGND VGND VPWR VPWR sky130_fd_sc_hd__fill_2
XFILLER_0_3_69 VPWR VGND VPWR VGND sky130_ef_sc_hd__decap_12
Xwire26 _3252_ VGND VGND VPWR VPWR net26 sky130_fd_sc_hd__buf_1
X_7820_ net194 _0695_ VGND VGND VPWR VPWR _0079_ sky130_fd_sc_hd__xnor2_1
X_4963_ _1946_ _1992_ _1994_ _1948_ _1953_ VGND VGND VPWR VPWR _1997_ sky130_fd_sc_hd__o2111ai_4
XFILLER_0_93_409 VGND VGND VPWR VPWR sky130_fd_sc_hd__fill_2
X_7751_ net364 _0652_ _0653_ VGND VGND VPWR VPWR _0655_ sky130_fd_sc_hd__or3_1
XFILLER_0_58_141 VGND VGND VPWR VPWR sky130_fd_sc_hd__decap_3
XFILLER_0_86_483 VGND VGND VPWR VPWR sky130_fd_sc_hd__fill_1
X_7682_ net275 _4202_ _4203_ VGND VGND VPWR VPWR _4205_ sky130_fd_sc_hd__or3_1
X_6702_ _3687_ _3692_ _3694_ VGND VGND VPWR VPWR _3695_ sky130_fd_sc_hd__a21oi_1
XFILLER_0_80_65 VPWR VGND VPWR VGND sky130_ef_sc_hd__decap_12
X_4894_ _1677_ _1848_ _1743_ VGND VGND VPWR VPWR _1929_ sky130_fd_sc_hd__o21a_1
XFILLER_0_104_61 VGND VGND VPWR VPWR sky130_fd_sc_hd__fill_1
X_6633_ _3286_ _3377_ sh15\[4\] VGND VGND VPWR VPWR _3628_ sky130_fd_sc_hd__a21oi_1
XFILLER_0_73_133 VGND VGND VPWR VPWR sky130_fd_sc_hd__decap_8
XFILLER_0_6_411 VGND VGND VPWR VPWR sky130_fd_sc_hd__fill_1
XFILLER_0_61_306 VGND VGND VPWR VPWR sky130_fd_sc_hd__decap_8
XFILLER_0_13_81 VGND VGND VPWR VPWR sky130_fd_sc_hd__decap_4
XFILLER_0_27_561 VGND VGND VPWR VPWR sky130_fd_sc_hd__fill_2
XFILLER_0_27_572 VPWR VGND VPWR VGND sky130_ef_sc_hd__decap_12
XFILLER_0_116_268 VGND VGND VPWR VPWR sky130_fd_sc_hd__decap_4
XFILLER_0_104_419 VGND VGND VPWR VPWR sky130_fd_sc_hd__fill_1
X_6564_ _3294_ _3306_ VGND VGND VPWR VPWR _3560_ sky130_fd_sc_hd__nand2_1
XFILLER_0_6_477 VGND VGND VPWR VPWR sky130_fd_sc_hd__fill_2
XFILLER_0_6_455 VGND VGND VPWR VPWR sky130_fd_sc_hd__decap_8
XFILLER_0_89_85 VPWR VGND VPWR VGND sky130_ef_sc_hd__decap_12
X_6495_ _3295_ _3297_ _3326_ VGND VGND VPWR VPWR _3492_ sky130_fd_sc_hd__o21bai_2
X_8303_ sum5\[8\] s7\[8\] VGND VGND VPWR VPWR _1142_ sky130_fd_sc_hd__nor2_1
XFILLER_0_6_488 VPWR VGND VPWR VGND sky130_ef_sc_hd__decap_12
X_5515_ _2489_ _2491_ _2493_ VGND VGND VPWR VPWR _2534_ sky130_fd_sc_hd__o21a_1
XFILLER_0_73_3 VPWR VGND VPWR VGND sky130_ef_sc_hd__decap_12
X_8234_ _1077_ _1078_ _1073_ VGND VGND VPWR VPWR _1079_ sky130_fd_sc_hd__o21ai_2
X_5446_ net437 VGND VGND VPWR VPWR _2466_ sky130_fd_sc_hd__inv_2
XFILLER_0_112_485 VGND VGND VPWR VPWR sky130_fd_sc_hd__fill_1
XFILLER_0_112_474 VGND VGND VPWR VPWR sky130_fd_sc_hd__fill_2
X_8165_ _1005_ _1008_ _1009_ _1010_ VGND VGND VPWR VPWR _1011_ sky130_fd_sc_hd__a31o_1
XFILLER_0_1_193 VPWR VGND VPWR VGND sky130_ef_sc_hd__decap_12
X_5377_ _2396_ _2401_ VGND VGND VPWR VPWR _2402_ sky130_fd_sc_hd__nand2_1
X_4328_ _1370_ _1371_ _1373_ _1374_ VGND VGND VPWR VPWR _1375_ sky130_fd_sc_hd__o22ai_4
X_8096_ _0763_ _0765_ _0892_ VGND VGND VPWR VPWR _0943_ sky130_fd_sc_hd__o21ai_1
X_7116_ _4073_ _4070_ _4079_ _4085_ VGND VGND VPWR VPWR _4099_ sky130_fd_sc_hd__and4_1
X_4259_ _1280_ _1285_ _1306_ VGND VGND VPWR VPWR _1307_ sky130_fd_sc_hd__a21o_2
X_7047_ _4017_ _4018_ _3973_ _4020_ VGND VGND VPWR VPWR _4032_ sky130_fd_sc_hd__o211ai_4
XTAP_1104 VGND VPWR sky130_fd_sc_hd__tapvpwrvgnd_1
XTAP_1126 VGND VPWR sky130_fd_sc_hd__tapvpwrvgnd_1
XTAP_1137 VGND VPWR sky130_fd_sc_hd__tapvpwrvgnd_1
XTAP_1115 VGND VPWR sky130_fd_sc_hd__tapvpwrvgnd_1
X_7949_ sh10\[3\] _0797_ _0726_ VGND VGND VPWR VPWR _0798_ sky130_fd_sc_hd__o21a_1
XTAP_1159 VGND VPWR sky130_fd_sc_hd__tapvpwrvgnd_1
XTAP_1148 VGND VPWR sky130_fd_sc_hd__tapvpwrvgnd_1
XFILLER_0_65_623 VGND VGND VPWR VPWR sky130_fd_sc_hd__fill_1
XFILLER_0_108_725 VGND VGND VPWR VPWR sky130_fd_sc_hd__decap_8
XFILLER_0_107_202 VGND VGND VPWR VPWR sky130_fd_sc_hd__fill_2
XFILLER_0_92_475 VGND VGND VPWR VPWR sky130_fd_sc_hd__fill_1
XFILLER_0_92_497 VGND VGND VPWR VPWR sky130_fd_sc_hd__decap_4
XFILLER_0_45_391 VGND VGND VPWR VPWR sky130_fd_sc_hd__fill_1
XFILLER_0_33_553 VGND VGND VPWR VPWR sky130_fd_sc_hd__decap_6
XFILLER_0_60_394 VGND VGND VPWR VPWR sky130_fd_sc_hd__decap_3
XFILLER_0_18_15 VPWR VGND VPWR VGND sky130_ef_sc_hd__decap_12
XFILLER_0_87_225 VGND VGND VPWR VPWR sky130_fd_sc_hd__decap_8
XTAP_1660 VGND VPWR sky130_fd_sc_hd__tapvpwrvgnd_1
XFILLER_0_56_601 VGND VGND VPWR VPWR sky130_fd_sc_hd__decap_8
XTAP_1693 VGND VPWR sky130_fd_sc_hd__tapvpwrvgnd_1
XTAP_1682 VGND VPWR sky130_fd_sc_hd__tapvpwrvgnd_1
XTAP_1671 VGND VPWR sky130_fd_sc_hd__tapvpwrvgnd_1
XFILLER_0_55_111 VGND VGND VPWR VPWR sky130_fd_sc_hd__fill_1
XFILLER_0_28_325 VGND VGND VPWR VPWR sky130_fd_sc_hd__decap_8
XFILLER_0_70_103 VGND VGND VPWR VPWR sky130_fd_sc_hd__decap_8
XFILLER_0_56_689 VGND VGND VPWR VPWR sky130_fd_sc_hd__decap_8
XFILLER_0_50_35 VGND VGND VPWR VPWR sky130_fd_sc_hd__fill_1
XFILLER_0_71_637 VGND VGND VPWR VPWR sky130_fd_sc_hd__fill_1
XFILLER_0_55_199 VGND VGND VPWR VPWR sky130_fd_sc_hd__decap_4
XFILLER_0_36_380 VPWR VGND VPWR VGND sky130_ef_sc_hd__decap_12
XFILLER_0_50_79 VGND VGND VPWR VPWR sky130_fd_sc_hd__decap_4
X_5300_ _2324_ _2325_ _2069_ VGND VGND VPWR VPWR _2326_ sky130_fd_sc_hd__a21oi_1
X_6280_ _3264_ _3273_ _3271_ VGND VGND VPWR VPWR _3282_ sky130_fd_sc_hd__a21bo_1
XFILLER_0_11_225 VGND VGND VPWR VPWR sky130_fd_sc_hd__decap_8
XFILLER_0_59_99 VPWR VGND VPWR VGND sky130_ef_sc_hd__decap_12
X_5231_ _2094_ _2091_ _2213_ VGND VGND VPWR VPWR _2258_ sky130_fd_sc_hd__o21a_1
X_5162_ _2102_ _2189_ sh12\[2\] VGND VGND VPWR VPWR _2190_ sky130_fd_sc_hd__o21ai_1
X_5093_ _2071_ sh6\[2\] _2072_ VGND VGND VPWR VPWR _2122_ sky130_fd_sc_hd__o21a_1
XFILLER_0_38_6 VPWR VGND VPWR VGND sky130_ef_sc_hd__decap_12
XFILLER_0_78_203 VGND VGND VPWR VPWR sky130_fd_sc_hd__decap_4
X_8852_ clknet_leaf_51_clk net314 _0603_ VGND VGND VPWR VPWR sh13\[0\] sky130_fd_sc_hd__dfrtp_1
XFILLER_0_78_247 VGND VGND VPWR VPWR sky130_fd_sc_hd__decap_4
X_8783_ clknet_leaf_5_clk net201 _0534_ VGND VGND VPWR VPWR sh4\[3\] sky130_fd_sc_hd__dfrtp_4
X_7803_ s0\[7\] s1\[7\] s2\[7\] VGND VGND VPWR VPWR _0687_ sky130_fd_sc_hd__a21o_1
XPHY_209 VGND VGND VPWR VPWR sky130_fd_sc_hd__decap_3
X_5995_ _3002_ _3000_ _2883_ VGND VGND VPWR VPWR _3003_ sky130_fd_sc_hd__o21bai_4
X_7734_ carry4\[6\] sum4\[7\] VGND VGND VPWR VPWR _0641_ sky130_fd_sc_hd__nor2_1
X_4946_ _1973_ _1975_ _1979_ VGND VGND VPWR VPWR _1980_ sky130_fd_sc_hd__nand3_2
XFILLER_0_86_291 VPWR VGND VPWR VGND sky130_ef_sc_hd__decap_12
XFILLER_0_24_80 VGND VGND VPWR VPWR sky130_fd_sc_hd__decap_4
X_4877_ _1652_ _1637_ VGND VGND VPWR VPWR _1912_ sky130_fd_sc_hd__xnor2_1
X_7665_ sum3\[10\] carry3\[9\] VGND VGND VPWR VPWR _4191_ sky130_fd_sc_hd__nor2_1
X_6616_ _3609_ _3610_ sh14\[4\] VGND VGND VPWR VPWR _3611_ sky130_fd_sc_hd__and3b_2
XFILLER_0_62_648 VPWR VGND VPWR VGND sky130_ef_sc_hd__decap_12
XFILLER_0_6_241 VGND VGND VPWR VPWR sky130_fd_sc_hd__decap_3
X_7596_ _4166_ VGND VGND VPWR VPWR _0587_ sky130_fd_sc_hd__inv_2
XFILLER_0_34_328 VGND VGND VPWR VPWR sky130_fd_sc_hd__fill_1
X_6547_ _3542_ _3537_ _3540_ VGND VGND VPWR VPWR _3544_ sky130_fd_sc_hd__nand3_2
XFILLER_0_27_391 VGND VGND VPWR VPWR sky130_fd_sc_hd__fill_1
XFILLER_0_30_501 VGND VGND VPWR VPWR sky130_fd_sc_hd__fill_1
X_6478_ _3474_ _3471_ _3472_ VGND VGND VPWR VPWR _3476_ sky130_fd_sc_hd__nand3_1
X_8217_ _0740_ _0723_ _1058_ VGND VGND VPWR VPWR _1062_ sky130_fd_sc_hd__a21o_1
X_5429_ _2420_ _2448_ _2451_ VGND VGND VPWR VPWR _2452_ sky130_fd_sc_hd__nand3_1
XFILLER_0_100_477 VGND VGND VPWR VPWR sky130_fd_sc_hd__decap_6
X_8148_ _0993_ _0994_ VGND VGND VPWR VPWR _0995_ sky130_fd_sc_hd__and2b_1
XFILLER_0_100_499 VPWR VGND VPWR VGND sky130_ef_sc_hd__decap_12
X_8079_ _0926_ VGND VGND VPWR VPWR _0111_ sky130_fd_sc_hd__buf_1
XFILLER_0_69_258 VPWR VGND VPWR VGND sky130_ef_sc_hd__decap_12
XFILLER_0_85_729 VGND VGND VPWR VPWR sky130_fd_sc_hd__decap_6
XFILLER_0_37_133 VGND VGND VPWR VPWR sky130_fd_sc_hd__decap_3
XFILLER_0_108_533 VGND VGND VPWR VPWR sky130_fd_sc_hd__fill_1
XFILLER_0_53_615 VGND VGND VPWR VPWR sky130_fd_sc_hd__fill_1
XFILLER_0_37_166 VGND VGND VPWR VPWR sky130_fd_sc_hd__fill_2
XFILLER_0_123_503 VGND VGND VPWR VPWR sky130_fd_sc_hd__fill_1
XFILLER_0_25_328 VGND VGND VPWR VPWR sky130_fd_sc_hd__decap_3
XFILLER_0_80_445 VGND VGND VPWR VPWR sky130_fd_sc_hd__decap_6
XFILLER_0_40_309 VGND VGND VPWR VPWR sky130_fd_sc_hd__decap_8
XFILLER_0_33_361 VPWR VGND VPWR VGND sky130_ef_sc_hd__decap_12
XFILLER_0_0_417 VGND VGND VPWR VPWR sky130_fd_sc_hd__decap_3
XTAP_707 VGND VPWR sky130_fd_sc_hd__tapvpwrvgnd_1
XFILLER_0_29_69 VGND VGND VPWR VPWR sky130_fd_sc_hd__fill_2
XTAP_718 VGND VPWR sky130_fd_sc_hd__tapvpwrvgnd_1
XTAP_729 VGND VPWR sky130_fd_sc_hd__tapvpwrvgnd_1
XFILLER_0_88_523 VGND VGND VPWR VPWR sky130_fd_sc_hd__decap_8
XFILLER_0_45_68 VPWR VGND VPWR VGND sky130_ef_sc_hd__decap_12
XFILLER_0_0_15 VPWR VGND VPWR VGND sky130_ef_sc_hd__decap_12
X_4800_ _1644_ _1646_ _1682_ VGND VGND VPWR VPWR _1836_ sky130_fd_sc_hd__o21ai_2
XFILLER_0_29_623 VGND VGND VPWR VPWR sky130_fd_sc_hd__decap_3
XFILLER_0_61_67 VGND VGND VPWR VPWR sky130_fd_sc_hd__fill_1
X_5780_ _2754_ _2747_ _2743_ VGND VGND VPWR VPWR _2795_ sky130_fd_sc_hd__a21bo_2
X_4731_ _1649_ _1641_ _1638_ VGND VGND VPWR VPWR _1768_ sky130_fd_sc_hd__o21ai_2
XTAP_1490 VGND VPWR sky130_fd_sc_hd__tapvpwrvgnd_1
XFILLER_0_56_475 VGND VGND VPWR VPWR sky130_fd_sc_hd__fill_1
X_4662_ sh0\[7\] net40 sh4\[7\] VGND VGND VPWR VPWR _1700_ sky130_fd_sc_hd__o21ai_4
XFILLER_0_4_701 VPWR VGND VPWR VGND sky130_ef_sc_hd__decap_12
X_7450_ _4152_ VGND VGND VPWR VPWR _0455_ sky130_fd_sc_hd__inv_2
XFILLER_0_114_514 VPWR VGND VPWR VGND sky130_ef_sc_hd__decap_12
X_6401_ _3354_ _3364_ _3398_ VGND VGND VPWR VPWR _3400_ sky130_fd_sc_hd__a21o_1
XFILLER_0_9_57 VPWR VGND VPWR VGND sky130_ef_sc_hd__decap_12
X_4593_ _1349_ VGND VGND VPWR VPWR _1633_ sky130_fd_sc_hd__inv_2
X_7381_ _4145_ VGND VGND VPWR VPWR _0393_ sky130_fd_sc_hd__inv_2
XFILLER_0_24_350 VPWR VGND VPWR VGND sky130_ef_sc_hd__decap_12
X_6332_ _3296_ sh2\[4\] VGND VGND VPWR VPWR _3331_ sky130_fd_sc_hd__nor2_2
XFILLER_0_12_556 VGND VGND VPWR VPWR sky130_fd_sc_hd__decap_8
XFILLER_0_3_277 VGND VGND VPWR VPWR sky130_fd_sc_hd__decap_3
XFILLER_0_24_394 VGND VGND VPWR VPWR sky130_fd_sc_hd__fill_2
XFILLER_0_51_191 VGND VGND VPWR VPWR sky130_fd_sc_hd__decap_8
X_6263_ _3235_ _3243_ _3266_ VGND VGND VPWR VPWR _3267_ sky130_fd_sc_hd__a21o_1
XFILLER_0_86_53 VPWR VGND VPWR VGND sky130_ef_sc_hd__decap_12
X_5214_ _2239_ _2240_ _2241_ VGND VGND VPWR VPWR _2242_ sky130_fd_sc_hd__nand3_2
X_8002_ _0793_ _0850_ VGND VGND VPWR VPWR _0851_ sky130_fd_sc_hd__nand2_1
X_6194_ _2886_ _2875_ sh6\[6\] VGND VGND VPWR VPWR _3199_ sky130_fd_sc_hd__o21ai_2
XFILLER_0_86_97 VPWR VGND VPWR VGND sky130_ef_sc_hd__decap_12
X_5145_ _2168_ _2173_ VGND VGND VPWR VPWR _2174_ sky130_fd_sc_hd__nand2_1
XFILLER_0_36_3 VPWR VGND VPWR VGND sky130_ef_sc_hd__decap_12
X_5076_ _2072_ _2104_ VGND VGND VPWR VPWR _2105_ sky130_fd_sc_hd__nor2_1
X_8835_ clknet_leaf_16_clk net169 _0586_ VGND VGND VPWR VPWR sh10\[7\] sky130_fd_sc_hd__dfrtp_2
XFILLER_0_94_504 VPWR VGND VPWR VGND sky130_ef_sc_hd__decap_12
XFILLER_0_79_589 VGND VGND VPWR VPWR sky130_fd_sc_hd__decap_8
XFILLER_0_109_308 VGND VGND VPWR VPWR sky130_fd_sc_hd__decap_8
X_5978_ _2986_ _2939_ _2938_ VGND VGND VPWR VPWR _2987_ sky130_fd_sc_hd__a21boi_1
X_8766_ clknet_leaf_63_clk net144 _0517_ VGND VGND VPWR VPWR sh2\[2\] sky130_fd_sc_hd__dfrtp_4
X_4929_ _1674_ _1791_ VGND VGND VPWR VPWR _1963_ sky130_fd_sc_hd__nor2_1
XFILLER_0_81_209 VPWR VGND VPWR VGND sky130_ef_sc_hd__decap_12
X_7717_ net210 _0630_ VGND VGND VPWR VPWR _0067_ sky130_fd_sc_hd__xnor2_1
X_8697_ clknet_leaf_58_clk _0161_ _0448_ VGND VGND VPWR VPWR bit_sum2\[8\] sky130_fd_sc_hd__dfrtp_1
XFILLER_0_117_341 VGND VGND VPWR VPWR sky130_fd_sc_hd__fill_2
X_7648_ net421 _4177_ VGND VGND VPWR VPWR _0086_ sky130_fd_sc_hd__nand2_1
XFILLER_0_7_594 VGND VGND VPWR VPWR sky130_fd_sc_hd__fill_1
XFILLER_0_7_561 VGND VGND VPWR VPWR sky130_fd_sc_hd__decap_4
XFILLER_0_22_309 VPWR VGND VPWR VGND sky130_ef_sc_hd__decap_12
X_7579_ _4165_ VGND VGND VPWR VPWR _0571_ sky130_fd_sc_hd__inv_2
XFILLER_0_30_331 VGND VGND VPWR VPWR sky130_fd_sc_hd__decap_4
XFILLER_0_120_539 VGND VGND VPWR VPWR sky130_fd_sc_hd__decap_6
XFILLER_0_30_397 VGND VGND VPWR VPWR sky130_fd_sc_hd__fill_2
XFILLER_0_15_27 VPWR VGND VPWR VGND sky130_ef_sc_hd__decap_12
XFILLER_0_57_217 VGND VGND VPWR VPWR sky130_fd_sc_hd__decap_6
XFILLER_0_31_15 VPWR VGND VPWR VGND sky130_ef_sc_hd__decap_12
XFILLER_0_81_710 VPWR VGND VPWR VGND sky130_ef_sc_hd__decap_12
XFILLER_0_53_423 VPWR VGND VPWR VGND sky130_ef_sc_hd__decap_12
XFILLER_0_108_363 VGND VGND VPWR VPWR sky130_fd_sc_hd__fill_1
XFILLER_0_80_253 VGND VGND VPWR VPWR sky130_fd_sc_hd__decap_4
XFILLER_0_123_333 VGND VGND VPWR VPWR sky130_fd_sc_hd__decap_3
XFILLER_0_123_388 VGND VGND VPWR VPWR sky130_fd_sc_hd__decap_4
XFILLER_0_34_692 VGND VGND VPWR VPWR sky130_fd_sc_hd__decap_8
XFILLER_0_0_225 VPWR VGND VPWR VGND sky130_ef_sc_hd__decap_12
XTAP_504 VGND VPWR sky130_fd_sc_hd__tapvpwrvgnd_1
XTAP_515 VGND VPWR sky130_fd_sc_hd__tapvpwrvgnd_1
XFILLER_0_21_375 VGND VGND VPWR VPWR sky130_fd_sc_hd__fill_2
XTAP_526 VGND VPWR sky130_fd_sc_hd__tapvpwrvgnd_1
XTAP_537 VGND VPWR sky130_fd_sc_hd__tapvpwrvgnd_1
XTAP_548 VGND VPWR sky130_fd_sc_hd__tapvpwrvgnd_1
XTAP_559 VGND VPWR sky130_fd_sc_hd__tapvpwrvgnd_1
XFILLER_0_56_78 VGND VGND VPWR VPWR sky130_fd_sc_hd__decap_6
X_6950_ _3924_ _3926_ _3936_ VGND VGND VPWR VPWR _3937_ sky130_fd_sc_hd__o21ai_2
X_5901_ net37 VGND VGND VPWR VPWR _2910_ sky130_fd_sc_hd__inv_2
XFILLER_0_72_77 VGND VGND VPWR VPWR sky130_fd_sc_hd__decap_6
XFILLER_0_72_66 VGND VGND VPWR VPWR sky130_fd_sc_hd__decap_8
X_6881_ _3863_ _3860_ _3862_ _3788_ _3865_ VGND VGND VPWR VPWR _3869_ sky130_fd_sc_hd__o311a_2
XFILLER_0_49_729 VGND VGND VPWR VPWR sky130_fd_sc_hd__decap_6
X_5832_ _2844_ _2842_ _2809_ VGND VGND VPWR VPWR _2846_ sky130_fd_sc_hd__a21o_1
X_8620_ clknet_leaf_56_clk net113 _0371_ VGND VGND VPWR VPWR s3\[3\] sky130_fd_sc_hd__dfrtp_1
X_5763_ _2521_ _2672_ VGND VGND VPWR VPWR _2778_ sky130_fd_sc_hd__nand2_1
X_8551_ clknet_leaf_41_clk net88 _0302_ VGND VGND VPWR VPWR sum4\[1\] sky130_fd_sc_hd__dfrtp_1
X_4714_ _1743_ _1745_ VGND VGND VPWR VPWR _1752_ sky130_fd_sc_hd__nand2_1
XFILLER_0_91_529 VGND VGND VPWR VPWR sky130_fd_sc_hd__fill_2
XFILLER_0_72_721 VPWR VGND VPWR VGND sky130_ef_sc_hd__decap_12
X_7502_ _4157_ VGND VGND VPWR VPWR _0502_ sky130_fd_sc_hd__inv_2
XFILLER_0_17_648 VGND VGND VPWR VPWR sky130_fd_sc_hd__fill_1
X_5694_ net453 _2648_ _2656_ _2657_ VGND VGND VPWR VPWR _2711_ sky130_fd_sc_hd__o2bb2ai_4
X_8482_ clknet_leaf_42_clk net171 _0233_ VGND VGND VPWR VPWR net20 sky130_fd_sc_hd__dfrtp_1
XFILLER_0_114_333 VPWR VGND VPWR VGND sky130_ef_sc_hd__decap_12
X_4645_ sh0\[7\] sh2\[7\] sh6\[7\] VGND VGND VPWR VPWR _1683_ sky130_fd_sc_hd__o21ai_4
X_7433_ _4151_ VGND VGND VPWR VPWR _0439_ sky130_fd_sc_hd__inv_2
X_4576_ _1594_ _1591_ _1618_ VGND VGND VPWR VPWR _1619_ sky130_fd_sc_hd__a21o_1
X_7364_ _4143_ VGND VGND VPWR VPWR _0378_ sky130_fd_sc_hd__inv_2
XFILLER_0_97_74 VPWR VGND VPWR VGND sky130_ef_sc_hd__decap_12
X_6315_ _3295_ _3297_ _3299_ VGND VGND VPWR VPWR _3315_ sky130_fd_sc_hd__a21o_1
XFILLER_0_12_353 VGND VGND VPWR VPWR sky130_fd_sc_hd__fill_1
XFILLER_0_4_597 VPWR VGND VPWR VGND sky130_ef_sc_hd__decap_12
XFILLER_0_110_550 VPWR VGND VPWR VGND sky130_ef_sc_hd__decap_12
X_7295_ _4137_ VGND VGND VPWR VPWR _0315_ sky130_fd_sc_hd__inv_2
X_6246_ _3249_ _3207_ _3205_ _3247_ VGND VGND VPWR VPWR _3250_ sky130_fd_sc_hd__o211a_1
X_6177_ _3177_ _3178_ _3182_ VGND VGND VPWR VPWR _3183_ sky130_fd_sc_hd__nand3b_1
XFILLER_0_99_629 VPWR VGND VPWR VGND sky130_ef_sc_hd__decap_12
X_5128_ _2156_ _2152_ VGND VGND VPWR VPWR _2157_ sky130_fd_sc_hd__nand2_1
XFILLER_0_98_139 VGND VGND VPWR VPWR sky130_fd_sc_hd__fill_1
X_5059_ _2086_ _2087_ _2069_ VGND VGND VPWR VPWR _2088_ sky130_fd_sc_hd__o21ai_1
X_8818_ clknet_leaf_6_clk net340 _0569_ VGND VGND VPWR VPWR sh8\[6\] sky130_fd_sc_hd__dfrtp_4
XFILLER_0_67_548 VGND VGND VPWR VPWR sky130_fd_sc_hd__fill_1
XFILLER_0_39_228 VPWR VGND VPWR VGND sky130_ef_sc_hd__decap_12
XFILLER_0_109_105 VGND VGND VPWR VPWR sky130_fd_sc_hd__fill_2
X_8749_ clknet_leaf_61_clk net3 _0500_ VGND VGND VPWR VPWR sh0\[1\] sky130_fd_sc_hd__dfrtp_4
XFILLER_0_35_423 VGND VGND VPWR VPWR sky130_fd_sc_hd__decap_3
XFILLER_0_118_672 VGND VGND VPWR VPWR sky130_fd_sc_hd__fill_2
XFILLER_0_62_253 VGND VGND VPWR VPWR sky130_fd_sc_hd__decap_8
XFILLER_0_16_670 VPWR VGND VPWR VGND sky130_ef_sc_hd__decap_12
XFILLER_0_23_629 VGND VGND VPWR VPWR sky130_fd_sc_hd__decap_3
XFILLER_0_22_139 VGND VGND VPWR VPWR sky130_fd_sc_hd__fill_1
XFILLER_0_31_673 VPWR VGND VPWR VGND sky130_ef_sc_hd__decap_12
XFILLER_0_30_161 VPWR VGND VPWR VGND sky130_ef_sc_hd__decap_12
XFILLER_0_117_39 VPWR VGND VPWR VGND sky130_ef_sc_hd__decap_12
XFILLER_0_89_117 VGND VGND VPWR VPWR sky130_fd_sc_hd__fill_1
Xhold60 bit_sum5\[2\] VGND VGND VPWR VPWR net102 sky130_fd_sc_hd__dlygate4sd3_1
Xhold82 final_sum\[7\] VGND VGND VPWR VPWR net124 sky130_fd_sc_hd__dlygate4sd3_1
Xhold71 bit_sum3\[0\] VGND VGND VPWR VPWR net113 sky130_fd_sc_hd__dlygate4sd3_1
Xhold93 s6\[15\] VGND VGND VPWR VPWR net135 sky130_fd_sc_hd__dlygate4sd3_1
XFILLER_0_98_695 VGND VGND VPWR VPWR sky130_fd_sc_hd__decap_4
XFILLER_0_85_312 VGND VGND VPWR VPWR sky130_fd_sc_hd__decap_6
XFILLER_0_85_378 VGND VGND VPWR VPWR sky130_fd_sc_hd__fill_2
XFILLER_0_54_721 VPWR VGND VPWR VGND sky130_ef_sc_hd__decap_12
XFILLER_0_53_231 VGND VGND VPWR VPWR sky130_fd_sc_hd__fill_1
XFILLER_0_26_445 VGND VGND VPWR VPWR sky130_fd_sc_hd__decap_8
XFILLER_0_53_253 VGND VGND VPWR VPWR sky130_fd_sc_hd__decap_8
XFILLER_0_26_467 VGND VGND VPWR VPWR sky130_fd_sc_hd__decap_8
XFILLER_0_123_141 VPWR VGND VPWR VGND sky130_ef_sc_hd__decap_12
X_4430_ _1409_ _1410_ _1407_ _1316_ VGND VGND VPWR VPWR _1476_ sky130_fd_sc_hd__a31oi_1
XFILLER_0_81_595 VPWR VGND VPWR VGND sky130_ef_sc_hd__decap_12
XFILLER_0_53_286 VGND VGND VPWR VPWR sky130_fd_sc_hd__decap_8
XANTENNA_2 _0111_ VGND VGND VPWR VPWR sky130_fd_sc_hd__diode_2
X_6100_ _3092_ _3093_ _3085_ _3090_ VGND VGND VPWR VPWR _3107_ sky130_fd_sc_hd__o211ai_1
X_4361_ _1396_ _1400_ _1405_ VGND VGND VPWR VPWR _1408_ sky130_fd_sc_hd__o21ai_1
X_4292_ _1339_ VGND VGND VPWR VPWR _1340_ sky130_fd_sc_hd__inv_2
XFILLER_0_67_44 VPWR VGND VPWR VGND sky130_ef_sc_hd__decap_12
XTAP_323 VGND VPWR sky130_fd_sc_hd__tapvpwrvgnd_1
XTAP_312 VGND VPWR sky130_fd_sc_hd__tapvpwrvgnd_1
XTAP_301 VGND VPWR sky130_fd_sc_hd__tapvpwrvgnd_1
X_7080_ _4062_ _4064_ VGND VGND VPWR VPWR _0150_ sky130_fd_sc_hd__xnor2_1
X_6031_ _2936_ _2893_ _3030_ VGND VGND VPWR VPWR _3039_ sky130_fd_sc_hd__a21oi_2
XTAP_367 VGND VPWR sky130_fd_sc_hd__tapvpwrvgnd_1
XTAP_345 VGND VPWR sky130_fd_sc_hd__tapvpwrvgnd_1
XTAP_356 VGND VPWR sky130_fd_sc_hd__tapvpwrvgnd_1
XTAP_334 VGND VPWR sky130_fd_sc_hd__tapvpwrvgnd_1
XTAP_389 VGND VPWR sky130_fd_sc_hd__tapvpwrvgnd_1
XTAP_378 VGND VPWR sky130_fd_sc_hd__tapvpwrvgnd_1
XFILLER_0_89_640 VGND VGND VPWR VPWR sky130_fd_sc_hd__fill_2
XFILLER_0_20_6 VPWR VGND VPWR VGND sky130_ef_sc_hd__decap_12
X_7982_ _0822_ _0824_ _0826_ VGND VGND VPWR VPWR _0831_ sky130_fd_sc_hd__o21ai_2
XFILLER_0_95_109 VGND VGND VPWR VPWR sky130_fd_sc_hd__decap_3
XFILLER_0_89_684 VGND VGND VPWR VPWR sky130_fd_sc_hd__fill_1
X_6933_ _3911_ _3915_ _3919_ VGND VGND VPWR VPWR _3920_ sky130_fd_sc_hd__nand3_2
XPHY_18 VGND VGND VPWR VPWR sky130_fd_sc_hd__decap_3
XPHY_29 VGND VGND VPWR VPWR sky130_fd_sc_hd__decap_3
X_6864_ _3848_ _3849_ _3851_ VGND VGND VPWR VPWR _3852_ sky130_fd_sc_hd__nand3_4
XFILLER_0_16_92 VGND VGND VPWR VPWR sky130_fd_sc_hd__decap_3
XFILLER_0_49_537 VGND VGND VPWR VPWR sky130_fd_sc_hd__decap_4
X_5815_ _2827_ _2828_ VGND VGND VPWR VPWR _2829_ sky130_fd_sc_hd__nor2_1
X_8603_ clknet_leaf_53_clk net109 _0354_ VGND VGND VPWR VPWR s1\[4\] sky130_fd_sc_hd__dfrtp_1
XFILLER_0_119_469 VGND VGND VPWR VPWR sky130_fd_sc_hd__decap_4
XFILLER_0_119_447 VGND VGND VPWR VPWR sky130_fd_sc_hd__fill_1
XFILLER_0_91_304 VGND VGND VPWR VPWR sky130_fd_sc_hd__fill_2
XFILLER_0_8_133 VGND VGND VPWR VPWR sky130_fd_sc_hd__decap_6
X_6795_ _3743_ _3749_ _3778_ VGND VGND VPWR VPWR _3784_ sky130_fd_sc_hd__a21o_1
X_8534_ clknet_leaf_30_clk net209 _0285_ VGND VGND VPWR VPWR sum3\[8\] sky130_fd_sc_hd__dfrtp_1
XFILLER_0_8_177 VPWR VGND VPWR VGND sky130_ef_sc_hd__decap_12
X_5746_ _2706_ _2759_ _2714_ VGND VGND VPWR VPWR _2762_ sky130_fd_sc_hd__a21oi_1
X_8465_ clknet_leaf_28_clk net361 _0216_ VGND VGND VPWR VPWR carry5\[12\] sky130_fd_sc_hd__dfrtp_1
X_5677_ _2677_ _2689_ _2693_ VGND VGND VPWR VPWR _2694_ sky130_fd_sc_hd__nand3_2
XFILLER_0_44_253 VGND VGND VPWR VPWR sky130_fd_sc_hd__decap_8
X_4628_ _1665_ _1666_ sh12\[7\] VGND VGND VPWR VPWR _1667_ sky130_fd_sc_hd__o21bai_4
X_7416_ _4149_ VGND VGND VPWR VPWR _0424_ sky130_fd_sc_hd__inv_2
XFILLER_0_115_697 VPWR VGND VPWR VGND sky130_ef_sc_hd__decap_12
X_8396_ _1224_ _1225_ sh12\[5\] VGND VGND VPWR VPWR _1226_ sky130_fd_sc_hd__o21bai_4
XFILLER_0_32_459 VGND VGND VPWR VPWR sky130_fd_sc_hd__fill_1
X_4559_ _1274_ _1384_ _1548_ VGND VGND VPWR VPWR _1602_ sky130_fd_sc_hd__a21o_1
XFILLER_0_13_673 VPWR VGND VPWR VGND sky130_ef_sc_hd__decap_12
X_7347_ _4142_ VGND VGND VPWR VPWR _0362_ sky130_fd_sc_hd__inv_2
X_7278_ _4135_ VGND VGND VPWR VPWR _0300_ sky130_fd_sc_hd__inv_2
X_6229_ _3174_ _3190_ _3224_ _3227_ VGND VGND VPWR VPWR _3234_ sky130_fd_sc_hd__o211ai_4
XFILLER_0_99_404 VPWR VGND VPWR VGND sky130_ef_sc_hd__decap_12
XTAP_890 VGND VPWR sky130_fd_sc_hd__tapvpwrvgnd_1
XFILLER_0_86_109 VGND VGND VPWR VPWR sky130_fd_sc_hd__decap_8
XFILLER_0_79_161 VGND VGND VPWR VPWR sky130_fd_sc_hd__decap_6
XFILLER_0_95_632 VGND VGND VPWR VPWR sky130_fd_sc_hd__decap_8
XFILLER_0_94_120 VGND VGND VPWR VPWR sky130_fd_sc_hd__fill_2
XFILLER_0_94_153 VGND VGND VPWR VPWR sky130_fd_sc_hd__decap_8
XFILLER_0_94_197 VGND VGND VPWR VPWR sky130_fd_sc_hd__fill_1
XFILLER_0_63_540 VGND VGND VPWR VPWR sky130_fd_sc_hd__decap_6
XFILLER_0_35_220 VGND VGND VPWR VPWR sky130_fd_sc_hd__decap_4
XFILLER_0_63_573 VPWR VGND VPWR VGND sky130_ef_sc_hd__decap_12
XFILLER_0_90_370 VGND VGND VPWR VPWR sky130_fd_sc_hd__fill_1
XFILLER_0_35_297 VPWR VGND VPWR VGND sky130_ef_sc_hd__decap_12
XFILLER_0_120_133 VGND VGND VPWR VPWR sky130_fd_sc_hd__decap_6
XFILLER_0_10_109 VPWR VGND VPWR VGND sky130_ef_sc_hd__decap_12
XFILLER_0_50_278 VGND VGND VPWR VPWR sky130_fd_sc_hd__decap_3
XFILLER_0_120_177 VPWR VGND VPWR VGND sky130_ef_sc_hd__decap_12
XFILLER_0_101_380 VPWR VGND VPWR VGND sky130_ef_sc_hd__decap_12
XFILLER_0_37_69 VGND VGND VPWR VPWR sky130_fd_sc_hd__decap_4
XFILLER_0_53_35 VGND VGND VPWR VPWR sky130_fd_sc_hd__decap_8
XFILLER_0_98_492 VGND VGND VPWR VPWR sky130_fd_sc_hd__decap_8
XFILLER_0_58_312 VGND VGND VPWR VPWR sky130_fd_sc_hd__decap_8
XFILLER_0_53_57 VPWR VGND VPWR VGND sky130_ef_sc_hd__decap_12
XFILLER_0_86_698 VGND VGND VPWR VPWR sky130_fd_sc_hd__fill_2
XFILLER_0_73_326 VGND VGND VPWR VPWR sky130_fd_sc_hd__decap_8
XFILLER_0_46_529 VGND VGND VPWR VPWR sky130_fd_sc_hd__decap_3
XFILLER_0_116_417 VGND VGND VPWR VPWR sky130_fd_sc_hd__decap_3
X_6580_ _3360_ _3287_ _3335_ _3575_ VGND VGND VPWR VPWR _3576_ sky130_fd_sc_hd__o2bb2a_1
X_5600_ sh4\[0\] _2490_ VGND VGND VPWR VPWR _2618_ sky130_fd_sc_hd__and2_1
XFILLER_0_6_626 VPWR VGND VPWR VGND sky130_ef_sc_hd__decap_12
XFILLER_0_5_125 VPWR VGND VPWR VGND sky130_ef_sc_hd__decap_12
X_5531_ net30 sh12\[0\] VGND VGND VPWR VPWR _2550_ sky130_fd_sc_hd__nor2_1
XFILLER_0_42_713 VGND VGND VPWR VPWR sky130_fd_sc_hd__fill_2
X_8250_ _1048_ _1049_ _1094_ VGND VGND VPWR VPWR _1095_ sky130_fd_sc_hd__o21bai_1
XFILLER_0_5_169 VPWR VGND VPWR VGND sky130_ef_sc_hd__decap_12
XFILLER_0_26_286 VPWR VGND VPWR VGND sky130_ef_sc_hd__decap_12
XFILLER_0_112_623 VPWR VGND VPWR VGND sky130_ef_sc_hd__decap_12
X_5462_ sh3\[0\] VGND VGND VPWR VPWR _2482_ sky130_fd_sc_hd__clkbuf_4
X_7201_ _4128_ VGND VGND VPWR VPWR _0230_ sky130_fd_sc_hd__inv_2
XFILLER_0_112_645 VGND VGND VPWR VPWR sky130_fd_sc_hd__decap_8
X_4413_ _1436_ _1437_ _1434_ _1438_ VGND VGND VPWR VPWR _1459_ sky130_fd_sc_hd__o211a_1
XFILLER_0_78_65 VPWR VGND VPWR VGND sky130_ef_sc_hd__decap_12
X_8181_ _1000_ _1001_ _1022_ _1026_ VGND VGND VPWR VPWR _1027_ sky130_fd_sc_hd__nand4_2
X_5393_ _2411_ _2416_ _2417_ VGND VGND VPWR VPWR _2418_ sky130_fd_sc_hd__a21o_1
XFILLER_0_111_177 VGND VGND VPWR VPWR sky130_fd_sc_hd__fill_2
X_4344_ _1383_ _1382_ sh12\[5\] VGND VGND VPWR VPWR _1391_ sky130_fd_sc_hd__o21ai_1
X_7132_ _4111_ VGND VGND VPWR VPWR _0001_ sky130_fd_sc_hd__clkbuf_1
X_7063_ _3989_ _3985_ VGND VGND VPWR VPWR _4048_ sky130_fd_sc_hd__nand2_1
X_4275_ _1234_ _1266_ _1271_ _1269_ _1273_ VGND VGND VPWR VPWR _1323_ sky130_fd_sc_hd__o221ai_2
X_6014_ _2890_ _2883_ _3005_ VGND VGND VPWR VPWR _3022_ sky130_fd_sc_hd__o21ai_1
XFILLER_0_96_429 VGND VGND VPWR VPWR sky130_fd_sc_hd__fill_2
XTAP_1319 VGND VPWR sky130_fd_sc_hd__tapvpwrvgnd_1
XTAP_1308 VGND VPWR sky130_fd_sc_hd__tapvpwrvgnd_1
X_7965_ _0812_ _0813_ VGND VGND VPWR VPWR _0814_ sky130_fd_sc_hd__nand2_2
X_7896_ sh6\[3\] VGND VGND VPWR VPWR _0746_ sky130_fd_sc_hd__buf_4
X_6916_ _3902_ _3903_ VGND VGND VPWR VPWR _3904_ sky130_fd_sc_hd__and2_1
XFILLER_0_49_345 VGND VGND VPWR VPWR sky130_fd_sc_hd__decap_8
XFILLER_0_119_233 VGND VGND VPWR VPWR sky130_fd_sc_hd__decap_3
XFILLER_0_77_698 VGND VGND VPWR VPWR sky130_fd_sc_hd__fill_1
X_6847_ sh4\[1\] sh5\[1\] sh7\[1\] VGND VGND VPWR VPWR _3835_ sky130_fd_sc_hd__o21ai_2
XFILLER_0_76_197 VGND VGND VPWR VPWR sky130_fd_sc_hd__decap_4
X_6778_ sh7\[1\] sh8\[1\] VGND VGND VPWR VPWR _3767_ sky130_fd_sc_hd__or2_1
XFILLER_0_91_167 VGND VGND VPWR VPWR sky130_fd_sc_hd__fill_1
X_8517_ clknet_leaf_26_clk _0097_ _0268_ VGND VGND VPWR VPWR sum5\[7\] sky130_fd_sc_hd__dfrtp_1
X_5729_ _2739_ _2740_ VGND VGND VPWR VPWR _2745_ sky130_fd_sc_hd__nand2_1
XFILLER_0_45_595 VPWR VGND VPWR VGND sky130_ef_sc_hd__decap_12
XFILLER_0_115_461 VGND VGND VPWR VPWR sky130_fd_sc_hd__fill_1
X_8448_ clknet_leaf_39_clk _0023_ _0199_ VGND VGND VPWR VPWR carry3\[3\] sky130_fd_sc_hd__dfrtp_1
XFILLER_0_103_645 VGND VGND VPWR VPWR sky130_fd_sc_hd__decap_4
X_8379_ _1209_ _1210_ _1211_ VGND VGND VPWR VPWR _1212_ sky130_fd_sc_hd__and3_1
Xhold360 sum2\[7\] VGND VGND VPWR VPWR net402 sky130_fd_sc_hd__dlygate4sd3_1
Xhold371 sum2\[5\] VGND VGND VPWR VPWR net413 sky130_fd_sc_hd__dlygate4sd3_1
Xhold382 carry3\[10\] VGND VGND VPWR VPWR net424 sky130_fd_sc_hd__dlygate4sd3_1
Xhold393 sum2\[3\] VGND VGND VPWR VPWR net435 sky130_fd_sc_hd__dlygate4sd3_1
XTAP_1842 VGND VPWR sky130_fd_sc_hd__tapvpwrvgnd_1
XTAP_1831 VGND VPWR sky130_fd_sc_hd__tapvpwrvgnd_1
XTAP_1820 VGND VPWR sky130_fd_sc_hd__tapvpwrvgnd_1
XFILLER_0_114_29 VPWR VGND VPWR VGND sky130_ef_sc_hd__decap_12
XFILLER_0_67_142 VGND VGND VPWR VPWR sky130_fd_sc_hd__decap_8
XTAP_1875 VGND VPWR sky130_fd_sc_hd__tapvpwrvgnd_1
XTAP_1864 VGND VPWR sky130_fd_sc_hd__tapvpwrvgnd_1
XTAP_1853 VGND VPWR sky130_fd_sc_hd__tapvpwrvgnd_1
XFILLER_0_67_175 VGND VGND VPWR VPWR sky130_fd_sc_hd__fill_1
XFILLER_0_55_337 VPWR VGND VPWR VGND sky130_ef_sc_hd__decap_12
XFILLER_0_70_307 VGND VGND VPWR VPWR sky130_fd_sc_hd__fill_1
XFILLER_0_24_713 VPWR VGND VPWR VGND sky130_ef_sc_hd__decap_12
XFILLER_0_23_223 VGND VGND VPWR VPWR sky130_fd_sc_hd__fill_1
XFILLER_0_3_629 VPWR VGND VPWR VGND sky130_ef_sc_hd__decap_12
XFILLER_0_2_139 VGND VGND VPWR VPWR sky130_fd_sc_hd__fill_1
XFILLER_0_3_15 VPWR VGND VPWR VGND sky130_ef_sc_hd__decap_12
XFILLER_0_64_23 VGND VGND VPWR VPWR sky130_fd_sc_hd__decap_4
XFILLER_0_64_56 VGND VGND VPWR VPWR sky130_fd_sc_hd__decap_8
X_4962_ _1948_ _1953_ _1995_ VGND VGND VPWR VPWR _1996_ sky130_fd_sc_hd__a21o_1
X_7750_ _0652_ _0653_ net364 VGND VGND VPWR VPWR _0654_ sky130_fd_sc_hd__o21ai_1
X_4893_ _1791_ _1679_ _1743_ VGND VGND VPWR VPWR _1928_ sky130_fd_sc_hd__a21oi_1
XFILLER_0_86_462 VGND VGND VPWR VPWR sky130_fd_sc_hd__fill_2
X_7681_ _4202_ _4203_ net275 VGND VGND VPWR VPWR _4204_ sky130_fd_sc_hd__o21ai_1
X_6701_ _3688_ _3691_ _3678_ _3690_ VGND VGND VPWR VPWR _3694_ sky130_fd_sc_hd__o22a_1
XFILLER_0_59_676 VGND VGND VPWR VPWR sky130_fd_sc_hd__decap_4
XFILLER_0_46_315 VGND VGND VPWR VPWR sky130_fd_sc_hd__fill_1
X_6632_ sh15\[4\] _3286_ _3377_ VGND VGND VPWR VPWR _3627_ sky130_fd_sc_hd__and3_1
XFILLER_0_80_77 VGND VGND VPWR VPWR sky130_fd_sc_hd__decap_6
XFILLER_0_58_197 VPWR VGND VPWR VGND sky130_ef_sc_hd__decap_12
X_6563_ _3301_ _3554_ _3555_ _3556_ _3558_ VGND VGND VPWR VPWR _3559_ sky130_fd_sc_hd__o221ai_4
XFILLER_0_27_584 VPWR VGND VPWR VGND sky130_ef_sc_hd__decap_12
X_6494_ _3488_ _3301_ _3489_ _3490_ VGND VGND VPWR VPWR _3491_ sky130_fd_sc_hd__o211ai_4
X_8302_ sum5\[8\] s7\[8\] VGND VGND VPWR VPWR _1141_ sky130_fd_sc_hd__and2_1
X_5514_ sh12\[0\] _2468_ _2467_ VGND VGND VPWR VPWR _2533_ sky130_fd_sc_hd__o21bai_4
XFILLER_0_120_83 VGND VGND VPWR VPWR sky130_fd_sc_hd__fill_1
XFILLER_0_112_431 VGND VGND VPWR VPWR sky130_fd_sc_hd__fill_1
XFILLER_0_89_97 VPWR VGND VPWR VGND sky130_ef_sc_hd__decap_12
X_8233_ _1065_ _1069_ _1051_ VGND VGND VPWR VPWR _1078_ sky130_fd_sc_hd__a21boi_2
XFILLER_0_14_278 VGND VGND VPWR VPWR sky130_fd_sc_hd__decap_4
X_5445_ _2134_ _2185_ _2082_ _2465_ VGND VGND VPWR VPWR _0154_ sky130_fd_sc_hd__o22a_1
XFILLER_0_42_587 VGND VGND VPWR VPWR sky130_fd_sc_hd__fill_1
XFILLER_0_66_3 VPWR VGND VPWR VGND sky130_ef_sc_hd__decap_12
X_8164_ _0797_ _0826_ VGND VGND VPWR VPWR _1010_ sky130_fd_sc_hd__xnor2_2
XFILLER_0_1_161 VGND VGND VPWR VPWR sky130_fd_sc_hd__decap_6
X_7115_ _4063_ _4013_ _4097_ VGND VGND VPWR VPWR _4098_ sky130_fd_sc_hd__o21ai_1
X_5376_ _2399_ _2400_ _2394_ VGND VGND VPWR VPWR _2401_ sky130_fd_sc_hd__o21ai_2
X_4327_ _1288_ _1356_ _1357_ _1358_ _1360_ VGND VGND VPWR VPWR _1374_ sky130_fd_sc_hd__o221a_2
X_8095_ _0930_ _0932_ _0937_ _0941_ VGND VGND VPWR VPWR _0942_ sky130_fd_sc_hd__o211ai_2
X_4258_ _1234_ _1266_ _1271_ _1269_ _1273_ VGND VGND VPWR VPWR _1306_ sky130_fd_sc_hd__o221a_1
X_7046_ _3979_ _3976_ _3971_ VGND VGND VPWR VPWR _4031_ sky130_fd_sc_hd__a21boi_1
XFILLER_0_69_418 VGND VGND VPWR VPWR sky130_fd_sc_hd__decap_3
XTAP_1105 VGND VPWR sky130_fd_sc_hd__tapvpwrvgnd_1
XTAP_1127 VGND VPWR sky130_fd_sc_hd__tapvpwrvgnd_1
XTAP_1138 VGND VPWR sky130_fd_sc_hd__tapvpwrvgnd_1
XTAP_1116 VGND VPWR sky130_fd_sc_hd__tapvpwrvgnd_1
X_7948_ sh11\[3\] VGND VGND VPWR VPWR _0797_ sky130_fd_sc_hd__clkbuf_4
XTAP_1149 VGND VPWR sky130_fd_sc_hd__tapvpwrvgnd_1
XFILLER_0_49_153 VGND VGND VPWR VPWR sky130_fd_sc_hd__fill_1
XFILLER_0_49_175 VGND VGND VPWR VPWR sky130_fd_sc_hd__fill_1
XFILLER_0_64_112 VGND VGND VPWR VPWR sky130_fd_sc_hd__decap_3
X_7879_ _0727_ _0722_ _0723_ VGND VGND VPWR VPWR _0729_ sky130_fd_sc_hd__a21oi_1
XFILLER_0_37_337 VPWR VGND VPWR VGND sky130_ef_sc_hd__decap_12
XFILLER_0_52_307 VGND VGND VPWR VPWR sky130_fd_sc_hd__fill_1
XFILLER_0_18_540 VPWR VGND VPWR VGND sky130_ef_sc_hd__decap_12
XFILLER_0_18_584 VGND VGND VPWR VPWR sky130_fd_sc_hd__decap_4
XFILLER_0_21_705 VGND VGND VPWR VPWR sky130_fd_sc_hd__decap_3
XFILLER_0_20_226 VGND VGND VPWR VPWR sky130_fd_sc_hd__decap_3
XFILLER_0_109_29 VGND VGND VPWR VPWR sky130_fd_sc_hd__decap_4
Xhold190 sh10\[0\] VGND VGND VPWR VPWR net232 sky130_fd_sc_hd__dlygate4sd3_1
XFILLER_0_18_27 VGND VGND VPWR VPWR sky130_fd_sc_hd__fill_1
XFILLER_0_88_727 VGND VGND VPWR VPWR sky130_fd_sc_hd__fill_2
XFILLER_0_34_15 VPWR VGND VPWR VGND sky130_ef_sc_hd__decap_12
XTAP_1650 VGND VPWR sky130_fd_sc_hd__tapvpwrvgnd_1
XTAP_1694 VGND VPWR sky130_fd_sc_hd__tapvpwrvgnd_1
XTAP_1683 VGND VPWR sky130_fd_sc_hd__tapvpwrvgnd_1
XTAP_1672 VGND VPWR sky130_fd_sc_hd__tapvpwrvgnd_1
XTAP_1661 VGND VPWR sky130_fd_sc_hd__tapvpwrvgnd_1
XFILLER_0_83_443 VGND VGND VPWR VPWR sky130_fd_sc_hd__decap_4
XFILLER_0_71_605 VGND VGND VPWR VPWR sky130_fd_sc_hd__decap_8
XFILLER_0_50_47 VGND VGND VPWR VPWR sky130_fd_sc_hd__decap_4
XFILLER_0_71_649 VGND VGND VPWR VPWR sky130_fd_sc_hd__decap_6
XFILLER_0_36_392 VPWR VGND VPWR VGND sky130_ef_sc_hd__decap_12
XFILLER_0_59_34 VGND VGND VPWR VPWR sky130_fd_sc_hd__decap_3
XFILLER_0_24_587 VGND VGND VPWR VPWR sky130_fd_sc_hd__fill_1
XFILLER_0_121_261 VGND VGND VPWR VPWR sky130_fd_sc_hd__fill_2
XFILLER_0_59_67 VPWR VGND VPWR VGND sky130_ef_sc_hd__decap_12
X_5230_ _2060_ _2061_ _2091_ VGND VGND VPWR VPWR _2257_ sky130_fd_sc_hd__o21ai_2
XFILLER_0_121_272 VGND VGND VPWR VPWR sky130_fd_sc_hd__fill_1
X_5161_ sh9\[2\] VGND VGND VPWR VPWR _2189_ sky130_fd_sc_hd__clkbuf_4
XFILLER_0_75_55 VGND VGND VPWR VPWR sky130_fd_sc_hd__fill_1
X_5092_ _2119_ _2112_ _2118_ VGND VGND VPWR VPWR _2121_ sky130_fd_sc_hd__nand3_2
X_8851_ clknet_leaf_16_clk net199 _0602_ VGND VGND VPWR VPWR sh12\[7\] sky130_fd_sc_hd__dfrtp_4
X_5994_ _2878_ _2911_ VGND VGND VPWR VPWR _3002_ sky130_fd_sc_hd__nor2_1
X_8782_ clknet_leaf_63_clk net412 _0533_ VGND VGND VPWR VPWR sh4\[2\] sky130_fd_sc_hd__dfrtp_4
X_7802_ net367 s1\[6\] _0686_ VGND VGND VPWR VPWR _0006_ sky130_fd_sc_hd__o21a_1
X_4945_ _1976_ _1978_ VGND VGND VPWR VPWR _1979_ sky130_fd_sc_hd__nor2_1
X_7733_ carry4\[6\] sum4\[7\] VGND VGND VPWR VPWR _0640_ sky130_fd_sc_hd__and2_1
XFILLER_0_86_270 VPWR VGND VPWR VGND sky130_ef_sc_hd__decap_12
XFILLER_0_74_421 VGND VGND VPWR VPWR sky130_fd_sc_hd__fill_1
XFILLER_0_19_337 VGND VGND VPWR VPWR sky130_fd_sc_hd__decap_3
XFILLER_0_47_657 VPWR VGND VPWR VGND sky130_ef_sc_hd__decap_12
X_4876_ _1662_ _1722_ VGND VGND VPWR VPWR _1911_ sky130_fd_sc_hd__xnor2_4
X_7664_ sum3\[10\] carry3\[9\] VGND VGND VPWR VPWR _4190_ sky130_fd_sc_hd__and2_1
XFILLER_0_7_721 VGND VGND VPWR VPWR sky130_fd_sc_hd__decap_6
X_7595_ _4166_ VGND VGND VPWR VPWR _0586_ sky130_fd_sc_hd__inv_2
X_6615_ sh13\[4\] _3451_ VGND VGND VPWR VPWR _3610_ sky130_fd_sc_hd__nand2_1
XFILLER_0_6_253 VGND VGND VPWR VPWR sky130_fd_sc_hd__fill_1
X_6546_ _3537_ _3540_ _3542_ VGND VGND VPWR VPWR _3543_ sky130_fd_sc_hd__a21oi_1
XFILLER_0_40_91 VGND VGND VPWR VPWR sky130_fd_sc_hd__fill_1
XFILLER_0_112_261 VPWR VGND VPWR VGND sky130_ef_sc_hd__decap_12
X_6477_ _3471_ _3472_ _3474_ VGND VGND VPWR VPWR _3475_ sky130_fd_sc_hd__a21o_1
X_8216_ _1004_ _1056_ _1057_ _1058_ _1060_ VGND VGND VPWR VPWR _1061_ sky130_fd_sc_hd__o221ai_4
X_5428_ _2365_ _2418_ _2419_ VGND VGND VPWR VPWR _2451_ sky130_fd_sc_hd__and3_1
XFILLER_0_100_467 VGND VGND VPWR VPWR sky130_fd_sc_hd__decap_8
X_5359_ _2060_ _2071_ _2377_ VGND VGND VPWR VPWR _2384_ sky130_fd_sc_hd__a21o_1
X_8147_ _0992_ _0985_ _0991_ VGND VGND VPWR VPWR _0994_ sky130_fd_sc_hd__nand3_1
X_8078_ _0924_ _0925_ VGND VGND VPWR VPWR _0926_ sky130_fd_sc_hd__and2_1
X_7029_ _4012_ _4014_ VGND VGND VPWR VPWR _0149_ sky130_fd_sc_hd__xnor2_1
XFILLER_0_97_513 VPWR VGND VPWR VGND sky130_ef_sc_hd__decap_12
XFILLER_0_84_218 VGND VGND VPWR VPWR sky130_fd_sc_hd__decap_3
XFILLER_0_92_273 VPWR VGND VPWR VGND sky130_ef_sc_hd__decap_12
XFILLER_0_108_589 VPWR VGND VPWR VGND sky130_ef_sc_hd__decap_12
XFILLER_0_123_559 VGND VGND VPWR VPWR sky130_fd_sc_hd__fill_1
XFILLER_0_61_660 VPWR VGND VPWR VGND sky130_ef_sc_hd__decap_12
XFILLER_0_33_373 VGND VGND VPWR VPWR sky130_fd_sc_hd__decap_6
XFILLER_0_61_693 VGND VGND VPWR VPWR sky130_fd_sc_hd__decap_8
XFILLER_0_60_192 VGND VGND VPWR VPWR sky130_fd_sc_hd__decap_4
XFILLER_0_103_261 VGND VGND VPWR VPWR sky130_fd_sc_hd__decap_3
XFILLER_0_29_15 VPWR VGND VPWR VGND sky130_ef_sc_hd__decap_12
XTAP_708 VGND VPWR sky130_fd_sc_hd__tapvpwrvgnd_1
XTAP_719 VGND VPWR sky130_fd_sc_hd__tapvpwrvgnd_1
XFILLER_0_88_502 VGND VGND VPWR VPWR sky130_fd_sc_hd__fill_1
XFILLER_0_0_27 VGND VGND VPWR VPWR sky130_fd_sc_hd__fill_1
XFILLER_0_118_309 VGND VGND VPWR VPWR sky130_fd_sc_hd__decap_8
XFILLER_0_56_421 VGND VGND VPWR VPWR sky130_fd_sc_hd__decap_4
XFILLER_0_29_646 VGND VGND VPWR VPWR sky130_fd_sc_hd__fill_1
X_4730_ _1729_ _1734_ _1750_ VGND VGND VPWR VPWR _1767_ sky130_fd_sc_hd__a21oi_1
XTAP_1491 VGND VPWR sky130_fd_sc_hd__tapvpwrvgnd_1
XTAP_1480 VGND VPWR sky130_fd_sc_hd__tapvpwrvgnd_1
X_4661_ _1694_ _1695_ _1696_ _1698_ VGND VGND VPWR VPWR _1699_ sky130_fd_sc_hd__o31a_1
XFILLER_0_83_273 VGND VGND VPWR VPWR sky130_fd_sc_hd__decap_6
XFILLER_0_28_178 VGND VGND VPWR VPWR sky130_fd_sc_hd__fill_1
XFILLER_0_44_638 VGND VGND VPWR VPWR sky130_fd_sc_hd__decap_6
XFILLER_0_114_526 VGND VGND VPWR VPWR sky130_fd_sc_hd__decap_6
X_7380_ _4145_ VGND VGND VPWR VPWR _0392_ sky130_fd_sc_hd__inv_2
XFILLER_0_71_457 VGND VGND VPWR VPWR sky130_fd_sc_hd__fill_2
X_6400_ _3354_ _3364_ _3393_ _3395_ _3398_ VGND VGND VPWR VPWR _3399_ sky130_fd_sc_hd__a221o_1
XFILLER_0_9_69 VPWR VGND VPWR VGND sky130_ef_sc_hd__decap_12
XFILLER_0_4_713 VGND VGND VPWR VPWR sky130_fd_sc_hd__fill_2
X_4592_ _1630_ _1631_ _1632_ VGND VGND VPWR VPWR _0135_ sky130_fd_sc_hd__o21ai_1
X_6331_ _3327_ _3328_ _3329_ _3301_ VGND VGND VPWR VPWR _3330_ sky130_fd_sc_hd__o22ai_2
XFILLER_0_3_223 VGND VGND VPWR VPWR sky130_fd_sc_hd__fill_1
XFILLER_0_24_340 VGND VGND VPWR VPWR sky130_fd_sc_hd__decap_4
XFILLER_0_24_362 VGND VGND VPWR VPWR sky130_fd_sc_hd__fill_2
XFILLER_0_101_63 VGND VGND VPWR VPWR sky130_fd_sc_hd__fill_1
X_6262_ _3234_ _3265_ VGND VGND VPWR VPWR _3266_ sky130_fd_sc_hd__xor2_2
XFILLER_0_12_579 VGND VGND VPWR VPWR sky130_fd_sc_hd__decap_4
XFILLER_0_10_83 VGND VGND VPWR VPWR sky130_fd_sc_hd__fill_1
XFILLER_0_3_289 VGND VGND VPWR VPWR sky130_fd_sc_hd__fill_2
X_6193_ net39 _2911_ VGND VGND VPWR VPWR _3198_ sky130_fd_sc_hd__and2_2
XFILLER_0_86_65 VPWR VGND VPWR VGND sky130_ef_sc_hd__decap_12
X_5213_ _2229_ _2233_ _2163_ VGND VGND VPWR VPWR _2241_ sky130_fd_sc_hd__nand3_1
X_8001_ _0787_ _0802_ VGND VGND VPWR VPWR _0850_ sky130_fd_sc_hd__nand2_1
X_5144_ _2101_ _2118_ _2171_ _2172_ VGND VGND VPWR VPWR _2173_ sky130_fd_sc_hd__nand4_2
X_5075_ sh8\[2\] VGND VGND VPWR VPWR _2104_ sky130_fd_sc_hd__clkbuf_4
XFILLER_0_29_3 VPWR VGND VPWR VGND sky130_ef_sc_hd__decap_12
X_8834_ clknet_leaf_6_clk net289 _0585_ VGND VGND VPWR VPWR sh10\[6\] sky130_fd_sc_hd__dfrtp_4
XFILLER_0_94_527 VGND VGND VPWR VPWR sky130_fd_sc_hd__decap_4
XFILLER_0_94_516 VGND VGND VPWR VPWR sky130_fd_sc_hd__decap_8
XFILLER_0_66_207 VGND VGND VPWR VPWR sky130_fd_sc_hd__decap_4
X_5977_ sh10\[6\] _2906_ _2872_ VGND VGND VPWR VPWR _2986_ sky130_fd_sc_hd__a21o_2
XFILLER_0_59_292 VGND VGND VPWR VPWR sky130_fd_sc_hd__decap_6
XFILLER_0_59_281 VGND VGND VPWR VPWR sky130_fd_sc_hd__decap_3
X_8765_ clknet_leaf_61_clk net337 _0516_ VGND VGND VPWR VPWR sh2\[1\] sky130_fd_sc_hd__dfrtp_1
X_4928_ _1915_ _1959_ _1956_ _1958_ VGND VGND VPWR VPWR _1962_ sky130_fd_sc_hd__o211a_2
XFILLER_0_74_251 VGND VGND VPWR VPWR sky130_fd_sc_hd__fill_1
XFILLER_0_19_134 VGND VGND VPWR VPWR sky130_fd_sc_hd__decap_6
X_8696_ clknet_leaf_58_clk _0160_ _0447_ VGND VGND VPWR VPWR bit_sum2\[7\] sky130_fd_sc_hd__dfrtp_1
X_7716_ carry1\[6\] sum1\[7\] VGND VGND VPWR VPWR _0630_ sky130_fd_sc_hd__xnor2_1
XFILLER_0_90_733 VGND VGND VPWR VPWR sky130_fd_sc_hd__fill_2
X_7647_ s5\[6\] _4174_ _4175_ VGND VGND VPWR VPWR _4177_ sky130_fd_sc_hd__or3_1
XFILLER_0_19_167 VGND VGND VPWR VPWR sky130_fd_sc_hd__fill_1
XFILLER_0_47_487 VGND VGND VPWR VPWR sky130_fd_sc_hd__decap_4
XFILLER_0_105_526 VGND VGND VPWR VPWR sky130_fd_sc_hd__fill_2
X_4859_ _1892_ _1893_ _1894_ VGND VGND VPWR VPWR _1895_ sky130_fd_sc_hd__a21oi_1
XFILLER_0_34_137 VGND VGND VPWR VPWR sky130_fd_sc_hd__decap_3
X_7578_ _4165_ VGND VGND VPWR VPWR _0570_ sky130_fd_sc_hd__inv_2
Xclkbuf_3_0__f_clk clknet_0_clk VGND VGND VPWR VPWR clknet_3_0__leaf_clk sky130_fd_sc_hd__clkbuf_16
XFILLER_0_120_507 VGND VGND VPWR VPWR sky130_fd_sc_hd__fill_1
X_6529_ _3286_ sh12\[4\] _3450_ VGND VGND VPWR VPWR _3526_ sky130_fd_sc_hd__a21oi_1
XFILLER_0_42_170 VPWR VGND VPWR VGND sky130_ef_sc_hd__decap_12
XFILLER_0_30_365 VPWR VGND VPWR VGND sky130_ef_sc_hd__decap_12
XFILLER_0_15_39 VPWR VGND VPWR VGND sky130_ef_sc_hd__decap_12
XFILLER_0_85_505 VGND VGND VPWR VPWR sky130_fd_sc_hd__decap_4
XFILLER_0_38_421 VGND VGND VPWR VPWR sky130_fd_sc_hd__decap_6
XFILLER_0_122_29 VPWR VGND VPWR VGND sky130_ef_sc_hd__decap_12
XFILLER_0_93_571 VGND VGND VPWR VPWR sky130_fd_sc_hd__decap_8
XFILLER_0_81_722 VGND VGND VPWR VPWR sky130_fd_sc_hd__decap_6
XFILLER_0_26_616 VGND VGND VPWR VPWR sky130_fd_sc_hd__decap_6
XFILLER_0_31_27 VPWR VGND VPWR VGND sky130_ef_sc_hd__decap_12
XFILLER_0_53_435 VPWR VGND VPWR VGND sky130_ef_sc_hd__decap_12
XFILLER_0_40_107 VGND VGND VPWR VPWR sky130_fd_sc_hd__fill_1
XFILLER_0_1_727 VGND VGND VPWR VPWR sky130_fd_sc_hd__fill_1
XFILLER_0_0_237 VPWR VGND VPWR VGND sky130_ef_sc_hd__decap_12
XTAP_505 VGND VPWR sky130_fd_sc_hd__tapvpwrvgnd_1
XTAP_516 VGND VPWR sky130_fd_sc_hd__tapvpwrvgnd_1
XFILLER_0_21_387 VGND VGND VPWR VPWR sky130_fd_sc_hd__decap_4
XTAP_527 VGND VPWR sky130_fd_sc_hd__tapvpwrvgnd_1
XTAP_538 VGND VPWR sky130_fd_sc_hd__tapvpwrvgnd_1
XTAP_549 VGND VPWR sky130_fd_sc_hd__tapvpwrvgnd_1
X_5900_ sh0\[6\] sh2\[6\] VGND VGND VPWR VPWR _2909_ sky130_fd_sc_hd__nor2_2
XFILLER_0_88_365 VPWR VGND VPWR VGND sky130_ef_sc_hd__decap_12
X_6880_ _3865_ _3867_ VGND VGND VPWR VPWR _3868_ sky130_fd_sc_hd__nand2_1
XFILLER_0_69_590 VGND VGND VPWR VPWR sky130_fd_sc_hd__fill_1
XFILLER_0_29_421 VGND VGND VPWR VPWR sky130_fd_sc_hd__fill_1
X_5831_ _2809_ _2844_ VGND VGND VPWR VPWR _2845_ sky130_fd_sc_hd__nand2_1
XFILLER_0_118_117 VGND VGND VPWR VPWR sky130_fd_sc_hd__decap_6
X_5762_ _2773_ _2776_ _2736_ VGND VGND VPWR VPWR _2777_ sky130_fd_sc_hd__a21oi_4
X_8550_ clknet_leaf_41_clk net94 _0301_ VGND VGND VPWR VPWR sum4\[0\] sky130_fd_sc_hd__dfrtp_1
X_4713_ _1729_ _1734_ _1750_ VGND VGND VPWR VPWR _1751_ sky130_fd_sc_hd__a21o_1
XFILLER_0_72_733 VGND VGND VPWR VPWR sky130_fd_sc_hd__fill_2
XFILLER_0_56_251 VGND VGND VPWR VPWR sky130_fd_sc_hd__fill_1
XFILLER_0_8_359 VGND VGND VPWR VPWR sky130_fd_sc_hd__decap_4
X_7501_ _4157_ VGND VGND VPWR VPWR _0501_ sky130_fd_sc_hd__inv_2
XFILLER_0_71_221 VGND VGND VPWR VPWR sky130_fd_sc_hd__decap_3
XFILLER_0_71_210 VGND VGND VPWR VPWR sky130_fd_sc_hd__decap_8
X_8481_ clknet_leaf_45_clk net176 _0232_ VGND VGND VPWR VPWR net19 sky130_fd_sc_hd__dfrtp_1
X_5693_ _2610_ _2709_ _2702_ _2706_ VGND VGND VPWR VPWR _2710_ sky130_fd_sc_hd__o211ai_2
XFILLER_0_44_457 VGND VGND VPWR VPWR sky130_fd_sc_hd__decap_8
X_4644_ sh2\[7\] VGND VGND VPWR VPWR _1682_ sky130_fd_sc_hd__inv_2
XFILLER_0_25_660 VPWR VGND VPWR VGND sky130_ef_sc_hd__decap_12
XFILLER_0_31_107 VGND VGND VPWR VPWR sky130_fd_sc_hd__decap_4
X_7432_ _4147_ VGND VGND VPWR VPWR _4151_ sky130_fd_sc_hd__buf_4
XFILLER_0_114_345 VGND VGND VPWR VPWR sky130_fd_sc_hd__decap_6
X_4575_ _1616_ _1617_ VGND VGND VPWR VPWR _1618_ sky130_fd_sc_hd__or2_1
X_7363_ _4143_ VGND VGND VPWR VPWR _0377_ sky130_fd_sc_hd__inv_2
XFILLER_0_4_565 VGND VGND VPWR VPWR sky130_fd_sc_hd__fill_1
XFILLER_0_31_129 VGND VGND VPWR VPWR sky130_fd_sc_hd__decap_8
X_7294_ _4137_ VGND VGND VPWR VPWR _0314_ sky130_fd_sc_hd__inv_2
X_6314_ _3303_ _3305_ _3312_ _3313_ VGND VGND VPWR VPWR _3314_ sky130_fd_sc_hd__a22oi_4
XFILLER_0_40_641 VGND VGND VPWR VPWR sky130_fd_sc_hd__decap_3
X_6245_ _3193_ _3194_ _3196_ VGND VGND VPWR VPWR _3249_ sky130_fd_sc_hd__o21a_1
XFILLER_0_97_86 VGND VGND VPWR VPWR sky130_fd_sc_hd__fill_2
XFILLER_0_12_376 VGND VGND VPWR VPWR sky130_fd_sc_hd__fill_1
XFILLER_0_110_562 VGND VGND VPWR VPWR sky130_fd_sc_hd__decap_4
X_6176_ _3168_ _3136_ VGND VGND VPWR VPWR _3182_ sky130_fd_sc_hd__nand2_1
X_5127_ _2144_ _2140_ _2143_ _2155_ VGND VGND VPWR VPWR _2156_ sky130_fd_sc_hd__a31oi_1
X_5058_ _2061_ _2037_ VGND VGND VPWR VPWR _2087_ sky130_fd_sc_hd__and2_2
XFILLER_0_46_90 VPWR VGND VPWR VGND sky130_ef_sc_hd__decap_12
XFILLER_0_94_302 VGND VGND VPWR VPWR sky130_fd_sc_hd__decap_6
XFILLER_0_67_505 VGND VGND VPWR VPWR sky130_fd_sc_hd__decap_6
Xclkbuf_leaf_64_clk clknet_3_0__leaf_clk VGND VGND VPWR VPWR clknet_leaf_64_clk sky130_fd_sc_hd__clkbuf_16
X_8817_ clknet_leaf_9_clk net34 _0568_ VGND VGND VPWR VPWR sh8\[5\] sky130_fd_sc_hd__dfrtp_1
XFILLER_0_94_335 VPWR VGND VPWR VGND sky130_ef_sc_hd__decap_12
XFILLER_0_1_81 VPWR VGND VPWR VGND sky130_ef_sc_hd__decap_12
X_8748_ clknet_leaf_48_clk net2 _0499_ VGND VGND VPWR VPWR sh0\[0\] sky130_fd_sc_hd__dfrtp_1
XFILLER_0_90_530 VGND VGND VPWR VPWR sky130_fd_sc_hd__fill_2
XFILLER_0_35_446 VGND VGND VPWR VPWR sky130_fd_sc_hd__fill_2
X_8679_ clknet_leaf_53_clk _0104_ _0430_ VGND VGND VPWR VPWR bit_sum1\[0\] sky130_fd_sc_hd__dfrtp_1
XFILLER_0_62_276 VGND VGND VPWR VPWR sky130_fd_sc_hd__fill_2
XFILLER_0_15_181 VGND VGND VPWR VPWR sky130_fd_sc_hd__fill_2
XFILLER_0_16_682 VPWR VGND VPWR VGND sky130_ef_sc_hd__decap_12
XFILLER_0_120_337 VGND VGND VPWR VPWR sky130_fd_sc_hd__decap_8
XFILLER_0_105_389 VGND VGND VPWR VPWR sky130_fd_sc_hd__decap_3
XFILLER_0_30_173 VPWR VGND VPWR VGND sky130_ef_sc_hd__decap_12
XFILLER_0_31_685 VPWR VGND VPWR VGND sky130_ef_sc_hd__decap_12
Xhold50 bit_sum6\[7\] VGND VGND VPWR VPWR net92 sky130_fd_sc_hd__dlygate4sd3_1
Xhold72 bit_sum4\[9\] VGND VGND VPWR VPWR net114 sky130_fd_sc_hd__dlygate4sd3_1
Xhold83 bit_sum3\[1\] VGND VGND VPWR VPWR net125 sky130_fd_sc_hd__dlygate4sd3_1
Xhold61 sum2\[0\] VGND VGND VPWR VPWR net103 sky130_fd_sc_hd__dlygate4sd3_1
Xhold94 bit_sum1\[0\] VGND VGND VPWR VPWR net136 sky130_fd_sc_hd__dlygate4sd3_1
XFILLER_0_97_140 VPWR VGND VPWR VGND sky130_ef_sc_hd__decap_12
Xclkbuf_leaf_55_clk clknet_3_1__leaf_clk VGND VGND VPWR VPWR clknet_leaf_55_clk sky130_fd_sc_hd__clkbuf_16
XFILLER_0_97_195 VPWR VGND VPWR VGND sky130_ef_sc_hd__decap_12
XFILLER_0_97_173 VGND VGND VPWR VPWR sky130_fd_sc_hd__fill_1
XFILLER_0_58_549 VPWR VGND VPWR VGND sky130_ef_sc_hd__decap_12
XFILLER_0_42_15 VPWR VGND VPWR VGND sky130_ef_sc_hd__decap_12
XFILLER_0_66_582 VGND VGND VPWR VPWR sky130_fd_sc_hd__decap_6
XFILLER_0_38_251 VGND VGND VPWR VPWR sky130_fd_sc_hd__fill_1
XFILLER_0_109_673 VPWR VGND VPWR VGND sky130_ef_sc_hd__decap_12
XFILLER_0_81_541 VPWR VGND VPWR VGND sky130_ef_sc_hd__decap_12
XFILLER_0_54_733 VGND VGND VPWR VPWR sky130_fd_sc_hd__fill_2
XFILLER_0_81_574 VGND VGND VPWR VPWR sky130_fd_sc_hd__fill_1
XFILLER_0_14_608 VPWR VGND VPWR VGND sky130_ef_sc_hd__decap_12
XFILLER_0_123_153 VPWR VGND VPWR VGND sky130_ef_sc_hd__decap_12
XFILLER_0_41_438 VGND VGND VPWR VPWR sky130_fd_sc_hd__decap_8
X_4360_ _1396_ _1400_ _1405_ _1406_ VGND VGND VPWR VPWR _1407_ sky130_fd_sc_hd__o211ai_4
XFILLER_0_6_15 VPWR VGND VPWR VGND sky130_ef_sc_hd__decap_12
XFILLER_0_22_663 VPWR VGND VPWR VGND sky130_ef_sc_hd__decap_12
XFILLER_0_123_197 VPWR VGND VPWR VGND sky130_ef_sc_hd__decap_12
XFILLER_0_111_337 VPWR VGND VPWR VGND sky130_ef_sc_hd__decap_12
X_4291_ _1331_ _1330_ _1329_ VGND VGND VPWR VPWR _1339_ sky130_fd_sc_hd__a21boi_1
XTAP_324 VGND VPWR sky130_fd_sc_hd__tapvpwrvgnd_1
XTAP_313 VGND VPWR sky130_fd_sc_hd__tapvpwrvgnd_1
XTAP_302 VGND VPWR sky130_fd_sc_hd__tapvpwrvgnd_1
X_6030_ _3037_ _3032_ VGND VGND VPWR VPWR _3038_ sky130_fd_sc_hd__nand2_1
XTAP_346 VGND VPWR sky130_fd_sc_hd__tapvpwrvgnd_1
XTAP_357 VGND VPWR sky130_fd_sc_hd__tapvpwrvgnd_1
XTAP_335 VGND VPWR sky130_fd_sc_hd__tapvpwrvgnd_1
XTAP_379 VGND VPWR sky130_fd_sc_hd__tapvpwrvgnd_1
XTAP_368 VGND VPWR sky130_fd_sc_hd__tapvpwrvgnd_1
XFILLER_0_107_40 VGND VGND VPWR VPWR sky130_fd_sc_hd__fill_2
XFILLER_0_83_55 VGND VGND VPWR VPWR sky130_fd_sc_hd__fill_1
X_7981_ _0829_ _0822_ VGND VGND VPWR VPWR _0830_ sky130_fd_sc_hd__nand2_4
XFILLER_0_107_73 VPWR VGND VPWR VGND sky130_ef_sc_hd__decap_12
XPHY_19 VGND VGND VPWR VPWR sky130_fd_sc_hd__decap_3
X_6932_ _3838_ _3840_ _3917_ _3918_ VGND VGND VPWR VPWR _3919_ sky130_fd_sc_hd__o211ai_4
Xclkbuf_leaf_46_clk clknet_3_5__leaf_clk VGND VGND VPWR VPWR clknet_leaf_46_clk sky130_fd_sc_hd__clkbuf_16
XFILLER_0_49_505 VGND VGND VPWR VPWR sky130_fd_sc_hd__fill_2
X_6863_ _3832_ _3835_ _3850_ VGND VGND VPWR VPWR _3851_ sky130_fd_sc_hd__o21a_1
X_5814_ _2786_ _2783_ _2777_ VGND VGND VPWR VPWR _2828_ sky130_fd_sc_hd__a21oi_1
XFILLER_0_29_240 VPWR VGND VPWR VGND sky130_ef_sc_hd__decap_12
X_8602_ clknet_leaf_52_clk net86 _0353_ VGND VGND VPWR VPWR s1\[3\] sky130_fd_sc_hd__dfrtp_1
X_6794_ _3762_ _3771_ _3781_ _3782_ VGND VGND VPWR VPWR _3783_ sky130_fd_sc_hd__o2bb2ai_2
XFILLER_0_72_530 VGND VGND VPWR VPWR sky130_fd_sc_hd__fill_2
X_8533_ clknet_leaf_33_clk _0077_ _0284_ VGND VGND VPWR VPWR sum3\[7\] sky130_fd_sc_hd__dfrtp_1
X_5745_ _2724_ _2758_ _2760_ VGND VGND VPWR VPWR _2761_ sky130_fd_sc_hd__o21ai_2
XFILLER_0_96_3 VPWR VGND VPWR VGND sky130_ef_sc_hd__decap_12
X_8464_ clknet_leaf_27_clk net358 _0215_ VGND VGND VPWR VPWR carry5\[11\] sky130_fd_sc_hd__dfrtp_1
XFILLER_0_8_189 VGND VGND VPWR VPWR sky130_fd_sc_hd__decap_6
XFILLER_0_17_468 VGND VGND VPWR VPWR sky130_fd_sc_hd__fill_2
X_5676_ _2683_ _2688_ _2692_ VGND VGND VPWR VPWR _2693_ sky130_fd_sc_hd__a21o_1
X_4627_ sh10\[7\] sh11\[7\] VGND VGND VPWR VPWR _1666_ sky130_fd_sc_hd__and2_1
X_7415_ _4149_ VGND VGND VPWR VPWR _0423_ sky130_fd_sc_hd__inv_2
X_8395_ sh10\[5\] sh11\[5\] VGND VGND VPWR VPWR _1225_ sky130_fd_sc_hd__and2_2
XFILLER_0_13_630 VGND VGND VPWR VPWR sky130_fd_sc_hd__fill_2
X_4558_ _1597_ _1557_ _1600_ _1560_ VGND VGND VPWR VPWR _1601_ sky130_fd_sc_hd__o211ai_4
XFILLER_0_13_685 VPWR VGND VPWR VGND sky130_ef_sc_hd__decap_12
X_7346_ _4142_ VGND VGND VPWR VPWR _0361_ sky130_fd_sc_hd__inv_2
X_4489_ _1531_ _1532_ _1533_ VGND VGND VPWR VPWR _1534_ sky130_fd_sc_hd__a21o_1
X_7277_ _4135_ VGND VGND VPWR VPWR _0299_ sky130_fd_sc_hd__inv_2
XFILLER_0_40_493 VPWR VGND VPWR VGND sky130_ef_sc_hd__decap_12
X_6228_ _3169_ _3174_ _3175_ _3179_ VGND VGND VPWR VPWR _3233_ sky130_fd_sc_hd__o211a_1
X_6159_ _3079_ _3088_ _3092_ VGND VGND VPWR VPWR _3165_ sky130_fd_sc_hd__a21o_1
XTAP_880 VGND VPWR sky130_fd_sc_hd__tapvpwrvgnd_1
XFILLER_0_99_416 VGND VGND VPWR VPWR sky130_fd_sc_hd__decap_8
XTAP_891 VGND VPWR sky130_fd_sc_hd__tapvpwrvgnd_1
XFILLER_0_99_449 VPWR VGND VPWR VGND sky130_ef_sc_hd__decap_12
Xclkbuf_leaf_37_clk clknet_3_5__leaf_clk VGND VGND VPWR VPWR clknet_leaf_37_clk sky130_fd_sc_hd__clkbuf_16
XFILLER_0_82_316 VGND VGND VPWR VPWR sky130_fd_sc_hd__fill_2
XFILLER_0_12_29 VPWR VGND VPWR VGND sky130_ef_sc_hd__decap_12
XFILLER_0_36_733 VGND VGND VPWR VPWR sky130_fd_sc_hd__fill_2
XFILLER_0_23_405 VPWR VGND VPWR VGND sky130_ef_sc_hd__decap_12
XFILLER_0_90_382 VPWR VGND VPWR VGND sky130_ef_sc_hd__decap_12
XFILLER_0_63_585 VPWR VGND VPWR VGND sky130_ef_sc_hd__decap_12
XFILLER_0_106_698 VGND VGND VPWR VPWR sky130_fd_sc_hd__fill_2
XFILLER_0_105_153 VGND VGND VPWR VPWR sky130_fd_sc_hd__fill_1
XFILLER_0_121_646 VGND VGND VPWR VPWR sky130_fd_sc_hd__decap_3
XFILLER_0_31_493 VGND VGND VPWR VPWR sky130_fd_sc_hd__decap_8
XFILLER_0_120_189 VGND VGND VPWR VPWR sky130_fd_sc_hd__decap_6
XFILLER_0_37_15 VPWR VGND VPWR VGND sky130_ef_sc_hd__decap_12
Xclkbuf_leaf_28_clk clknet_3_7__leaf_clk VGND VGND VPWR VPWR clknet_leaf_28_clk sky130_fd_sc_hd__clkbuf_16
XFILLER_0_85_154 VPWR VGND VPWR VGND sky130_ef_sc_hd__decap_12
XFILLER_0_73_349 VGND VGND VPWR VPWR sky130_fd_sc_hd__fill_1
XPHY_190 VGND VGND VPWR VPWR sky130_fd_sc_hd__decap_3
XFILLER_0_6_638 VGND VGND VPWR VPWR sky130_fd_sc_hd__decap_6
XFILLER_0_5_137 VPWR VGND VPWR VGND sky130_ef_sc_hd__decap_12
X_5530_ _2548_ _2469_ VGND VGND VPWR VPWR _2549_ sky130_fd_sc_hd__nor2_2
XFILLER_0_26_232 VGND VGND VPWR VPWR sky130_fd_sc_hd__fill_2
XFILLER_0_81_393 VPWR VGND VPWR VGND sky130_ef_sc_hd__decap_12
XFILLER_0_81_360 VGND VGND VPWR VPWR sky130_fd_sc_hd__decap_4
X_5461_ _2480_ VGND VGND VPWR VPWR _2481_ sky130_fd_sc_hd__clkbuf_4
XFILLER_0_26_298 VGND VGND VPWR VPWR sky130_fd_sc_hd__decap_8
X_4412_ _1438_ _1457_ _1434_ VGND VGND VPWR VPWR _1458_ sky130_fd_sc_hd__a21oi_2
X_7200_ _4128_ VGND VGND VPWR VPWR _0229_ sky130_fd_sc_hd__inv_2
XFILLER_0_1_310 VPWR VGND VPWR VGND sky130_ef_sc_hd__decap_12
X_8180_ _1023_ _1024_ _1025_ VGND VGND VPWR VPWR _1026_ sky130_fd_sc_hd__nand3_2
X_5392_ _2357_ _2358_ _2359_ _2361_ VGND VGND VPWR VPWR _2417_ sky130_fd_sc_hd__o211a_1
XFILLER_0_41_279 VGND VGND VPWR VPWR sky130_fd_sc_hd__fill_1
X_4343_ _1247_ net34 _1381_ VGND VGND VPWR VPWR _1390_ sky130_fd_sc_hd__a21oi_1
XFILLER_0_78_77 VGND VGND VPWR VPWR sky130_fd_sc_hd__decap_6
X_7131_ s1\[1\] net331 VGND VGND VPWR VPWR _4111_ sky130_fd_sc_hd__and2_1
X_4274_ _1252_ _1244_ _1321_ VGND VGND VPWR VPWR _1322_ sky130_fd_sc_hd__o21a_1
XFILLER_0_111_189 VPWR VGND VPWR VGND sky130_ef_sc_hd__decap_12
X_7062_ _4035_ _4042_ _4046_ VGND VGND VPWR VPWR _4047_ sky130_fd_sc_hd__nand3_2
X_6013_ _3011_ _3014_ _3019_ _3020_ VGND VGND VPWR VPWR _3021_ sky130_fd_sc_hd__o2bb2ai_4
XFILLER_0_94_43 VGND VGND VPWR VPWR sky130_fd_sc_hd__fill_1
XFILLER_0_10_699 VGND VGND VPWR VPWR sky130_fd_sc_hd__fill_1
XFILLER_0_118_83 VGND VGND VPWR VPWR sky130_fd_sc_hd__fill_1
Xclkbuf_leaf_19_clk clknet_3_6__leaf_clk VGND VGND VPWR VPWR clknet_leaf_19_clk sky130_fd_sc_hd__clkbuf_16
XFILLER_0_96_419 VGND VGND VPWR VPWR sky130_fd_sc_hd__fill_1
X_7964_ net42 sh3\[3\] sh4\[3\] VGND VGND VPWR VPWR _0813_ sky130_fd_sc_hd__o21ai_4
XTAP_1309 VGND VPWR sky130_fd_sc_hd__tapvpwrvgnd_1
XFILLER_0_11_3 VPWR VGND VPWR VGND sky130_ef_sc_hd__decap_12
X_6915_ _3897_ _3901_ _3828_ VGND VGND VPWR VPWR _3903_ sky130_fd_sc_hd__nand3_2
XFILLER_0_77_644 VGND VGND VPWR VPWR sky130_fd_sc_hd__decap_4
XFILLER_0_76_121 VPWR VGND VPWR VGND sky130_ef_sc_hd__decap_12
X_7895_ _0743_ _0744_ VGND VGND VPWR VPWR _0745_ sky130_fd_sc_hd__nand2_2
XFILLER_0_119_223 VGND VGND VPWR VPWR sky130_fd_sc_hd__fill_1
X_6846_ _3832_ _3833_ _3768_ VGND VGND VPWR VPWR _3834_ sky130_fd_sc_hd__o21ba_1
XFILLER_0_91_124 VGND VGND VPWR VPWR sky130_fd_sc_hd__decap_6
XFILLER_0_91_113 VGND VGND VPWR VPWR sky130_fd_sc_hd__fill_1
XFILLER_0_9_454 VPWR VGND VPWR VGND sky130_ef_sc_hd__decap_12
XFILLER_0_17_221 VGND VGND VPWR VPWR sky130_fd_sc_hd__decap_3
XFILLER_0_18_733 VGND VGND VPWR VPWR sky130_fd_sc_hd__fill_2
X_6777_ sh13\[1\] VGND VGND VPWR VPWR _3766_ sky130_fd_sc_hd__inv_2
XFILLER_0_45_530 VPWR VGND VPWR VGND sky130_ef_sc_hd__decap_12
X_8516_ clknet_leaf_39_clk _0096_ _0267_ VGND VGND VPWR VPWR sum5\[6\] sky130_fd_sc_hd__dfrtp_1
X_5728_ _2741_ _2740_ VGND VGND VPWR VPWR _2744_ sky130_fd_sc_hd__nand2_1
XFILLER_0_60_533 VGND VGND VPWR VPWR sky130_fd_sc_hd__decap_4
XFILLER_0_60_522 VGND VGND VPWR VPWR sky130_fd_sc_hd__fill_2
X_8447_ clknet_leaf_28_clk net419 _0198_ VGND VGND VPWR VPWR carry4\[13\] sky130_fd_sc_hd__dfrtp_1
X_5659_ _2618_ _2616_ _2634_ VGND VGND VPWR VPWR _2676_ sky130_fd_sc_hd__o21ai_1
XFILLER_0_5_671 VGND VGND VPWR VPWR sky130_fd_sc_hd__fill_1
XFILLER_0_102_134 VGND VGND VPWR VPWR sky130_fd_sc_hd__decap_6
X_8378_ sum5\[13\] s7\[13\] _1199_ VGND VGND VPWR VPWR _1211_ sky130_fd_sc_hd__a21bo_1
XFILLER_0_20_419 VGND VGND VPWR VPWR sky130_fd_sc_hd__fill_1
Xhold361 _0027_ VGND VGND VPWR VPWR net403 sky130_fd_sc_hd__dlygate4sd3_1
X_7329_ _4140_ VGND VGND VPWR VPWR _0346_ sky130_fd_sc_hd__inv_2
Xhold350 _0014_ VGND VGND VPWR VPWR net392 sky130_fd_sc_hd__dlygate4sd3_1
Xhold394 sh6\[4\] VGND VGND VPWR VPWR net436 sky130_fd_sc_hd__dlygate4sd3_1
Xhold383 _0031_ VGND VGND VPWR VPWR net425 sky130_fd_sc_hd__dlygate4sd3_1
Xhold372 _0025_ VGND VGND VPWR VPWR net414 sky130_fd_sc_hd__dlygate4sd3_1
XFILLER_0_99_279 VGND VGND VPWR VPWR sky130_fd_sc_hd__fill_1
XFILLER_0_68_633 VGND VGND VPWR VPWR sky130_fd_sc_hd__decap_8
XTAP_1843 VGND VPWR sky130_fd_sc_hd__tapvpwrvgnd_1
XTAP_1832 VGND VPWR sky130_fd_sc_hd__tapvpwrvgnd_1
XTAP_1821 VGND VPWR sky130_fd_sc_hd__tapvpwrvgnd_1
XTAP_1810 VGND VPWR sky130_fd_sc_hd__tapvpwrvgnd_1
XFILLER_0_95_452 VPWR VGND VPWR VGND sky130_ef_sc_hd__decap_12
XTAP_1876 VGND VPWR sky130_fd_sc_hd__tapvpwrvgnd_1
XTAP_1865 VGND VPWR sky130_fd_sc_hd__tapvpwrvgnd_1
XTAP_1854 VGND VPWR sky130_fd_sc_hd__tapvpwrvgnd_1
XFILLER_0_67_165 VGND VGND VPWR VPWR sky130_fd_sc_hd__decap_3
XFILLER_0_63_360 VPWR VGND VPWR VGND sky130_ef_sc_hd__decap_12
XFILLER_0_24_725 VGND VGND VPWR VPWR sky130_fd_sc_hd__fill_2
XFILLER_0_63_393 VGND VGND VPWR VPWR sky130_fd_sc_hd__decap_8
XFILLER_0_23_279 VGND VGND VPWR VPWR sky130_fd_sc_hd__fill_1
XFILLER_0_51_599 VPWR VGND VPWR VGND sky130_ef_sc_hd__decap_12
XFILLER_0_3_27 VPWR VGND VPWR VGND sky130_ef_sc_hd__decap_12
X_4961_ _1946_ _1992_ _1994_ VGND VGND VPWR VPWR _1995_ sky130_fd_sc_hd__o21a_1
XFILLER_0_59_666 VGND VGND VPWR VPWR sky130_fd_sc_hd__decap_6
XFILLER_0_58_121 VGND VGND VPWR VPWR sky130_fd_sc_hd__decap_3
X_4892_ _1910_ _1923_ _1926_ VGND VGND VPWR VPWR _1927_ sky130_fd_sc_hd__nand3_1
X_6700_ _3678_ _3690_ _3691_ _3688_ _3692_ VGND VGND VPWR VPWR _3693_ sky130_fd_sc_hd__o221a_1
X_7680_ sum3\[13\] carry3\[12\] VGND VGND VPWR VPWR _4203_ sky130_fd_sc_hd__nor2_1
XFILLER_0_58_176 VGND VGND VPWR VPWR sky130_fd_sc_hd__fill_1
XFILLER_0_117_727 VGND VGND VPWR VPWR sky130_fd_sc_hd__fill_1
X_6631_ _3616_ _3624_ _3625_ VGND VGND VPWR VPWR _3626_ sky130_fd_sc_hd__nand3b_2
XFILLER_0_116_226 VPWR VGND VPWR VGND sky130_ef_sc_hd__decap_12
XFILLER_0_104_85 VGND VGND VPWR VPWR sky130_fd_sc_hd__fill_1
XFILLER_0_13_61 VGND VGND VPWR VPWR sky130_fd_sc_hd__fill_1
X_6562_ _3555_ _3557_ _3311_ VGND VGND VPWR VPWR _3558_ sky130_fd_sc_hd__o21ai_1
X_8301_ sum5\[8\] s7\[8\] _1139_ VGND VGND VPWR VPWR _1140_ sky130_fd_sc_hd__a21o_1
XFILLER_0_27_596 VPWR VGND VPWR VGND sky130_ef_sc_hd__decap_12
X_6493_ _3301_ _3304_ _3289_ VGND VGND VPWR VPWR _3490_ sky130_fd_sc_hd__o21bai_2
X_5513_ _2530_ _2527_ _2528_ VGND VGND VPWR VPWR _2532_ sky130_fd_sc_hd__nand3_1
XFILLER_0_42_533 VGND VGND VPWR VPWR sky130_fd_sc_hd__decap_4
X_8232_ _1015_ _1076_ _1065_ _1069_ VGND VGND VPWR VPWR _1077_ sky130_fd_sc_hd__o211a_1
X_5444_ _2133_ _2184_ VGND VGND VPWR VPWR _2465_ sky130_fd_sc_hd__and2_1
X_8163_ _0870_ _0731_ _0738_ VGND VGND VPWR VPWR _1009_ sky130_fd_sc_hd__o21a_1
XFILLER_0_59_3 VGND VGND VPWR VPWR sky130_fd_sc_hd__decap_4
X_7114_ _4055_ _4059_ _4061_ _4011_ _4095_ VGND VGND VPWR VPWR _4097_ sky130_fd_sc_hd__o2111a_1
X_5375_ _2386_ _2390_ _2371_ VGND VGND VPWR VPWR _2400_ sky130_fd_sc_hd__a21boi_2
X_4326_ _1372_ _1293_ _1360_ _1366_ VGND VGND VPWR VPWR _1373_ sky130_fd_sc_hd__a22oi_4
X_8094_ _0938_ _0733_ _0939_ _0940_ VGND VGND VPWR VPWR _0941_ sky130_fd_sc_hd__o211ai_4
X_4257_ _1286_ _1303_ _1304_ VGND VGND VPWR VPWR _1305_ sky130_fd_sc_hd__nand3_4
X_7045_ _4021_ _4023_ _4029_ VGND VGND VPWR VPWR _4030_ sky130_fd_sc_hd__o21ai_1
XTAP_1128 VGND VPWR sky130_fd_sc_hd__tapvpwrvgnd_1
XTAP_1117 VGND VPWR sky130_fd_sc_hd__tapvpwrvgnd_1
XTAP_1106 VGND VPWR sky130_fd_sc_hd__tapvpwrvgnd_1
X_7947_ _0751_ _0794_ sh14\[3\] VGND VGND VPWR VPWR _0796_ sky130_fd_sc_hd__o21ai_1
XTAP_1139 VGND VPWR sky130_fd_sc_hd__tapvpwrvgnd_1
X_7878_ _0722_ _0723_ _0727_ VGND VGND VPWR VPWR _0728_ sky130_fd_sc_hd__and3_1
XFILLER_0_92_411 VGND VGND VPWR VPWR sky130_fd_sc_hd__decap_3
XFILLER_0_77_496 VGND VGND VPWR VPWR sky130_fd_sc_hd__decap_8
XFILLER_0_64_124 VGND VGND VPWR VPWR sky130_fd_sc_hd__decap_8
X_6829_ _3814_ _3815_ _3817_ VGND VGND VPWR VPWR _3818_ sky130_fd_sc_hd__a21oi_1
XFILLER_0_37_349 VGND VGND VPWR VPWR sky130_fd_sc_hd__decap_4
XFILLER_0_49_198 VPWR VGND VPWR VGND sky130_ef_sc_hd__decap_12
XFILLER_0_80_617 VGND VGND VPWR VPWR sky130_fd_sc_hd__fill_2
XFILLER_0_65_669 VGND VGND VPWR VPWR sky130_fd_sc_hd__decap_3
XFILLER_0_18_552 VGND VGND VPWR VPWR sky130_fd_sc_hd__decap_3
XFILLER_0_107_259 VGND VGND VPWR VPWR sky130_fd_sc_hd__decap_3
XFILLER_0_107_237 VGND VGND VPWR VPWR sky130_fd_sc_hd__fill_2
XFILLER_0_80_639 VGND VGND VPWR VPWR sky130_fd_sc_hd__decap_4
XFILLER_0_45_393 VGND VGND VPWR VPWR sky130_fd_sc_hd__decap_8
XFILLER_0_60_363 VGND VGND VPWR VPWR sky130_fd_sc_hd__fill_1
Xhold180 s4\[6\] VGND VGND VPWR VPWR net222 sky130_fd_sc_hd__clkdlybuf4s25_1
Xhold191 sh5\[3\] VGND VGND VPWR VPWR net233 sky130_fd_sc_hd__dlygate4sd3_1
XFILLER_0_0_3 VPWR VGND VPWR VGND sky130_ef_sc_hd__decap_12
XFILLER_0_34_27 VGND VGND VPWR VPWR sky130_fd_sc_hd__fill_1
XFILLER_0_68_441 VGND VGND VPWR VPWR sky130_fd_sc_hd__decap_8
XTAP_1651 VGND VPWR sky130_fd_sc_hd__tapvpwrvgnd_1
XTAP_1640 VGND VPWR sky130_fd_sc_hd__tapvpwrvgnd_1
XFILLER_0_68_474 VGND VGND VPWR VPWR sky130_fd_sc_hd__fill_2
XTAP_1684 VGND VPWR sky130_fd_sc_hd__tapvpwrvgnd_1
XTAP_1673 VGND VPWR sky130_fd_sc_hd__tapvpwrvgnd_1
XTAP_1662 VGND VPWR sky130_fd_sc_hd__tapvpwrvgnd_1
XFILLER_0_55_113 VPWR VGND VPWR VGND sky130_ef_sc_hd__decap_12
XFILLER_0_50_15 VPWR VGND VPWR VGND sky130_ef_sc_hd__decap_12
XTAP_1695 VGND VPWR sky130_fd_sc_hd__tapvpwrvgnd_1
XFILLER_0_70_116 VPWR VGND VPWR VGND sky130_ef_sc_hd__decap_12
XFILLER_0_24_533 VPWR VGND VPWR VGND sky130_ef_sc_hd__decap_12
XFILLER_0_59_57 VGND VGND VPWR VPWR sky130_fd_sc_hd__fill_2
XFILLER_0_59_79 VGND VGND VPWR VPWR sky130_fd_sc_hd__decap_4
X_5160_ _2101_ _2118_ _2171_ _2172_ _2166_ VGND VGND VPWR VPWR _2188_ sky130_fd_sc_hd__a41oi_4
X_5091_ _2112_ _2118_ _2119_ VGND VGND VPWR VPWR _2120_ sky130_fd_sc_hd__a21o_1
XFILLER_0_79_717 VGND VGND VPWR VPWR sky130_fd_sc_hd__decap_8
X_8850_ clknet_leaf_2_clk net239 _0601_ VGND VGND VPWR VPWR sh12\[6\] sky130_fd_sc_hd__dfrtp_1
X_5993_ _2878_ _2911_ _2883_ VGND VGND VPWR VPWR _3001_ sky130_fd_sc_hd__o21ai_2
X_8781_ clknet_leaf_61_clk net206 _0532_ VGND VGND VPWR VPWR sh4\[1\] sky130_fd_sc_hd__dfrtp_4
X_7801_ net367 s1\[6\] net212 VGND VGND VPWR VPWR _0686_ sky130_fd_sc_hd__a21o_1
X_4944_ _1977_ VGND VGND VPWR VPWR _1978_ sky130_fd_sc_hd__buf_2
XFILLER_0_115_51 VGND VGND VPWR VPWR sky130_fd_sc_hd__decap_4
XFILLER_0_91_77 VGND VGND VPWR VPWR sky130_fd_sc_hd__decap_4
XFILLER_0_86_260 VGND VGND VPWR VPWR sky130_fd_sc_hd__decap_4
X_7732_ net320 _0639_ VGND VGND VPWR VPWR _0096_ sky130_fd_sc_hd__nand2_1
XFILLER_0_59_452 VGND VGND VPWR VPWR sky130_fd_sc_hd__decap_3
XFILLER_0_24_60 VGND VGND VPWR VPWR sky130_fd_sc_hd__decap_4
XFILLER_0_47_603 VPWR VGND VPWR VGND sky130_ef_sc_hd__decap_12
XFILLER_0_86_282 VGND VGND VPWR VPWR sky130_fd_sc_hd__fill_2
XFILLER_0_24_93 VGND VGND VPWR VPWR sky130_fd_sc_hd__decap_8
XFILLER_0_46_102 VGND VGND VPWR VPWR sky130_fd_sc_hd__decap_6
X_4875_ _1844_ _1883_ _1839_ _1837_ VGND VGND VPWR VPWR _1910_ sky130_fd_sc_hd__a31o_1
X_7663_ _4188_ _4189_ VGND VGND VPWR VPWR _0089_ sky130_fd_sc_hd__nand2_1
XFILLER_0_62_617 VGND VGND VPWR VPWR sky130_fd_sc_hd__fill_2
XFILLER_0_46_146 VGND VGND VPWR VPWR sky130_fd_sc_hd__decap_4
XFILLER_0_47_669 VGND VGND VPWR VPWR sky130_fd_sc_hd__decap_3
X_6614_ sh13\[4\] sh9\[4\] VGND VGND VPWR VPWR _3609_ sky130_fd_sc_hd__nor2_1
X_7594_ _4166_ VGND VGND VPWR VPWR _0585_ sky130_fd_sc_hd__inv_2
XFILLER_0_6_221 VPWR VGND VPWR VGND sky130_ef_sc_hd__decap_12
X_6545_ _3337_ _3541_ _3476_ VGND VGND VPWR VPWR _3542_ sky130_fd_sc_hd__o21ai_1
XFILLER_0_6_287 VGND VGND VPWR VPWR sky130_fd_sc_hd__fill_2
XFILLER_0_27_393 VGND VGND VPWR VPWR sky130_fd_sc_hd__decap_6
X_8215_ _1057_ _1059_ _0776_ VGND VGND VPWR VPWR _1060_ sky130_fd_sc_hd__o21ai_2
X_6476_ _3403_ _3473_ _3401_ VGND VGND VPWR VPWR _3474_ sky130_fd_sc_hd__o21ai_2
XFILLER_0_15_599 VGND VGND VPWR VPWR sky130_fd_sc_hd__fill_2
XFILLER_0_112_273 VPWR VGND VPWR VGND sky130_ef_sc_hd__decap_12
XFILLER_0_30_569 VGND VGND VPWR VPWR sky130_fd_sc_hd__decap_3
X_5427_ _2449_ _2450_ VGND VGND VPWR VPWR _0160_ sky130_fd_sc_hd__nand2_1
X_5358_ _2057_ _2038_ _2379_ VGND VGND VPWR VPWR _2383_ sky130_fd_sc_hd__a21o_2
X_8146_ _0985_ _0991_ _0992_ VGND VGND VPWR VPWR _0993_ sky130_fd_sc_hd__a21oi_1
X_4309_ _1239_ sh3\[5\] _1242_ VGND VGND VPWR VPWR _1356_ sky130_fd_sc_hd__o21a_1
X_8077_ _0858_ _0921_ _0923_ VGND VGND VPWR VPWR _0925_ sky130_fd_sc_hd__nand3_2
X_7028_ _3958_ _3962_ _3963_ _4013_ VGND VGND VPWR VPWR _4014_ sky130_fd_sc_hd__a31o_1
X_5289_ sh15\[2\] VGND VGND VPWR VPWR _2315_ sky130_fd_sc_hd__inv_2
XFILLER_0_97_525 VGND VGND VPWR VPWR sky130_fd_sc_hd__decap_3
XFILLER_0_97_503 VGND VGND VPWR VPWR sky130_fd_sc_hd__fill_1
XFILLER_0_69_216 VGND VGND VPWR VPWR sky130_fd_sc_hd__fill_2
XFILLER_0_37_113 VPWR VGND VPWR VGND sky130_ef_sc_hd__decap_12
XFILLER_0_92_285 VGND VGND VPWR VPWR sky130_fd_sc_hd__decap_3
XFILLER_0_25_308 VGND VGND VPWR VPWR sky130_fd_sc_hd__decap_4
XFILLER_0_123_505 VGND VGND VPWR VPWR sky130_fd_sc_hd__decap_6
XFILLER_0_20_18 VGND VGND VPWR VPWR sky130_fd_sc_hd__decap_8
XFILLER_0_33_352 VGND VGND VPWR VPWR sky130_fd_sc_hd__fill_1
XFILLER_0_29_27 VPWR VGND VPWR VGND sky130_ef_sc_hd__decap_12
XTAP_709 VGND VPWR sky130_fd_sc_hd__tapvpwrvgnd_1
XFILLER_0_45_15 VPWR VGND VPWR VGND sky130_ef_sc_hd__decap_12
XFILLER_0_45_48 VGND VGND VPWR VPWR sky130_fd_sc_hd__decap_8
XFILLER_0_61_36 VGND VGND VPWR VPWR sky130_fd_sc_hd__fill_1
XTAP_1492 VGND VPWR sky130_fd_sc_hd__tapvpwrvgnd_1
XTAP_1481 VGND VPWR sky130_fd_sc_hd__tapvpwrvgnd_1
XTAP_1470 VGND VPWR sky130_fd_sc_hd__tapvpwrvgnd_1
X_4660_ _1697_ _1694_ net31 VGND VGND VPWR VPWR _1698_ sky130_fd_sc_hd__o21ai_2
XFILLER_0_56_477 VGND VGND VPWR VPWR sky130_fd_sc_hd__decap_6
XFILLER_0_9_15 VPWR VGND VPWR VGND sky130_ef_sc_hd__decap_12
XFILLER_0_44_617 VGND VGND VPWR VPWR sky130_fd_sc_hd__fill_1
XFILLER_0_117_3 VPWR VGND VPWR VGND sky130_ef_sc_hd__decap_12
XFILLER_0_24_330 VGND VGND VPWR VPWR sky130_fd_sc_hd__decap_3
XFILLER_0_114_549 VPWR VGND VPWR VGND sky130_ef_sc_hd__decap_12
X_4591_ _1622_ _1627_ _1626_ VGND VGND VPWR VPWR _1632_ sky130_fd_sc_hd__a21o_1
X_6330_ _3294_ _3297_ _3298_ VGND VGND VPWR VPWR _3329_ sky130_fd_sc_hd__o21a_2
XFILLER_0_3_257 VGND VGND VPWR VPWR sky130_fd_sc_hd__fill_2
X_6261_ _3263_ _3264_ VGND VGND VPWR VPWR _3265_ sky130_fd_sc_hd__nand2_1
XFILLER_0_110_733 VGND VGND VPWR VPWR sky130_fd_sc_hd__fill_2
X_6192_ _2889_ _2936_ net37 VGND VGND VPWR VPWR _3197_ sky130_fd_sc_hd__o21a_1
X_5212_ _2229_ _2233_ _2163_ VGND VGND VPWR VPWR _2240_ sky130_fd_sc_hd__a21o_1
X_8000_ _0845_ _0847_ _0848_ VGND VGND VPWR VPWR _0849_ sky130_fd_sc_hd__nand3b_2
XFILLER_0_86_77 VGND VGND VPWR VPWR sky130_fd_sc_hd__decap_6
X_5143_ _2152_ _2145_ _2155_ VGND VGND VPWR VPWR _2172_ sky130_fd_sc_hd__a21o_1
X_5074_ sh7\[2\] _2102_ VGND VGND VPWR VPWR _2103_ sky130_fd_sc_hd__and2_1
XFILLER_0_79_503 VGND VGND VPWR VPWR sky130_fd_sc_hd__fill_1
X_8833_ clknet_leaf_11_clk net229 _0584_ VGND VGND VPWR VPWR sh10\[5\] sky130_fd_sc_hd__dfrtp_4
XFILLER_0_35_70 VPWR VGND VPWR VGND sky130_ef_sc_hd__decap_12
XFILLER_0_79_569 VGND VGND VPWR VPWR sky130_fd_sc_hd__decap_3
XFILLER_0_35_92 VGND VGND VPWR VPWR sky130_fd_sc_hd__fill_2
X_5976_ _2983_ _2981_ _2982_ VGND VGND VPWR VPWR _2985_ sky130_fd_sc_hd__and3_1
X_8764_ clknet_leaf_47_clk net247 _0515_ VGND VGND VPWR VPWR sh2\[0\] sky130_fd_sc_hd__dfrtp_4
XFILLER_0_19_102 VGND VGND VPWR VPWR sky130_fd_sc_hd__decap_8
XFILLER_0_19_113 VGND VGND VPWR VPWR sky130_fd_sc_hd__decap_8
X_4927_ _1956_ _1958_ _1960_ VGND VGND VPWR VPWR _1961_ sky130_fd_sc_hd__a21oi_2
XFILLER_0_74_241 VGND VGND VPWR VPWR sky130_fd_sc_hd__fill_1
X_7715_ net205 _0629_ VGND VGND VPWR VPWR _0066_ sky130_fd_sc_hd__xnor2_1
XFILLER_0_19_146 VGND VGND VPWR VPWR sky130_fd_sc_hd__decap_6
X_8695_ clknet_leaf_58_clk _0159_ _0446_ VGND VGND VPWR VPWR bit_sum2\[6\] sky130_fd_sc_hd__dfrtp_1
XFILLER_0_47_444 VGND VGND VPWR VPWR sky130_fd_sc_hd__decap_4
X_4858_ _1820_ _1808_ _1826_ _1827_ VGND VGND VPWR VPWR _1894_ sky130_fd_sc_hd__o2bb2ai_2
XFILLER_0_90_701 VPWR VGND VPWR VGND sky130_ef_sc_hd__decap_12
X_7646_ _4174_ _4175_ net420 VGND VGND VPWR VPWR _4176_ sky130_fd_sc_hd__o21ai_1
XFILLER_0_105_505 VGND VGND VPWR VPWR sky130_fd_sc_hd__decap_6
XFILLER_0_62_458 VGND VGND VPWR VPWR sky130_fd_sc_hd__fill_1
XFILLER_0_15_330 VGND VGND VPWR VPWR sky130_fd_sc_hd__decap_6
XFILLER_0_28_680 VPWR VGND VPWR VGND sky130_ef_sc_hd__decap_12
X_4789_ _1805_ _1806_ _1801_ VGND VGND VPWR VPWR _1826_ sky130_fd_sc_hd__and3_1
X_7577_ _4165_ VGND VGND VPWR VPWR _0569_ sky130_fd_sc_hd__inv_2
X_6528_ _3503_ _3522_ _3523_ _3524_ VGND VGND VPWR VPWR _3525_ sky130_fd_sc_hd__o211ai_4
XFILLER_0_15_374 VGND VGND VPWR VPWR sky130_fd_sc_hd__fill_1
X_6459_ _3447_ _3450_ VGND VGND VPWR VPWR _3457_ sky130_fd_sc_hd__nor2_1
XFILLER_0_30_377 VPWR VGND VPWR VGND sky130_ef_sc_hd__decap_12
X_8129_ _0967_ _0974_ _0975_ _0902_ VGND VGND VPWR VPWR _0976_ sky130_fd_sc_hd__o2bb2ai_2
XFILLER_0_58_709 VPWR VGND VPWR VGND sky130_ef_sc_hd__decap_12
XFILLER_0_97_399 VGND VGND VPWR VPWR sky130_fd_sc_hd__decap_4
XFILLER_0_93_550 VGND VGND VPWR VPWR sky130_fd_sc_hd__decap_8
XFILLER_0_31_39 VGND VGND VPWR VPWR sky130_fd_sc_hd__decap_8
XFILLER_0_38_477 VPWR VGND VPWR VGND sky130_ef_sc_hd__decap_12
XFILLER_0_108_365 VGND VGND VPWR VPWR sky130_fd_sc_hd__fill_1
XFILLER_0_53_447 VGND VGND VPWR VPWR sky130_fd_sc_hd__fill_1
XFILLER_0_0_249 VGND VGND VPWR VPWR sky130_fd_sc_hd__decap_3
XTAP_506 VGND VPWR sky130_fd_sc_hd__tapvpwrvgnd_1
XTAP_528 VGND VPWR sky130_fd_sc_hd__tapvpwrvgnd_1
XTAP_517 VGND VPWR sky130_fd_sc_hd__tapvpwrvgnd_1
XTAP_539 VGND VPWR sky130_fd_sc_hd__tapvpwrvgnd_1
XFILLER_0_88_377 VPWR VGND VPWR VGND sky130_ef_sc_hd__decap_12
XFILLER_0_88_355 VGND VGND VPWR VPWR sky130_fd_sc_hd__decap_8
X_5830_ _2838_ _2841_ _2824_ VGND VGND VPWR VPWR _2844_ sky130_fd_sc_hd__a21o_1
XFILLER_0_118_129 VGND VGND VPWR VPWR sky130_fd_sc_hd__decap_8
X_5761_ _2774_ _2775_ _2489_ VGND VGND VPWR VPWR _2776_ sky130_fd_sc_hd__o21bai_4
X_4712_ _1736_ _1737_ _1738_ _1742_ _1749_ VGND VGND VPWR VPWR _1750_ sky130_fd_sc_hd__a32oi_4
X_8480_ clknet_leaf_45_clk net184 _0231_ VGND VGND VPWR VPWR net18 sky130_fd_sc_hd__dfrtp_1
XFILLER_0_17_617 VPWR VGND VPWR VGND sky130_ef_sc_hd__decap_12
X_7500_ _4157_ VGND VGND VPWR VPWR _0500_ sky130_fd_sc_hd__inv_2
XFILLER_0_112_41 VPWR VGND VPWR VGND sky130_ef_sc_hd__decap_12
XFILLER_0_71_233 VGND VGND VPWR VPWR sky130_fd_sc_hd__fill_2
X_5692_ _2611_ _2610_ VGND VGND VPWR VPWR _2709_ sky130_fd_sc_hd__nor2_1
X_7431_ _4150_ VGND VGND VPWR VPWR _0438_ sky130_fd_sc_hd__inv_2
X_4643_ _1643_ _1668_ VGND VGND VPWR VPWR _1681_ sky130_fd_sc_hd__nor2_1
XFILLER_0_71_255 VGND VGND VPWR VPWR sky130_fd_sc_hd__decap_4
XFILLER_0_4_533 VGND VGND VPWR VPWR sky130_fd_sc_hd__decap_4
XFILLER_0_4_522 VGND VGND VPWR VPWR sky130_fd_sc_hd__fill_1
X_4574_ _1584_ _1611_ _1615_ VGND VGND VPWR VPWR _1617_ sky130_fd_sc_hd__and3_1
X_7362_ _4143_ VGND VGND VPWR VPWR _0376_ sky130_fd_sc_hd__inv_2
XFILLER_0_97_65 VGND VGND VPWR VPWR sky130_fd_sc_hd__decap_3
X_7293_ _4137_ VGND VGND VPWR VPWR _0313_ sky130_fd_sc_hd__inv_2
X_6313_ _3308_ _3309_ sh6\[4\] VGND VGND VPWR VPWR _3313_ sky130_fd_sc_hd__o21ai_2
XFILLER_0_12_333 VPWR VGND VPWR VGND sky130_ef_sc_hd__decap_12
X_6244_ _3205_ _3246_ _3247_ VGND VGND VPWR VPWR _3248_ sky130_fd_sc_hd__a21oi_4
XFILLER_0_110_541 VGND VGND VPWR VPWR sky130_fd_sc_hd__fill_2
XFILLER_0_97_98 VGND VGND VPWR VPWR sky130_fd_sc_hd__decap_3
XFILLER_0_40_697 VGND VGND VPWR VPWR sky130_fd_sc_hd__decap_3
X_6175_ _3135_ _3100_ _3174_ _3177_ VGND VGND VPWR VPWR _3181_ sky130_fd_sc_hd__o22ai_1
XFILLER_0_41_3 VPWR VGND VPWR VGND sky130_ef_sc_hd__decap_12
X_5126_ _2068_ _2135_ _2136_ VGND VGND VPWR VPWR _2155_ sky130_fd_sc_hd__o21ai_1
X_5057_ sh0\[2\] sh2\[2\] sh6\[2\] VGND VGND VPWR VPWR _2086_ sky130_fd_sc_hd__o21ai_4
XFILLER_0_79_366 VGND VGND VPWR VPWR sky130_fd_sc_hd__fill_1
X_8816_ clknet_leaf_11_clk net215 _0567_ VGND VGND VPWR VPWR sh8\[4\] sky130_fd_sc_hd__dfrtp_1
X_8747_ clknet_leaf_21_clk _0188_ _0498_ VGND VGND VPWR VPWR bit_sum7\[8\] sky130_fd_sc_hd__dfrtp_1
XFILLER_0_94_347 VPWR VGND VPWR VGND sky130_ef_sc_hd__decap_12
X_5959_ _2909_ _2913_ _2915_ _2918_ VGND VGND VPWR VPWR _2968_ sky130_fd_sc_hd__o211a_1
XFILLER_0_1_93 VPWR VGND VPWR VGND sky130_ef_sc_hd__decap_12
XFILLER_0_75_583 VGND VGND VPWR VPWR sky130_fd_sc_hd__fill_1
XFILLER_0_62_233 VPWR VGND VPWR VGND sky130_ef_sc_hd__decap_12
X_8678_ clknet_leaf_51_clk _0180_ _0429_ VGND VGND VPWR VPWR bit_sum0\[9\] sky130_fd_sc_hd__dfrtp_1
XFILLER_0_105_335 VGND VGND VPWR VPWR sky130_fd_sc_hd__fill_1
X_7629_ _4169_ VGND VGND VPWR VPWR _0617_ sky130_fd_sc_hd__inv_2
XFILLER_0_7_393 VGND VGND VPWR VPWR sky130_fd_sc_hd__decap_4
XFILLER_0_16_694 VGND VGND VPWR VPWR sky130_fd_sc_hd__decap_6
XFILLER_0_30_141 VGND VGND VPWR VPWR sky130_fd_sc_hd__decap_6
XFILLER_0_31_697 VPWR VGND VPWR VGND sky130_ef_sc_hd__decap_12
XFILLER_0_30_185 VGND VGND VPWR VPWR sky130_fd_sc_hd__decap_8
Xhold40 sum5\[5\] VGND VGND VPWR VPWR net82 sky130_fd_sc_hd__dlygate4sd3_1
Xhold62 bit_sum6\[9\] VGND VGND VPWR VPWR net104 sky130_fd_sc_hd__dlygate4sd3_1
XFILLER_0_26_17 VGND VGND VPWR VPWR sky130_fd_sc_hd__decap_8
Xhold51 sh13\[2\] VGND VGND VPWR VPWR net93 sky130_fd_sc_hd__dlygate4sd3_1
Xhold73 sum1\[0\] VGND VGND VPWR VPWR net115 sky130_fd_sc_hd__dlygate4sd3_1
Xhold95 bit_sum7\[3\] VGND VGND VPWR VPWR net137 sky130_fd_sc_hd__dlygate4sd3_1
Xhold84 sum5\[0\] VGND VGND VPWR VPWR net126 sky130_fd_sc_hd__dlygate4sd3_1
XFILLER_0_98_653 VGND VGND VPWR VPWR sky130_fd_sc_hd__fill_1
XFILLER_0_97_152 VGND VGND VPWR VPWR sky130_fd_sc_hd__decap_8
XFILLER_0_39_720 VGND VGND VPWR VPWR sky130_fd_sc_hd__decap_8
XFILLER_0_85_358 VPWR VGND VPWR VGND sky130_ef_sc_hd__decap_12
XFILLER_0_42_27 VGND VGND VPWR VPWR sky130_fd_sc_hd__fill_1
XFILLER_0_66_550 VGND VGND VPWR VPWR sky130_fd_sc_hd__decap_4
XFILLER_0_5_308 VGND VGND VPWR VPWR sky130_fd_sc_hd__decap_3
XFILLER_0_109_685 VPWR VGND VPWR VGND sky130_ef_sc_hd__decap_12
XFILLER_0_81_553 VGND VGND VPWR VPWR sky130_fd_sc_hd__fill_1
XFILLER_0_108_195 VGND VGND VPWR VPWR sky130_fd_sc_hd__fill_1
XFILLER_0_123_165 VGND VGND VPWR VPWR sky130_fd_sc_hd__decap_3
XFILLER_0_1_503 VGND VGND VPWR VPWR sky130_fd_sc_hd__fill_1
XFILLER_0_22_653 VGND VGND VPWR VPWR sky130_fd_sc_hd__fill_2
XFILLER_0_6_27 VGND VGND VPWR VPWR sky130_fd_sc_hd__fill_1
XFILLER_0_22_675 VPWR VGND VPWR VGND sky130_ef_sc_hd__decap_12
X_4290_ _1336_ _1319_ _1320_ VGND VGND VPWR VPWR _1338_ sky130_fd_sc_hd__and3_1
XFILLER_0_67_57 VGND VGND VPWR VPWR sky130_fd_sc_hd__decap_8
XTAP_314 VGND VPWR sky130_fd_sc_hd__tapvpwrvgnd_1
XTAP_303 VGND VPWR sky130_fd_sc_hd__tapvpwrvgnd_1
XTAP_347 VGND VPWR sky130_fd_sc_hd__tapvpwrvgnd_1
XTAP_358 VGND VPWR sky130_fd_sc_hd__tapvpwrvgnd_1
XTAP_336 VGND VPWR sky130_fd_sc_hd__tapvpwrvgnd_1
XTAP_325 VGND VPWR sky130_fd_sc_hd__tapvpwrvgnd_1
XTAP_369 VGND VPWR sky130_fd_sc_hd__tapvpwrvgnd_1
XFILLER_0_89_620 VPWR VGND VPWR VGND sky130_ef_sc_hd__decap_12
X_7980_ _0750_ net35 VGND VGND VPWR VPWR _0829_ sky130_fd_sc_hd__nand2_1
X_6931_ _3708_ _3709_ _3740_ VGND VGND VPWR VPWR _3918_ sky130_fd_sc_hd__o21ai_1
XFILLER_0_107_85 VPWR VGND VPWR VGND sky130_ef_sc_hd__decap_12
X_6862_ _3832_ _3833_ _3768_ VGND VGND VPWR VPWR _3850_ sky130_fd_sc_hd__o21bai_1
XFILLER_0_76_369 VGND VGND VPWR VPWR sky130_fd_sc_hd__fill_1
X_5813_ _2826_ _2772_ VGND VGND VPWR VPWR _2827_ sky130_fd_sc_hd__nand2_1
XFILLER_0_9_614 VGND VGND VPWR VPWR sky130_fd_sc_hd__fill_2
XFILLER_0_9_603 VGND VGND VPWR VPWR sky130_fd_sc_hd__fill_1
X_8601_ clknet_leaf_52_clk net89 _0352_ VGND VGND VPWR VPWR s1\[2\] sky130_fd_sc_hd__dfrtp_2
XFILLER_0_119_438 VGND VGND VPWR VPWR sky130_fd_sc_hd__fill_1
X_8532_ clknet_leaf_34_clk _0076_ _0283_ VGND VGND VPWR VPWR sum3\[6\] sky130_fd_sc_hd__dfrtp_1
X_6793_ _3757_ _3758_ _3724_ VGND VGND VPWR VPWR _3782_ sky130_fd_sc_hd__a21oi_2
XFILLER_0_29_252 VGND VGND VPWR VPWR sky130_fd_sc_hd__fill_2
XFILLER_0_45_723 VGND VGND VPWR VPWR sky130_fd_sc_hd__decap_4
XFILLER_0_29_285 VGND VGND VPWR VPWR sky130_fd_sc_hd__fill_1
X_5744_ _2706_ _2759_ _2758_ _2724_ _2714_ VGND VGND VPWR VPWR _2760_ sky130_fd_sc_hd__a221oi_1
XFILLER_0_114_110 VGND VGND VPWR VPWR sky130_fd_sc_hd__decap_8
X_8463_ clknet_leaf_27_clk net353 _0214_ VGND VGND VPWR VPWR carry5\[10\] sky130_fd_sc_hd__dfrtp_1
X_5675_ _2690_ _2691_ VGND VGND VPWR VPWR _2692_ sky130_fd_sc_hd__nand2_1
X_4626_ sh10\[7\] _1662_ VGND VGND VPWR VPWR _1665_ sky130_fd_sc_hd__nor2_1
X_8394_ sh10\[5\] sh11\[5\] VGND VGND VPWR VPWR _1224_ sky130_fd_sc_hd__nor2_1
XFILLER_0_89_3 VPWR VGND VPWR VGND sky130_ef_sc_hd__decap_12
XFILLER_0_72_586 VGND VGND VPWR VPWR sky130_fd_sc_hd__fill_2
X_7414_ _4149_ VGND VGND VPWR VPWR _0422_ sky130_fd_sc_hd__inv_2
XFILLER_0_102_327 VPWR VGND VPWR VGND sky130_ef_sc_hd__decap_12
XFILLER_0_4_385 VPWR VGND VPWR VGND sky130_ef_sc_hd__decap_12
XFILLER_0_4_363 VGND VGND VPWR VPWR sky130_fd_sc_hd__fill_1
X_7345_ _4142_ VGND VGND VPWR VPWR _0360_ sky130_fd_sc_hd__inv_2
X_4557_ _1243_ _1223_ _1596_ VGND VGND VPWR VPWR _1600_ sky130_fd_sc_hd__a21oi_2
XFILLER_0_12_141 VPWR VGND VPWR VGND sky130_ef_sc_hd__decap_12
X_4488_ _1262_ _1474_ _1478_ VGND VGND VPWR VPWR _1533_ sky130_fd_sc_hd__o21ai_2
X_7276_ _4125_ VGND VGND VPWR VPWR _4135_ sky130_fd_sc_hd__buf_4
XFILLER_0_13_697 VPWR VGND VPWR VGND sky130_ef_sc_hd__decap_12
X_6227_ _3224_ _3227_ _3229_ VGND VGND VPWR VPWR _3232_ sky130_fd_sc_hd__a21o_1
X_6158_ _3142_ _3145_ _3148_ VGND VGND VPWR VPWR _3164_ sky130_fd_sc_hd__and3_1
XTAP_870 VGND VPWR sky130_fd_sc_hd__tapvpwrvgnd_1
X_5109_ sh0\[2\] sh3\[2\] sh4\[2\] VGND VGND VPWR VPWR _2138_ sky130_fd_sc_hd__o21ai_4
XTAP_881 VGND VPWR sky130_fd_sc_hd__tapvpwrvgnd_1
XTAP_892 VGND VPWR sky130_fd_sc_hd__tapvpwrvgnd_1
X_6089_ _3095_ _3009_ VGND VGND VPWR VPWR _3096_ sky130_fd_sc_hd__nand2_1
XFILLER_0_67_325 VGND VGND VPWR VPWR sky130_fd_sc_hd__decap_8
XFILLER_0_36_701 VPWR VGND VPWR VGND sky130_ef_sc_hd__decap_12
XFILLER_0_82_328 VGND VGND VPWR VPWR sky130_fd_sc_hd__fill_1
XFILLER_0_75_391 VGND VGND VPWR VPWR sky130_fd_sc_hd__fill_1
XFILLER_0_63_597 VGND VGND VPWR VPWR sky130_fd_sc_hd__fill_2
XFILLER_0_51_726 VGND VGND VPWR VPWR sky130_fd_sc_hd__fill_2
XFILLER_0_23_417 VGND VGND VPWR VPWR sky130_fd_sc_hd__decap_8
XFILLER_0_105_187 VGND VGND VPWR VPWR sky130_fd_sc_hd__fill_1
XFILLER_0_101_393 VPWR VGND VPWR VGND sky130_ef_sc_hd__decap_12
XFILLER_0_37_27 VPWR VGND VPWR VGND sky130_ef_sc_hd__decap_12
XFILLER_0_58_303 VGND VGND VPWR VPWR sky130_fd_sc_hd__decap_4
XFILLER_0_86_645 VGND VGND VPWR VPWR sky130_fd_sc_hd__decap_8
XFILLER_0_85_111 VGND VGND VPWR VPWR sky130_fd_sc_hd__fill_1
XFILLER_0_85_177 VGND VGND VPWR VPWR sky130_fd_sc_hd__decap_3
XFILLER_0_85_166 VGND VGND VPWR VPWR sky130_fd_sc_hd__fill_2
XFILLER_0_39_561 VPWR VGND VPWR VGND sky130_ef_sc_hd__decap_12
XPHY_191 VGND VGND VPWR VPWR sky130_fd_sc_hd__decap_3
XPHY_180 VGND VGND VPWR VPWR sky130_fd_sc_hd__decap_3
XFILLER_0_5_105 VGND VGND VPWR VPWR sky130_fd_sc_hd__decap_6
XFILLER_0_54_586 VGND VGND VPWR VPWR sky130_fd_sc_hd__fill_2
XFILLER_0_5_149 VPWR VGND VPWR VGND sky130_ef_sc_hd__decap_12
X_5460_ sh1\[0\] _2479_ VGND VGND VPWR VPWR _2480_ sky130_fd_sc_hd__and2_1
XFILLER_0_14_439 VGND VGND VPWR VPWR sky130_fd_sc_hd__decap_8
X_4411_ _1430_ _1431_ _1422_ _1425_ VGND VGND VPWR VPWR _1457_ sky130_fd_sc_hd__o211ai_1
XFILLER_0_41_225 VGND VGND VPWR VPWR sky130_fd_sc_hd__decap_6
XFILLER_0_112_658 VPWR VGND VPWR VGND sky130_ef_sc_hd__decap_12
XFILLER_0_111_135 VGND VGND VPWR VPWR sky130_fd_sc_hd__fill_1
XFILLER_0_111_113 VGND VGND VPWR VPWR sky130_fd_sc_hd__decap_3
XFILLER_0_10_601 VPWR VGND VPWR VGND sky130_ef_sc_hd__decap_12
XFILLER_0_1_322 VGND VGND VPWR VPWR sky130_fd_sc_hd__decap_6
X_5391_ _2412_ _2368_ _2415_ VGND VGND VPWR VPWR _2416_ sky130_fd_sc_hd__nand3_1
X_4342_ _1388_ _1383_ VGND VGND VPWR VPWR _1389_ sky130_fd_sc_hd__nand2_2
XFILLER_0_10_645 VPWR VGND VPWR VGND sky130_ef_sc_hd__decap_12
X_7130_ s1\[1\] net331 VGND VGND VPWR VPWR _4110_ sky130_fd_sc_hd__nor2_1
XFILLER_0_120_691 VGND VGND VPWR VPWR sky130_fd_sc_hd__decap_8
X_4273_ _1240_ _1234_ _1235_ _1254_ _1243_ VGND VGND VPWR VPWR _1321_ sky130_fd_sc_hd__o221ai_1
X_7061_ _4043_ _4044_ VGND VGND VPWR VPWR _4046_ sky130_fd_sc_hd__nor2_1
X_6012_ _2950_ _2998_ _3000_ _3001_ _3003_ VGND VGND VPWR VPWR _3020_ sky130_fd_sc_hd__o221a_2
.ends
